* NGSPICE file created from gate_top.ext - technology: scmos

.subckt gate_top cin_hi cout_lo mode vdd gnd
M1000 gtile_0/gn gtile_0/modeb vdd vdd pfet w=1.8u l=0.18u
+  ad=0.81p pd=4.5u as=0.567p ps=2.43u
M1001 gnd gtile_0/gn cin_hi Gnd nfet w=1.8u l=0.18u
+  ad=0.81p pd=4.5u as=0.972p ps=4.68u
M1002 gnd gtile_0/modeb gtile_0/a_34_10# Gnd nfet w=1.8u l=0.18u
+  ad=0.81p pd=4.5u as=0.567p ps=2.43u
M1003 gnd mode gtile_0/modeb Gnd nfet w=0.9u l=0.18u
+  ad=0.405p pd=2.7u as=0.486p ps=2.88u
M1004 vdd mode gtile_0/modeb vdd pfet w=1.8u l=0.18u
+  ad=0.81p pd=4.5u as=0.972p ps=4.68u
M1005 vdd cout_lo gtile_0/gn vdd pfet w=1.8u l=0.18u
+  ad=0.567p pd=2.43u as=0.972p ps=4.68u
M1006 vdd gtile_0/gn cin_hi vdd pfet w=3.6u l=0.18u
+  ad=1.62p pd=8.1u as=1.944p ps=8.28u
M1007 gtile_0/a_34_10# cout_lo gtile_0/gn Gnd nfet w=1.8u l=0.18u
+  ad=0.567p pd=2.43u as=0.972p ps=4.68u
C0 gnd vdd 0.26678f
C1 mode vdd 0.02136f
C2 cin_hi gnd 0.37164f
C3 mode cin_hi 0.06257f
C4 gtile_0/modeb vdd 0.19844f
C5 gtile_0/modeb cin_hi 0.00206f
C6 gtile_0/gn gnd 0.20963f
C7 gtile_0/gn mode 0.40142f
C8 gtile_0/gn gtile_0/modeb 0.09068f
C9 cout_lo vdd 0.02775f
C10 cout_lo cin_hi 0.23461f
C11 mode gnd 0.00153f
C12 gtile_0/a_34_10# cin_hi 0
C13 gtile_0/modeb gnd 0.08604f
C14 gtile_0/modeb mode 0.35567f
C15 gtile_0/gn cout_lo 0.46084f
C16 gtile_0/gn gtile_0/a_34_10# 0
C17 cin_hi vdd 0.3967f
C18 cout_lo gnd 0.00105f
C19 gtile_0/gn vdd 0.54273f
C20 gtile_0/a_34_10# gnd 0
C21 mode cout_lo 0.00894f
C22 gtile_0/modeb cout_lo 0.20524f
C23 gtile_0/gn cin_hi 0.30468f
C24 vdd 0 5.03688f
C25 gnd 0 1.15677f
C26 cin_hi 0 0.55104f
C27 cout_lo 0 0.55219f
C28 mode 0 0.63938f
C29 gtile_0/modeb 0 0.94406f ; **FLOATING
C30 gtile_0/gn 0 1.09717f ; **FLOATING
.ends
