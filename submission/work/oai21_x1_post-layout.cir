* oai21_x1_post-layout
.include ../../part1/spice/models/TSMC_180nm.txt
.options reltol=1e-4
VDD vdd gnd 1.8
* NGSPICE file created from oai21_x1.ext - technology: scmos

.subckt oai21_x1 a b c y vdd gnd
M1000 a_16_89# a vdd vdd CMOSP w=3.6u l=0.18u
+  ad=1.134p pd=4.23u as=1.944p ps=8.28u
M1001 y a a_8_10# Gnd CMOSN w=1.8u l=0.18u
+  ad=0.567p pd=2.43u as=0.972p ps=4.68u
M1002 y b a_16_89# vdd CMOSP w=3.6u l=0.18u
+  ad=0.972p pd=4.23u as=1.134p ps=4.23u
M1003 a_8_10# b y Gnd CMOSN w=1.8u l=0.18u
+  ad=0.567p pd=2.43u as=0.567p ps=2.43u
M1004 vdd c y vdd CMOSP w=1.8u l=0.18u
+  ad=0.81p pd=4.5u as=0.972p ps=4.23u
M1005 gnd c a_8_10# Gnd CMOSN w=1.8u l=0.18u
+  ad=0.81p pd=4.5u as=0.567p ps=2.43u
C0 c gnd 0.00339f
C1 a gnd 0.00105f
C2 b c 0.49473f
C3 vdd y 0.38445f
C4 a_8_10# c 0.00491f
C5 a b 0.22477f
C6 a_8_10# a 0.19843f
C7 b gnd 0.00105f
C8 y c 0.00693f
C9 a_8_10# gnd 0.24788f
C10 a y 0.15918f
C11 vdd c 0.02244f
C12 vdd a 0.02383f
C13 a_8_10# b 0.01215f
C14 a_16_89# y 0.00113f
C15 a_16_89# vdd 0.00107f
C16 y gnd 0.04131f
C17 a c 0.00958f
C18 b y 0.11964f
C19 a_8_10# y 0.5957f
C20 vdd b 0.01975f
.ends

.subckt oai21_x1x_post a b c y vdd gnd
X0 a b c y vdd gnd oai21_x1
.ends
.subckt tb_x1 a y vdd gnd
mp y a vdd vdd CMOSP W=1.8e-06 L=1.8e-07 AS=9.72e-13 PS=4.68e-06 AD=9.72e-13 PD=4.68e-06
mn y a gnd gnd CMOSN W=9.0e-07 L=1.8e-07 AS=4.86e-13 PS=2.88e-06 AD=4.86e-13 PD=2.88e-06
.ends
.subckt tb_x2 a y vdd gnd
mp y a vdd vdd CMOSP W=3.6e-06 L=1.8e-07 AS=1.944e-12 PS=8.28e-06 AD=1.944e-12 PD=8.28e-06
mn y a gnd gnd CMOSN W=1.8e-06 L=1.8e-07 AS=9.72e-13 PS=4.68e-06 AD=9.72e-13 PD=4.68e-06
.ends
Va src_a gnd PWL(
+ 0.00000e+00 0.000 1.00000e-09 0.000 1.02000e-09 1.800 2.00000e-09 1.800 2.02000e-09 0.000 4.00000e-09 0.000
+ 4.02000e-09 1.800 5.00000e-09 1.800 5.02000e-09 0.000 8.00000e-09 0.000 8.02000e-09 1.800 9.00000e-09 1.800
+ 9.02000e-09 0.000 1.10000e-08 0.000 1.10200e-08 1.800 2.00000e-08 1.800 2.00200e-08 0.000 2.50000e-08 0.000
+ )
Xs_a src_a drv_a vdd gnd tb_x1
Xd_a drv_a a vdd gnd tb_x2
Vb src_b gnd PWL(
+ 0.00000e+00 0.000 3.00000e-09 0.000 3.02000e-09 1.800 6.00000e-09 1.800 6.02000e-09 0.000 1.00000e-08 0.000
+ 1.00200e-08 1.800 1.20000e-08 1.800 1.20200e-08 0.000 1.30000e-08 0.000 1.30200e-08 1.800 1.50000e-08 1.800
+ 1.50200e-08 0.000 1.80000e-08 0.000 1.80200e-08 1.800 2.30000e-08 1.800 2.30200e-08 0.000 2.50000e-08 0.000
+ )
Xs_b src_b drv_b vdd gnd tb_x1
Xd_b drv_b b vdd gnd tb_x2
Vc src_c gnd PWL(
+ 0.00000e+00 0.000 7.00000e-09 0.000 7.02000e-09 1.800 1.40000e-08 1.800 1.40200e-08 0.000 1.60000e-08 0.000
+ 1.60200e-08 1.800 1.70000e-08 1.800 1.70200e-08 0.000 1.90000e-08 0.000 1.90200e-08 1.800 2.10000e-08 1.800
+ 2.10200e-08 0.000 2.20000e-08 0.000 2.20200e-08 1.800 2.40000e-08 1.800 2.40200e-08 0.000 2.50000e-08 0.000
+ )
Xs_c src_c drv_c vdd gnd tb_x1
Xd_c drv_c c vdd gnd tb_x2
Xl_y y lo_y vdd gnd tb_x1
X0 a b c y vdd gnd oai21_x1x_post
.tran 5p 2.50000e-08
.control
set wr_singlescale
set wr_vecnames
run
wrdata oai21_x1_post-layout.txt v(a) v(b) v(c) v(y)
quit
.endc
.end
