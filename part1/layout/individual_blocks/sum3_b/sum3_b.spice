* NGSPICE file created from sum3_b.ext - technology: scmos

.global Vdd Gnd

.subckt sum3_b c3 p3 p3b s3 vdd gnd
M1000 vdd c3 x3_s1xp1 vdd pfet w=1.8u l=0.18u
+  ad=0.81p pd=4.5u as=0.567p ps=2.43u
M1001 vdd c3 x3_cb vdd pfet w=1.8u l=0.18u
+  ad=0.567p pd=2.43u as=0.972p ps=4.68u
M1002 gnd x3_cb a_34_10# Gnd nfet w=0.9u l=0.18u
+  ad=0.2835p pd=1.53u as=0.2835p ps=1.53u
M1003 x3_s1xp1 p3 vdd vdd pfet w=1.8u l=0.18u
+  ad=0.567p pd=2.43u as=0.567p ps=2.43u
M1004 x3_cb c3 gnd Gnd nfet w=0.9u l=0.18u
+  ad=0.405p pd=2.7u as=0.2835p ps=1.53u
M1005 s3 p3b x3_s1xp1 vdd pfet w=1.8u l=0.18u
+  ad=0.567p pd=2.43u as=0.567p ps=2.43u
M1006 a_16_10# c3 gnd Gnd nfet w=0.9u l=0.18u
+  ad=0.2835p pd=1.53u as=0.486p ps=2.88u
M1007 x3_s1xp1 x3_cb s3 vdd pfet w=1.8u l=0.18u
+  ad=0.567p pd=2.43u as=0.567p ps=2.43u
M1008 s3 p3 a_16_10# Gnd nfet w=0.9u l=0.18u
+  ad=0.2835p pd=1.53u as=0.2835p ps=1.53u
M1009 a_34_10# p3b s3 Gnd nfet w=0.9u l=0.18u
+  ad=0.2835p pd=1.53u as=0.2835p ps=1.53u
C0 p3 gnd 0.00105f
C1 p3b s3 0.09187f
C2 a_34_10# gnd 0
C3 vdd s3 0.05237f
C4 c3 p3b 0.01832f
C5 vdd c3 0.04444f
C6 x3_s1xp1 s3 0.73152f
C7 x3_cb gnd 0.12649f
C8 x3_s1xp1 c3 0.00492f
C9 x3_cb p3 0.01812f
C10 p3b gnd 0.00105f
C11 c3 s3 0.0228f
C12 p3 p3b 0.2539f
C13 a_16_10# s3 0
C14 vdd p3 0.02202f
C15 x3_s1xp1 p3 0.00494f
C16 x3_cb p3b 0.26268f
C17 x3_cb vdd 0.23817f
C18 x3_cb x3_s1xp1 0.01217f
C19 s3 gnd 0.04131f
C20 c3 gnd 0.00516f
C21 p3 s3 0.15839f
C22 a_34_10# s3 0
C23 a_16_10# gnd 0
C24 c3 p3 0.59372f
C25 vdd p3b 0.02078f
C26 x3_s1xp1 p3b 0.27667f
C27 x3_cb s3 0.08337f
C28 x3_s1xp1 vdd 0.43592f
C29 x3_cb c3 0.71543f
.ends
