* NGSPICE file created from nor3_x1.ext - technology: scmos

.global Vdd Gnd

.subckt nor3_x1 i0 i1 i2 y vdd gnd
M1000 y i2 a_25_70# vdd pfet w=5.4u l=0.18u
+  ad=2.43p pd=11.7u as=1.701p ps=6.03u
M1001 gnd i0 y Gnd nfet w=0.9u l=0.18u
+  ad=0.2835p pd=1.53u as=0.486p ps=2.88u
M1002 a_16_70# i0 vdd vdd pfet w=5.4u l=0.18u
+  ad=1.701p pd=6.03u as=2.916p ps=11.88u
M1003 y i1 gnd Gnd nfet w=0.9u l=0.18u
+  ad=0.2835p pd=1.53u as=0.2835p ps=1.53u
M1004 a_25_70# i1 a_16_70# vdd pfet w=5.4u l=0.18u
+  ad=1.701p pd=6.03u as=1.701p ps=6.03u
M1005 gnd i2 y Gnd nfet w=0.9u l=0.18u
+  ad=0.405p pd=2.7u as=0.2835p ps=1.53u
C0 i2 gnd 0.00258f
C1 i0 y 0.3133f
C2 i1 i2 0.47499f
C3 vdd i1 0.01968f
C4 a_25_70# vdd 0
C5 y gnd 0.33053f
C6 i0 gnd 0.00258f
C7 i1 y 0.02134f
C8 a_25_70# y 0.0017f
C9 i0 i1 0.47479f
C10 vdd i2 0.02098f
C11 i1 gnd 0.00258f
C12 i2 y 0.09598f
C13 vdd y 0.05599f
C14 i0 i2 0.00894f
C15 vdd i0 0.02545f
C16 a_16_70# vdd 0.00152f
.ends
