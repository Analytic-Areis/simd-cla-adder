* DC supply current of pg_block_x1
.include ../../../../spice/models/TSMC_180nm.txt
VDD vdd gnd 1.8
* nand2_x1: 2-input NAND
* GENERATED from part1/cells/library.py. Do not edit by hand.
.subckt nand2_x1 i0 i1 y vdd gnd
Mp1 y i0 vdd vdd CMOSP W=1.8000e-06 L=1.8000e-07 AS=9.7200e-13 PS=4.6800e-06 AD=9.7200e-13 PD=4.6800e-06
Mp2 y i1 vdd vdd CMOSP W=1.8000e-06 L=1.8000e-07 AS=9.7200e-13 PS=4.6800e-06 AD=9.7200e-13 PD=4.6800e-06
Mn1 y i0 xn1 gnd CMOSN W=1.8000e-06 L=1.8000e-07 AS=4.8600e-13 PS=4.1400e-06 AD=9.7200e-13 PD=4.6800e-06
Mn2 xn1 i1 gnd gnd CMOSN W=1.8000e-06 L=1.8000e-07 AS=9.7200e-13 PS=4.6800e-06 AD=4.8600e-13 PD=4.1400e-06
.ends nand2_x1
* nor2_x1: 2-input NOR
* GENERATED from part1/cells/library.py. Do not edit by hand.
.subckt nor2_x1 i0 i1 y vdd gnd
Mp1 xp1 i0 vdd vdd CMOSP W=3.6000e-06 L=1.8000e-07 AS=1.9440e-12 PS=8.2800e-06 AD=9.7200e-13 PD=7.7400e-06
Mp2 y i1 xp1 vdd CMOSP W=3.6000e-06 L=1.8000e-07 AS=9.7200e-13 PS=7.7400e-06 AD=1.9440e-12 PD=8.2800e-06
Mn1 y i0 gnd gnd CMOSN W=9.0000e-07 L=1.8000e-07 AS=4.8600e-13 PS=2.8800e-06 AD=4.8600e-13 PD=2.8800e-06
Mn2 y i1 gnd gnd CMOSN W=9.0000e-07 L=1.8000e-07 AS=4.8600e-13 PS=2.8800e-06 AD=4.8600e-13 PD=2.8800e-06
.ends nor2_x1
* aoi21_x1: NOT(a b + c)
* GENERATED from part1/cells/library.py. Do not edit by hand.
.subckt aoi21_x1 a b c y vdd gnd
Mp1 xp1 a vdd vdd CMOSP W=3.6000e-06 L=1.8000e-07 AS=1.9440e-12 PS=8.2800e-06 AD=1.9440e-12 PD=8.2800e-06
Mp2 xp1 b vdd vdd CMOSP W=3.6000e-06 L=1.8000e-07 AS=1.9440e-12 PS=8.2800e-06 AD=1.9440e-12 PD=8.2800e-06
Mp3 y c xp1 vdd CMOSP W=3.6000e-06 L=1.8000e-07 AS=1.9440e-12 PS=8.2800e-06 AD=1.9440e-12 PD=8.2800e-06
Mn1 y a xn1 gnd CMOSN W=1.8000e-06 L=1.8000e-07 AS=4.8600e-13 PS=4.1400e-06 AD=9.7200e-13 PD=4.6800e-06
Mn2 xn1 b gnd gnd CMOSN W=1.8000e-06 L=1.8000e-07 AS=9.7200e-13 PS=4.6800e-06 AD=4.8600e-13 PD=4.1400e-06
Mn3 y c gnd gnd CMOSN W=9.0000e-07 L=1.8000e-07 AS=4.8600e-13 PS=2.8800e-06 AD=4.8600e-13 PD=2.8800e-06
.ends aoi21_x1
* oai21_x1: NOT((a + b) c)
* GENERATED from part1/cells/library.py. Do not edit by hand.
.subckt oai21_x1 a b c y vdd gnd
Mp1 xp1 a vdd vdd CMOSP W=3.6000e-06 L=1.8000e-07 AS=1.9440e-12 PS=8.2800e-06 AD=9.7200e-13 PD=7.7400e-06
Mp2 y b xp1 vdd CMOSP W=3.6000e-06 L=1.8000e-07 AS=9.7200e-13 PS=7.7400e-06 AD=1.9440e-12 PD=8.2800e-06
Mp3 y c vdd vdd CMOSP W=1.8000e-06 L=1.8000e-07 AS=9.7200e-13 PS=4.6800e-06 AD=9.7200e-13 PD=4.6800e-06
Mn1 y a xn1 gnd CMOSN W=1.8000e-06 L=1.8000e-07 AS=9.7200e-13 PS=4.6800e-06 AD=9.7200e-13 PD=4.6800e-06
Mn2 y b xn1 gnd CMOSN W=1.8000e-06 L=1.8000e-07 AS=9.7200e-13 PS=4.6800e-06 AD=9.7200e-13 PD=4.6800e-06
Mn3 xn1 c gnd gnd CMOSN W=1.8000e-06 L=1.8000e-07 AS=9.7200e-13 PS=4.6800e-06 AD=9.7200e-13 PD=4.6800e-06
.ends oai21_x1
* pg_bit_x1: P/G bit: NAND2, NOR2, compound AOI21 and OAI21
* GENERATED from part1/cells/library.py. Do not edit by hand.
.subckt pg_bit_x1 a b gb tb p pb vdd gnd
Xnand a b gb vdd gnd nand2_x1
Xnor a b tb vdd gnd nor2_x1
Xaoi a b tb p vdd gnd aoi21_x1
Xoai a b gb pb vdd gnd oai21_x1
.ends pg_bit_x1
* pg_block_x1: 4-bit propagate and generate block
* GENERATED from part1/cells/library.py. Do not edit by hand.
.subckt pg_block_x1 a0 a1 a2 a3 b0 b1 b2 b3 g0b t0b p0 p0b g1b t1b p1 p1b g2b t2b p2 p2b g3b t3b p3 p3b vdd gnd
Xbit0 a0 b0 g0b t0b p0 p0b vdd gnd pg_bit_x1
Xbit1 a1 b1 g1b t1b p1 p1b vdd gnd pg_bit_x1
Xbit2 a2 b2 g2b t2b p2 p2b vdd gnd pg_bit_x1
Xbit3 a3 b3 g3b t3b p3 p3b vdd gnd pg_bit_x1
.ends pg_block_x1
.subckt tb_inv a y vdd gnd
mp y a vdd vdd CMOSP W=1.8e-06 L=1.8e-07 AS=9.72e-13 PS=4.68e-06 AD=9.72e-13 PD=4.68e-06
mn y a gnd gnd CMOSN W=9.0e-07 L=1.8e-07 AS=4.86e-13 PS=2.88e-06 AD=4.86e-13 PD=2.88e-06
.ends
Va0 src_a0 gnd 1.8
Xd_a0 src_a0 a0 vdd gnd tb_inv
Va1 src_a1 gnd 1.8
Xd_a1 src_a1 a1 vdd gnd tb_inv
Va2 src_a2 gnd 1.8
Xd_a2 src_a2 a2 vdd gnd tb_inv
Va3 src_a3 gnd 1.8
Xd_a3 src_a3 a3 vdd gnd tb_inv
Vb0 src_b0 gnd 1.8
Xd_b0 src_b0 b0 vdd gnd tb_inv
Vb1 src_b1 gnd 1.8
Xd_b1 src_b1 b1 vdd gnd tb_inv
Vb2 src_b2 gnd 1.8
Xd_b2 src_b2 b2 vdd gnd tb_inv
Vb3 src_b3 gnd 1.8
Xd_b3 src_b3 b3 vdd gnd tb_inv
Xl_g0b g0b lo_g0b vdd gnd tb_inv
Xl_t0b t0b lo_t0b vdd gnd tb_inv
Xl_p0 p0 lo_p0 vdd gnd tb_inv
Xl_p0b p0b lo_p0b vdd gnd tb_inv
Xl_g1b g1b lo_g1b vdd gnd tb_inv
Xl_t1b t1b lo_t1b vdd gnd tb_inv
Xl_p1 p1 lo_p1 vdd gnd tb_inv
Xl_p1b p1b lo_p1b vdd gnd tb_inv
Xl_g2b g2b lo_g2b vdd gnd tb_inv
Xl_t2b t2b lo_t2b vdd gnd tb_inv
Xl_p2 p2 lo_p2 vdd gnd tb_inv
Xl_p2b p2b lo_p2b vdd gnd tb_inv
Xl_g3b g3b lo_g3b vdd gnd tb_inv
Xl_t3b t3b lo_t3b vdd gnd tb_inv
Xl_p3 p3 lo_p3 vdd gnd tb_inv
Xl_p3b p3b lo_p3b vdd gnd tb_inv
X0 a0 a1 a2 a3 b0 b1 b2 b3 g0b t0b p0 p0b g1b t1b p1 p1b g2b t2b p2 p2b g3b t3b p3 p3b vdd gnd pg_block_x1
.control
alter Va0 = 1.8
alter Va1 = 1.8
alter Va2 = 1.8
alter Va3 = 1.8
alter Vb0 = 1.8
alter Vb1 = 1.8
alter Vb2 = 1.8
alter Vb3 = 1.8
op
print i(VDD) >> dc_current.txt
alter Va0 = 1.8
alter Va1 = 1.8
alter Va2 = 1.8
alter Va3 = 1.8
alter Vb0 = 1.8
alter Vb1 = 1.8
alter Vb2 = 1.8
alter Vb3 = 0.0
op
print i(VDD) >> dc_current.txt
alter Va0 = 1.8
alter Va1 = 1.8
alter Va2 = 1.8
alter Va3 = 1.8
alter Vb0 = 1.8
alter Vb1 = 1.8
alter Vb2 = 0.0
alter Vb3 = 1.8
op
print i(VDD) >> dc_current.txt
alter Va0 = 1.8
alter Va1 = 1.8
alter Va2 = 1.8
alter Va3 = 1.8
alter Vb0 = 1.8
alter Vb1 = 1.8
alter Vb2 = 0.0
alter Vb3 = 0.0
op
print i(VDD) >> dc_current.txt
alter Va0 = 1.8
alter Va1 = 1.8
alter Va2 = 1.8
alter Va3 = 1.8
alter Vb0 = 1.8
alter Vb1 = 0.0
alter Vb2 = 1.8
alter Vb3 = 1.8
op
print i(VDD) >> dc_current.txt
alter Va0 = 1.8
alter Va1 = 1.8
alter Va2 = 1.8
alter Va3 = 1.8
alter Vb0 = 1.8
alter Vb1 = 0.0
alter Vb2 = 1.8
alter Vb3 = 0.0
op
print i(VDD) >> dc_current.txt
alter Va0 = 1.8
alter Va1 = 1.8
alter Va2 = 1.8
alter Va3 = 1.8
alter Vb0 = 1.8
alter Vb1 = 0.0
alter Vb2 = 0.0
alter Vb3 = 1.8
op
print i(VDD) >> dc_current.txt
alter Va0 = 1.8
alter Va1 = 1.8
alter Va2 = 1.8
alter Va3 = 1.8
alter Vb0 = 1.8
alter Vb1 = 0.0
alter Vb2 = 0.0
alter Vb3 = 0.0
op
print i(VDD) >> dc_current.txt
alter Va0 = 1.8
alter Va1 = 1.8
alter Va2 = 1.8
alter Va3 = 1.8
alter Vb0 = 0.0
alter Vb1 = 1.8
alter Vb2 = 1.8
alter Vb3 = 1.8
op
print i(VDD) >> dc_current.txt
alter Va0 = 1.8
alter Va1 = 1.8
alter Va2 = 1.8
alter Va3 = 1.8
alter Vb0 = 0.0
alter Vb1 = 1.8
alter Vb2 = 1.8
alter Vb3 = 0.0
op
print i(VDD) >> dc_current.txt
alter Va0 = 1.8
alter Va1 = 1.8
alter Va2 = 1.8
alter Va3 = 1.8
alter Vb0 = 0.0
alter Vb1 = 1.8
alter Vb2 = 0.0
alter Vb3 = 1.8
op
print i(VDD) >> dc_current.txt
alter Va0 = 1.8
alter Va1 = 1.8
alter Va2 = 1.8
alter Va3 = 1.8
alter Vb0 = 0.0
alter Vb1 = 1.8
alter Vb2 = 0.0
alter Vb3 = 0.0
op
print i(VDD) >> dc_current.txt
alter Va0 = 1.8
alter Va1 = 1.8
alter Va2 = 1.8
alter Va3 = 1.8
alter Vb0 = 0.0
alter Vb1 = 0.0
alter Vb2 = 1.8
alter Vb3 = 1.8
op
print i(VDD) >> dc_current.txt
alter Va0 = 1.8
alter Va1 = 1.8
alter Va2 = 1.8
alter Va3 = 1.8
alter Vb0 = 0.0
alter Vb1 = 0.0
alter Vb2 = 1.8
alter Vb3 = 0.0
op
print i(VDD) >> dc_current.txt
alter Va0 = 1.8
alter Va1 = 1.8
alter Va2 = 1.8
alter Va3 = 1.8
alter Vb0 = 0.0
alter Vb1 = 0.0
alter Vb2 = 0.0
alter Vb3 = 1.8
op
print i(VDD) >> dc_current.txt
alter Va0 = 1.8
alter Va1 = 1.8
alter Va2 = 1.8
alter Va3 = 1.8
alter Vb0 = 0.0
alter Vb1 = 0.0
alter Vb2 = 0.0
alter Vb3 = 0.0
op
print i(VDD) >> dc_current.txt
alter Va0 = 1.8
alter Va1 = 1.8
alter Va2 = 1.8
alter Va3 = 0.0
alter Vb0 = 1.8
alter Vb1 = 1.8
alter Vb2 = 1.8
alter Vb3 = 1.8
op
print i(VDD) >> dc_current.txt
alter Va0 = 1.8
alter Va1 = 1.8
alter Va2 = 1.8
alter Va3 = 0.0
alter Vb0 = 1.8
alter Vb1 = 1.8
alter Vb2 = 1.8
alter Vb3 = 0.0
op
print i(VDD) >> dc_current.txt
alter Va0 = 1.8
alter Va1 = 1.8
alter Va2 = 1.8
alter Va3 = 0.0
alter Vb0 = 1.8
alter Vb1 = 1.8
alter Vb2 = 0.0
alter Vb3 = 1.8
op
print i(VDD) >> dc_current.txt
alter Va0 = 1.8
alter Va1 = 1.8
alter Va2 = 1.8
alter Va3 = 0.0
alter Vb0 = 1.8
alter Vb1 = 1.8
alter Vb2 = 0.0
alter Vb3 = 0.0
op
print i(VDD) >> dc_current.txt
alter Va0 = 1.8
alter Va1 = 1.8
alter Va2 = 1.8
alter Va3 = 0.0
alter Vb0 = 1.8
alter Vb1 = 0.0
alter Vb2 = 1.8
alter Vb3 = 1.8
op
print i(VDD) >> dc_current.txt
alter Va0 = 1.8
alter Va1 = 1.8
alter Va2 = 1.8
alter Va3 = 0.0
alter Vb0 = 1.8
alter Vb1 = 0.0
alter Vb2 = 1.8
alter Vb3 = 0.0
op
print i(VDD) >> dc_current.txt
alter Va0 = 1.8
alter Va1 = 1.8
alter Va2 = 1.8
alter Va3 = 0.0
alter Vb0 = 1.8
alter Vb1 = 0.0
alter Vb2 = 0.0
alter Vb3 = 1.8
op
print i(VDD) >> dc_current.txt
alter Va0 = 1.8
alter Va1 = 1.8
alter Va2 = 1.8
alter Va3 = 0.0
alter Vb0 = 1.8
alter Vb1 = 0.0
alter Vb2 = 0.0
alter Vb3 = 0.0
op
print i(VDD) >> dc_current.txt
alter Va0 = 1.8
alter Va1 = 1.8
alter Va2 = 1.8
alter Va3 = 0.0
alter Vb0 = 0.0
alter Vb1 = 1.8
alter Vb2 = 1.8
alter Vb3 = 1.8
op
print i(VDD) >> dc_current.txt
alter Va0 = 1.8
alter Va1 = 1.8
alter Va2 = 1.8
alter Va3 = 0.0
alter Vb0 = 0.0
alter Vb1 = 1.8
alter Vb2 = 1.8
alter Vb3 = 0.0
op
print i(VDD) >> dc_current.txt
alter Va0 = 1.8
alter Va1 = 1.8
alter Va2 = 1.8
alter Va3 = 0.0
alter Vb0 = 0.0
alter Vb1 = 1.8
alter Vb2 = 0.0
alter Vb3 = 1.8
op
print i(VDD) >> dc_current.txt
alter Va0 = 1.8
alter Va1 = 1.8
alter Va2 = 1.8
alter Va3 = 0.0
alter Vb0 = 0.0
alter Vb1 = 1.8
alter Vb2 = 0.0
alter Vb3 = 0.0
op
print i(VDD) >> dc_current.txt
alter Va0 = 1.8
alter Va1 = 1.8
alter Va2 = 1.8
alter Va3 = 0.0
alter Vb0 = 0.0
alter Vb1 = 0.0
alter Vb2 = 1.8
alter Vb3 = 1.8
op
print i(VDD) >> dc_current.txt
alter Va0 = 1.8
alter Va1 = 1.8
alter Va2 = 1.8
alter Va3 = 0.0
alter Vb0 = 0.0
alter Vb1 = 0.0
alter Vb2 = 1.8
alter Vb3 = 0.0
op
print i(VDD) >> dc_current.txt
alter Va0 = 1.8
alter Va1 = 1.8
alter Va2 = 1.8
alter Va3 = 0.0
alter Vb0 = 0.0
alter Vb1 = 0.0
alter Vb2 = 0.0
alter Vb3 = 1.8
op
print i(VDD) >> dc_current.txt
alter Va0 = 1.8
alter Va1 = 1.8
alter Va2 = 1.8
alter Va3 = 0.0
alter Vb0 = 0.0
alter Vb1 = 0.0
alter Vb2 = 0.0
alter Vb3 = 0.0
op
print i(VDD) >> dc_current.txt
alter Va0 = 1.8
alter Va1 = 1.8
alter Va2 = 0.0
alter Va3 = 1.8
alter Vb0 = 1.8
alter Vb1 = 1.8
alter Vb2 = 1.8
alter Vb3 = 1.8
op
print i(VDD) >> dc_current.txt
alter Va0 = 1.8
alter Va1 = 1.8
alter Va2 = 0.0
alter Va3 = 1.8
alter Vb0 = 1.8
alter Vb1 = 1.8
alter Vb2 = 1.8
alter Vb3 = 0.0
op
print i(VDD) >> dc_current.txt
alter Va0 = 1.8
alter Va1 = 1.8
alter Va2 = 0.0
alter Va3 = 1.8
alter Vb0 = 1.8
alter Vb1 = 1.8
alter Vb2 = 0.0
alter Vb3 = 1.8
op
print i(VDD) >> dc_current.txt
alter Va0 = 1.8
alter Va1 = 1.8
alter Va2 = 0.0
alter Va3 = 1.8
alter Vb0 = 1.8
alter Vb1 = 1.8
alter Vb2 = 0.0
alter Vb3 = 0.0
op
print i(VDD) >> dc_current.txt
alter Va0 = 1.8
alter Va1 = 1.8
alter Va2 = 0.0
alter Va3 = 1.8
alter Vb0 = 1.8
alter Vb1 = 0.0
alter Vb2 = 1.8
alter Vb3 = 1.8
op
print i(VDD) >> dc_current.txt
alter Va0 = 1.8
alter Va1 = 1.8
alter Va2 = 0.0
alter Va3 = 1.8
alter Vb0 = 1.8
alter Vb1 = 0.0
alter Vb2 = 1.8
alter Vb3 = 0.0
op
print i(VDD) >> dc_current.txt
alter Va0 = 1.8
alter Va1 = 1.8
alter Va2 = 0.0
alter Va3 = 1.8
alter Vb0 = 1.8
alter Vb1 = 0.0
alter Vb2 = 0.0
alter Vb3 = 1.8
op
print i(VDD) >> dc_current.txt
alter Va0 = 1.8
alter Va1 = 1.8
alter Va2 = 0.0
alter Va3 = 1.8
alter Vb0 = 1.8
alter Vb1 = 0.0
alter Vb2 = 0.0
alter Vb3 = 0.0
op
print i(VDD) >> dc_current.txt
alter Va0 = 1.8
alter Va1 = 1.8
alter Va2 = 0.0
alter Va3 = 1.8
alter Vb0 = 0.0
alter Vb1 = 1.8
alter Vb2 = 1.8
alter Vb3 = 1.8
op
print i(VDD) >> dc_current.txt
alter Va0 = 1.8
alter Va1 = 1.8
alter Va2 = 0.0
alter Va3 = 1.8
alter Vb0 = 0.0
alter Vb1 = 1.8
alter Vb2 = 1.8
alter Vb3 = 0.0
op
print i(VDD) >> dc_current.txt
alter Va0 = 1.8
alter Va1 = 1.8
alter Va2 = 0.0
alter Va3 = 1.8
alter Vb0 = 0.0
alter Vb1 = 1.8
alter Vb2 = 0.0
alter Vb3 = 1.8
op
print i(VDD) >> dc_current.txt
alter Va0 = 1.8
alter Va1 = 1.8
alter Va2 = 0.0
alter Va3 = 1.8
alter Vb0 = 0.0
alter Vb1 = 1.8
alter Vb2 = 0.0
alter Vb3 = 0.0
op
print i(VDD) >> dc_current.txt
alter Va0 = 1.8
alter Va1 = 1.8
alter Va2 = 0.0
alter Va3 = 1.8
alter Vb0 = 0.0
alter Vb1 = 0.0
alter Vb2 = 1.8
alter Vb3 = 1.8
op
print i(VDD) >> dc_current.txt
alter Va0 = 1.8
alter Va1 = 1.8
alter Va2 = 0.0
alter Va3 = 1.8
alter Vb0 = 0.0
alter Vb1 = 0.0
alter Vb2 = 1.8
alter Vb3 = 0.0
op
print i(VDD) >> dc_current.txt
alter Va0 = 1.8
alter Va1 = 1.8
alter Va2 = 0.0
alter Va3 = 1.8
alter Vb0 = 0.0
alter Vb1 = 0.0
alter Vb2 = 0.0
alter Vb3 = 1.8
op
print i(VDD) >> dc_current.txt
alter Va0 = 1.8
alter Va1 = 1.8
alter Va2 = 0.0
alter Va3 = 1.8
alter Vb0 = 0.0
alter Vb1 = 0.0
alter Vb2 = 0.0
alter Vb3 = 0.0
op
print i(VDD) >> dc_current.txt
alter Va0 = 1.8
alter Va1 = 1.8
alter Va2 = 0.0
alter Va3 = 0.0
alter Vb0 = 1.8
alter Vb1 = 1.8
alter Vb2 = 1.8
alter Vb3 = 1.8
op
print i(VDD) >> dc_current.txt
alter Va0 = 1.8
alter Va1 = 1.8
alter Va2 = 0.0
alter Va3 = 0.0
alter Vb0 = 1.8
alter Vb1 = 1.8
alter Vb2 = 1.8
alter Vb3 = 0.0
op
print i(VDD) >> dc_current.txt
alter Va0 = 1.8
alter Va1 = 1.8
alter Va2 = 0.0
alter Va3 = 0.0
alter Vb0 = 1.8
alter Vb1 = 1.8
alter Vb2 = 0.0
alter Vb3 = 1.8
op
print i(VDD) >> dc_current.txt
alter Va0 = 1.8
alter Va1 = 1.8
alter Va2 = 0.0
alter Va3 = 0.0
alter Vb0 = 1.8
alter Vb1 = 1.8
alter Vb2 = 0.0
alter Vb3 = 0.0
op
print i(VDD) >> dc_current.txt
alter Va0 = 1.8
alter Va1 = 1.8
alter Va2 = 0.0
alter Va3 = 0.0
alter Vb0 = 1.8
alter Vb1 = 0.0
alter Vb2 = 1.8
alter Vb3 = 1.8
op
print i(VDD) >> dc_current.txt
alter Va0 = 1.8
alter Va1 = 1.8
alter Va2 = 0.0
alter Va3 = 0.0
alter Vb0 = 1.8
alter Vb1 = 0.0
alter Vb2 = 1.8
alter Vb3 = 0.0
op
print i(VDD) >> dc_current.txt
alter Va0 = 1.8
alter Va1 = 1.8
alter Va2 = 0.0
alter Va3 = 0.0
alter Vb0 = 1.8
alter Vb1 = 0.0
alter Vb2 = 0.0
alter Vb3 = 1.8
op
print i(VDD) >> dc_current.txt
alter Va0 = 1.8
alter Va1 = 1.8
alter Va2 = 0.0
alter Va3 = 0.0
alter Vb0 = 1.8
alter Vb1 = 0.0
alter Vb2 = 0.0
alter Vb3 = 0.0
op
print i(VDD) >> dc_current.txt
alter Va0 = 1.8
alter Va1 = 1.8
alter Va2 = 0.0
alter Va3 = 0.0
alter Vb0 = 0.0
alter Vb1 = 1.8
alter Vb2 = 1.8
alter Vb3 = 1.8
op
print i(VDD) >> dc_current.txt
alter Va0 = 1.8
alter Va1 = 1.8
alter Va2 = 0.0
alter Va3 = 0.0
alter Vb0 = 0.0
alter Vb1 = 1.8
alter Vb2 = 1.8
alter Vb3 = 0.0
op
print i(VDD) >> dc_current.txt
alter Va0 = 1.8
alter Va1 = 1.8
alter Va2 = 0.0
alter Va3 = 0.0
alter Vb0 = 0.0
alter Vb1 = 1.8
alter Vb2 = 0.0
alter Vb3 = 1.8
op
print i(VDD) >> dc_current.txt
alter Va0 = 1.8
alter Va1 = 1.8
alter Va2 = 0.0
alter Va3 = 0.0
alter Vb0 = 0.0
alter Vb1 = 1.8
alter Vb2 = 0.0
alter Vb3 = 0.0
op
print i(VDD) >> dc_current.txt
alter Va0 = 1.8
alter Va1 = 1.8
alter Va2 = 0.0
alter Va3 = 0.0
alter Vb0 = 0.0
alter Vb1 = 0.0
alter Vb2 = 1.8
alter Vb3 = 1.8
op
print i(VDD) >> dc_current.txt
alter Va0 = 1.8
alter Va1 = 1.8
alter Va2 = 0.0
alter Va3 = 0.0
alter Vb0 = 0.0
alter Vb1 = 0.0
alter Vb2 = 1.8
alter Vb3 = 0.0
op
print i(VDD) >> dc_current.txt
alter Va0 = 1.8
alter Va1 = 1.8
alter Va2 = 0.0
alter Va3 = 0.0
alter Vb0 = 0.0
alter Vb1 = 0.0
alter Vb2 = 0.0
alter Vb3 = 1.8
op
print i(VDD) >> dc_current.txt
alter Va0 = 1.8
alter Va1 = 1.8
alter Va2 = 0.0
alter Va3 = 0.0
alter Vb0 = 0.0
alter Vb1 = 0.0
alter Vb2 = 0.0
alter Vb3 = 0.0
op
print i(VDD) >> dc_current.txt
alter Va0 = 1.8
alter Va1 = 0.0
alter Va2 = 1.8
alter Va3 = 1.8
alter Vb0 = 1.8
alter Vb1 = 1.8
alter Vb2 = 1.8
alter Vb3 = 1.8
op
print i(VDD) >> dc_current.txt
alter Va0 = 1.8
alter Va1 = 0.0
alter Va2 = 1.8
alter Va3 = 1.8
alter Vb0 = 1.8
alter Vb1 = 1.8
alter Vb2 = 1.8
alter Vb3 = 0.0
op
print i(VDD) >> dc_current.txt
alter Va0 = 1.8
alter Va1 = 0.0
alter Va2 = 1.8
alter Va3 = 1.8
alter Vb0 = 1.8
alter Vb1 = 1.8
alter Vb2 = 0.0
alter Vb3 = 1.8
op
print i(VDD) >> dc_current.txt
alter Va0 = 1.8
alter Va1 = 0.0
alter Va2 = 1.8
alter Va3 = 1.8
alter Vb0 = 1.8
alter Vb1 = 1.8
alter Vb2 = 0.0
alter Vb3 = 0.0
op
print i(VDD) >> dc_current.txt
alter Va0 = 1.8
alter Va1 = 0.0
alter Va2 = 1.8
alter Va3 = 1.8
alter Vb0 = 1.8
alter Vb1 = 0.0
alter Vb2 = 1.8
alter Vb3 = 1.8
op
print i(VDD) >> dc_current.txt
alter Va0 = 1.8
alter Va1 = 0.0
alter Va2 = 1.8
alter Va3 = 1.8
alter Vb0 = 1.8
alter Vb1 = 0.0
alter Vb2 = 1.8
alter Vb3 = 0.0
op
print i(VDD) >> dc_current.txt
alter Va0 = 1.8
alter Va1 = 0.0
alter Va2 = 1.8
alter Va3 = 1.8
alter Vb0 = 1.8
alter Vb1 = 0.0
alter Vb2 = 0.0
alter Vb3 = 1.8
op
print i(VDD) >> dc_current.txt
alter Va0 = 1.8
alter Va1 = 0.0
alter Va2 = 1.8
alter Va3 = 1.8
alter Vb0 = 1.8
alter Vb1 = 0.0
alter Vb2 = 0.0
alter Vb3 = 0.0
op
print i(VDD) >> dc_current.txt
alter Va0 = 1.8
alter Va1 = 0.0
alter Va2 = 1.8
alter Va3 = 1.8
alter Vb0 = 0.0
alter Vb1 = 1.8
alter Vb2 = 1.8
alter Vb3 = 1.8
op
print i(VDD) >> dc_current.txt
alter Va0 = 1.8
alter Va1 = 0.0
alter Va2 = 1.8
alter Va3 = 1.8
alter Vb0 = 0.0
alter Vb1 = 1.8
alter Vb2 = 1.8
alter Vb3 = 0.0
op
print i(VDD) >> dc_current.txt
alter Va0 = 1.8
alter Va1 = 0.0
alter Va2 = 1.8
alter Va3 = 1.8
alter Vb0 = 0.0
alter Vb1 = 1.8
alter Vb2 = 0.0
alter Vb3 = 1.8
op
print i(VDD) >> dc_current.txt
alter Va0 = 1.8
alter Va1 = 0.0
alter Va2 = 1.8
alter Va3 = 1.8
alter Vb0 = 0.0
alter Vb1 = 1.8
alter Vb2 = 0.0
alter Vb3 = 0.0
op
print i(VDD) >> dc_current.txt
alter Va0 = 1.8
alter Va1 = 0.0
alter Va2 = 1.8
alter Va3 = 1.8
alter Vb0 = 0.0
alter Vb1 = 0.0
alter Vb2 = 1.8
alter Vb3 = 1.8
op
print i(VDD) >> dc_current.txt
alter Va0 = 1.8
alter Va1 = 0.0
alter Va2 = 1.8
alter Va3 = 1.8
alter Vb0 = 0.0
alter Vb1 = 0.0
alter Vb2 = 1.8
alter Vb3 = 0.0
op
print i(VDD) >> dc_current.txt
alter Va0 = 1.8
alter Va1 = 0.0
alter Va2 = 1.8
alter Va3 = 1.8
alter Vb0 = 0.0
alter Vb1 = 0.0
alter Vb2 = 0.0
alter Vb3 = 1.8
op
print i(VDD) >> dc_current.txt
alter Va0 = 1.8
alter Va1 = 0.0
alter Va2 = 1.8
alter Va3 = 1.8
alter Vb0 = 0.0
alter Vb1 = 0.0
alter Vb2 = 0.0
alter Vb3 = 0.0
op
print i(VDD) >> dc_current.txt
alter Va0 = 1.8
alter Va1 = 0.0
alter Va2 = 1.8
alter Va3 = 0.0
alter Vb0 = 1.8
alter Vb1 = 1.8
alter Vb2 = 1.8
alter Vb3 = 1.8
op
print i(VDD) >> dc_current.txt
alter Va0 = 1.8
alter Va1 = 0.0
alter Va2 = 1.8
alter Va3 = 0.0
alter Vb0 = 1.8
alter Vb1 = 1.8
alter Vb2 = 1.8
alter Vb3 = 0.0
op
print i(VDD) >> dc_current.txt
alter Va0 = 1.8
alter Va1 = 0.0
alter Va2 = 1.8
alter Va3 = 0.0
alter Vb0 = 1.8
alter Vb1 = 1.8
alter Vb2 = 0.0
alter Vb3 = 1.8
op
print i(VDD) >> dc_current.txt
alter Va0 = 1.8
alter Va1 = 0.0
alter Va2 = 1.8
alter Va3 = 0.0
alter Vb0 = 1.8
alter Vb1 = 1.8
alter Vb2 = 0.0
alter Vb3 = 0.0
op
print i(VDD) >> dc_current.txt
alter Va0 = 1.8
alter Va1 = 0.0
alter Va2 = 1.8
alter Va3 = 0.0
alter Vb0 = 1.8
alter Vb1 = 0.0
alter Vb2 = 1.8
alter Vb3 = 1.8
op
print i(VDD) >> dc_current.txt
alter Va0 = 1.8
alter Va1 = 0.0
alter Va2 = 1.8
alter Va3 = 0.0
alter Vb0 = 1.8
alter Vb1 = 0.0
alter Vb2 = 1.8
alter Vb3 = 0.0
op
print i(VDD) >> dc_current.txt
alter Va0 = 1.8
alter Va1 = 0.0
alter Va2 = 1.8
alter Va3 = 0.0
alter Vb0 = 1.8
alter Vb1 = 0.0
alter Vb2 = 0.0
alter Vb3 = 1.8
op
print i(VDD) >> dc_current.txt
alter Va0 = 1.8
alter Va1 = 0.0
alter Va2 = 1.8
alter Va3 = 0.0
alter Vb0 = 1.8
alter Vb1 = 0.0
alter Vb2 = 0.0
alter Vb3 = 0.0
op
print i(VDD) >> dc_current.txt
alter Va0 = 1.8
alter Va1 = 0.0
alter Va2 = 1.8
alter Va3 = 0.0
alter Vb0 = 0.0
alter Vb1 = 1.8
alter Vb2 = 1.8
alter Vb3 = 1.8
op
print i(VDD) >> dc_current.txt
alter Va0 = 1.8
alter Va1 = 0.0
alter Va2 = 1.8
alter Va3 = 0.0
alter Vb0 = 0.0
alter Vb1 = 1.8
alter Vb2 = 1.8
alter Vb3 = 0.0
op
print i(VDD) >> dc_current.txt
alter Va0 = 1.8
alter Va1 = 0.0
alter Va2 = 1.8
alter Va3 = 0.0
alter Vb0 = 0.0
alter Vb1 = 1.8
alter Vb2 = 0.0
alter Vb3 = 1.8
op
print i(VDD) >> dc_current.txt
alter Va0 = 1.8
alter Va1 = 0.0
alter Va2 = 1.8
alter Va3 = 0.0
alter Vb0 = 0.0
alter Vb1 = 1.8
alter Vb2 = 0.0
alter Vb3 = 0.0
op
print i(VDD) >> dc_current.txt
alter Va0 = 1.8
alter Va1 = 0.0
alter Va2 = 1.8
alter Va3 = 0.0
alter Vb0 = 0.0
alter Vb1 = 0.0
alter Vb2 = 1.8
alter Vb3 = 1.8
op
print i(VDD) >> dc_current.txt
alter Va0 = 1.8
alter Va1 = 0.0
alter Va2 = 1.8
alter Va3 = 0.0
alter Vb0 = 0.0
alter Vb1 = 0.0
alter Vb2 = 1.8
alter Vb3 = 0.0
op
print i(VDD) >> dc_current.txt
alter Va0 = 1.8
alter Va1 = 0.0
alter Va2 = 1.8
alter Va3 = 0.0
alter Vb0 = 0.0
alter Vb1 = 0.0
alter Vb2 = 0.0
alter Vb3 = 1.8
op
print i(VDD) >> dc_current.txt
alter Va0 = 1.8
alter Va1 = 0.0
alter Va2 = 1.8
alter Va3 = 0.0
alter Vb0 = 0.0
alter Vb1 = 0.0
alter Vb2 = 0.0
alter Vb3 = 0.0
op
print i(VDD) >> dc_current.txt
alter Va0 = 1.8
alter Va1 = 0.0
alter Va2 = 0.0
alter Va3 = 1.8
alter Vb0 = 1.8
alter Vb1 = 1.8
alter Vb2 = 1.8
alter Vb3 = 1.8
op
print i(VDD) >> dc_current.txt
alter Va0 = 1.8
alter Va1 = 0.0
alter Va2 = 0.0
alter Va3 = 1.8
alter Vb0 = 1.8
alter Vb1 = 1.8
alter Vb2 = 1.8
alter Vb3 = 0.0
op
print i(VDD) >> dc_current.txt
alter Va0 = 1.8
alter Va1 = 0.0
alter Va2 = 0.0
alter Va3 = 1.8
alter Vb0 = 1.8
alter Vb1 = 1.8
alter Vb2 = 0.0
alter Vb3 = 1.8
op
print i(VDD) >> dc_current.txt
alter Va0 = 1.8
alter Va1 = 0.0
alter Va2 = 0.0
alter Va3 = 1.8
alter Vb0 = 1.8
alter Vb1 = 1.8
alter Vb2 = 0.0
alter Vb3 = 0.0
op
print i(VDD) >> dc_current.txt
alter Va0 = 1.8
alter Va1 = 0.0
alter Va2 = 0.0
alter Va3 = 1.8
alter Vb0 = 1.8
alter Vb1 = 0.0
alter Vb2 = 1.8
alter Vb3 = 1.8
op
print i(VDD) >> dc_current.txt
alter Va0 = 1.8
alter Va1 = 0.0
alter Va2 = 0.0
alter Va3 = 1.8
alter Vb0 = 1.8
alter Vb1 = 0.0
alter Vb2 = 1.8
alter Vb3 = 0.0
op
print i(VDD) >> dc_current.txt
alter Va0 = 1.8
alter Va1 = 0.0
alter Va2 = 0.0
alter Va3 = 1.8
alter Vb0 = 1.8
alter Vb1 = 0.0
alter Vb2 = 0.0
alter Vb3 = 1.8
op
print i(VDD) >> dc_current.txt
alter Va0 = 1.8
alter Va1 = 0.0
alter Va2 = 0.0
alter Va3 = 1.8
alter Vb0 = 1.8
alter Vb1 = 0.0
alter Vb2 = 0.0
alter Vb3 = 0.0
op
print i(VDD) >> dc_current.txt
alter Va0 = 1.8
alter Va1 = 0.0
alter Va2 = 0.0
alter Va3 = 1.8
alter Vb0 = 0.0
alter Vb1 = 1.8
alter Vb2 = 1.8
alter Vb3 = 1.8
op
print i(VDD) >> dc_current.txt
alter Va0 = 1.8
alter Va1 = 0.0
alter Va2 = 0.0
alter Va3 = 1.8
alter Vb0 = 0.0
alter Vb1 = 1.8
alter Vb2 = 1.8
alter Vb3 = 0.0
op
print i(VDD) >> dc_current.txt
alter Va0 = 1.8
alter Va1 = 0.0
alter Va2 = 0.0
alter Va3 = 1.8
alter Vb0 = 0.0
alter Vb1 = 1.8
alter Vb2 = 0.0
alter Vb3 = 1.8
op
print i(VDD) >> dc_current.txt
alter Va0 = 1.8
alter Va1 = 0.0
alter Va2 = 0.0
alter Va3 = 1.8
alter Vb0 = 0.0
alter Vb1 = 1.8
alter Vb2 = 0.0
alter Vb3 = 0.0
op
print i(VDD) >> dc_current.txt
alter Va0 = 1.8
alter Va1 = 0.0
alter Va2 = 0.0
alter Va3 = 1.8
alter Vb0 = 0.0
alter Vb1 = 0.0
alter Vb2 = 1.8
alter Vb3 = 1.8
op
print i(VDD) >> dc_current.txt
alter Va0 = 1.8
alter Va1 = 0.0
alter Va2 = 0.0
alter Va3 = 1.8
alter Vb0 = 0.0
alter Vb1 = 0.0
alter Vb2 = 1.8
alter Vb3 = 0.0
op
print i(VDD) >> dc_current.txt
alter Va0 = 1.8
alter Va1 = 0.0
alter Va2 = 0.0
alter Va3 = 1.8
alter Vb0 = 0.0
alter Vb1 = 0.0
alter Vb2 = 0.0
alter Vb3 = 1.8
op
print i(VDD) >> dc_current.txt
alter Va0 = 1.8
alter Va1 = 0.0
alter Va2 = 0.0
alter Va3 = 1.8
alter Vb0 = 0.0
alter Vb1 = 0.0
alter Vb2 = 0.0
alter Vb3 = 0.0
op
print i(VDD) >> dc_current.txt
alter Va0 = 1.8
alter Va1 = 0.0
alter Va2 = 0.0
alter Va3 = 0.0
alter Vb0 = 1.8
alter Vb1 = 1.8
alter Vb2 = 1.8
alter Vb3 = 1.8
op
print i(VDD) >> dc_current.txt
alter Va0 = 1.8
alter Va1 = 0.0
alter Va2 = 0.0
alter Va3 = 0.0
alter Vb0 = 1.8
alter Vb1 = 1.8
alter Vb2 = 1.8
alter Vb3 = 0.0
op
print i(VDD) >> dc_current.txt
alter Va0 = 1.8
alter Va1 = 0.0
alter Va2 = 0.0
alter Va3 = 0.0
alter Vb0 = 1.8
alter Vb1 = 1.8
alter Vb2 = 0.0
alter Vb3 = 1.8
op
print i(VDD) >> dc_current.txt
alter Va0 = 1.8
alter Va1 = 0.0
alter Va2 = 0.0
alter Va3 = 0.0
alter Vb0 = 1.8
alter Vb1 = 1.8
alter Vb2 = 0.0
alter Vb3 = 0.0
op
print i(VDD) >> dc_current.txt
alter Va0 = 1.8
alter Va1 = 0.0
alter Va2 = 0.0
alter Va3 = 0.0
alter Vb0 = 1.8
alter Vb1 = 0.0
alter Vb2 = 1.8
alter Vb3 = 1.8
op
print i(VDD) >> dc_current.txt
alter Va0 = 1.8
alter Va1 = 0.0
alter Va2 = 0.0
alter Va3 = 0.0
alter Vb0 = 1.8
alter Vb1 = 0.0
alter Vb2 = 1.8
alter Vb3 = 0.0
op
print i(VDD) >> dc_current.txt
alter Va0 = 1.8
alter Va1 = 0.0
alter Va2 = 0.0
alter Va3 = 0.0
alter Vb0 = 1.8
alter Vb1 = 0.0
alter Vb2 = 0.0
alter Vb3 = 1.8
op
print i(VDD) >> dc_current.txt
alter Va0 = 1.8
alter Va1 = 0.0
alter Va2 = 0.0
alter Va3 = 0.0
alter Vb0 = 1.8
alter Vb1 = 0.0
alter Vb2 = 0.0
alter Vb3 = 0.0
op
print i(VDD) >> dc_current.txt
alter Va0 = 1.8
alter Va1 = 0.0
alter Va2 = 0.0
alter Va3 = 0.0
alter Vb0 = 0.0
alter Vb1 = 1.8
alter Vb2 = 1.8
alter Vb3 = 1.8
op
print i(VDD) >> dc_current.txt
alter Va0 = 1.8
alter Va1 = 0.0
alter Va2 = 0.0
alter Va3 = 0.0
alter Vb0 = 0.0
alter Vb1 = 1.8
alter Vb2 = 1.8
alter Vb3 = 0.0
op
print i(VDD) >> dc_current.txt
alter Va0 = 1.8
alter Va1 = 0.0
alter Va2 = 0.0
alter Va3 = 0.0
alter Vb0 = 0.0
alter Vb1 = 1.8
alter Vb2 = 0.0
alter Vb3 = 1.8
op
print i(VDD) >> dc_current.txt
alter Va0 = 1.8
alter Va1 = 0.0
alter Va2 = 0.0
alter Va3 = 0.0
alter Vb0 = 0.0
alter Vb1 = 1.8
alter Vb2 = 0.0
alter Vb3 = 0.0
op
print i(VDD) >> dc_current.txt
alter Va0 = 1.8
alter Va1 = 0.0
alter Va2 = 0.0
alter Va3 = 0.0
alter Vb0 = 0.0
alter Vb1 = 0.0
alter Vb2 = 1.8
alter Vb3 = 1.8
op
print i(VDD) >> dc_current.txt
alter Va0 = 1.8
alter Va1 = 0.0
alter Va2 = 0.0
alter Va3 = 0.0
alter Vb0 = 0.0
alter Vb1 = 0.0
alter Vb2 = 1.8
alter Vb3 = 0.0
op
print i(VDD) >> dc_current.txt
alter Va0 = 1.8
alter Va1 = 0.0
alter Va2 = 0.0
alter Va3 = 0.0
alter Vb0 = 0.0
alter Vb1 = 0.0
alter Vb2 = 0.0
alter Vb3 = 1.8
op
print i(VDD) >> dc_current.txt
alter Va0 = 1.8
alter Va1 = 0.0
alter Va2 = 0.0
alter Va3 = 0.0
alter Vb0 = 0.0
alter Vb1 = 0.0
alter Vb2 = 0.0
alter Vb3 = 0.0
op
print i(VDD) >> dc_current.txt
alter Va0 = 0.0
alter Va1 = 1.8
alter Va2 = 1.8
alter Va3 = 1.8
alter Vb0 = 1.8
alter Vb1 = 1.8
alter Vb2 = 1.8
alter Vb3 = 1.8
op
print i(VDD) >> dc_current.txt
alter Va0 = 0.0
alter Va1 = 1.8
alter Va2 = 1.8
alter Va3 = 1.8
alter Vb0 = 1.8
alter Vb1 = 1.8
alter Vb2 = 1.8
alter Vb3 = 0.0
op
print i(VDD) >> dc_current.txt
alter Va0 = 0.0
alter Va1 = 1.8
alter Va2 = 1.8
alter Va3 = 1.8
alter Vb0 = 1.8
alter Vb1 = 1.8
alter Vb2 = 0.0
alter Vb3 = 1.8
op
print i(VDD) >> dc_current.txt
alter Va0 = 0.0
alter Va1 = 1.8
alter Va2 = 1.8
alter Va3 = 1.8
alter Vb0 = 1.8
alter Vb1 = 1.8
alter Vb2 = 0.0
alter Vb3 = 0.0
op
print i(VDD) >> dc_current.txt
alter Va0 = 0.0
alter Va1 = 1.8
alter Va2 = 1.8
alter Va3 = 1.8
alter Vb0 = 1.8
alter Vb1 = 0.0
alter Vb2 = 1.8
alter Vb3 = 1.8
op
print i(VDD) >> dc_current.txt
alter Va0 = 0.0
alter Va1 = 1.8
alter Va2 = 1.8
alter Va3 = 1.8
alter Vb0 = 1.8
alter Vb1 = 0.0
alter Vb2 = 1.8
alter Vb3 = 0.0
op
print i(VDD) >> dc_current.txt
alter Va0 = 0.0
alter Va1 = 1.8
alter Va2 = 1.8
alter Va3 = 1.8
alter Vb0 = 1.8
alter Vb1 = 0.0
alter Vb2 = 0.0
alter Vb3 = 1.8
op
print i(VDD) >> dc_current.txt
alter Va0 = 0.0
alter Va1 = 1.8
alter Va2 = 1.8
alter Va3 = 1.8
alter Vb0 = 1.8
alter Vb1 = 0.0
alter Vb2 = 0.0
alter Vb3 = 0.0
op
print i(VDD) >> dc_current.txt
alter Va0 = 0.0
alter Va1 = 1.8
alter Va2 = 1.8
alter Va3 = 1.8
alter Vb0 = 0.0
alter Vb1 = 1.8
alter Vb2 = 1.8
alter Vb3 = 1.8
op
print i(VDD) >> dc_current.txt
alter Va0 = 0.0
alter Va1 = 1.8
alter Va2 = 1.8
alter Va3 = 1.8
alter Vb0 = 0.0
alter Vb1 = 1.8
alter Vb2 = 1.8
alter Vb3 = 0.0
op
print i(VDD) >> dc_current.txt
alter Va0 = 0.0
alter Va1 = 1.8
alter Va2 = 1.8
alter Va3 = 1.8
alter Vb0 = 0.0
alter Vb1 = 1.8
alter Vb2 = 0.0
alter Vb3 = 1.8
op
print i(VDD) >> dc_current.txt
alter Va0 = 0.0
alter Va1 = 1.8
alter Va2 = 1.8
alter Va3 = 1.8
alter Vb0 = 0.0
alter Vb1 = 1.8
alter Vb2 = 0.0
alter Vb3 = 0.0
op
print i(VDD) >> dc_current.txt
alter Va0 = 0.0
alter Va1 = 1.8
alter Va2 = 1.8
alter Va3 = 1.8
alter Vb0 = 0.0
alter Vb1 = 0.0
alter Vb2 = 1.8
alter Vb3 = 1.8
op
print i(VDD) >> dc_current.txt
alter Va0 = 0.0
alter Va1 = 1.8
alter Va2 = 1.8
alter Va3 = 1.8
alter Vb0 = 0.0
alter Vb1 = 0.0
alter Vb2 = 1.8
alter Vb3 = 0.0
op
print i(VDD) >> dc_current.txt
alter Va0 = 0.0
alter Va1 = 1.8
alter Va2 = 1.8
alter Va3 = 1.8
alter Vb0 = 0.0
alter Vb1 = 0.0
alter Vb2 = 0.0
alter Vb3 = 1.8
op
print i(VDD) >> dc_current.txt
alter Va0 = 0.0
alter Va1 = 1.8
alter Va2 = 1.8
alter Va3 = 1.8
alter Vb0 = 0.0
alter Vb1 = 0.0
alter Vb2 = 0.0
alter Vb3 = 0.0
op
print i(VDD) >> dc_current.txt
alter Va0 = 0.0
alter Va1 = 1.8
alter Va2 = 1.8
alter Va3 = 0.0
alter Vb0 = 1.8
alter Vb1 = 1.8
alter Vb2 = 1.8
alter Vb3 = 1.8
op
print i(VDD) >> dc_current.txt
alter Va0 = 0.0
alter Va1 = 1.8
alter Va2 = 1.8
alter Va3 = 0.0
alter Vb0 = 1.8
alter Vb1 = 1.8
alter Vb2 = 1.8
alter Vb3 = 0.0
op
print i(VDD) >> dc_current.txt
alter Va0 = 0.0
alter Va1 = 1.8
alter Va2 = 1.8
alter Va3 = 0.0
alter Vb0 = 1.8
alter Vb1 = 1.8
alter Vb2 = 0.0
alter Vb3 = 1.8
op
print i(VDD) >> dc_current.txt
alter Va0 = 0.0
alter Va1 = 1.8
alter Va2 = 1.8
alter Va3 = 0.0
alter Vb0 = 1.8
alter Vb1 = 1.8
alter Vb2 = 0.0
alter Vb3 = 0.0
op
print i(VDD) >> dc_current.txt
alter Va0 = 0.0
alter Va1 = 1.8
alter Va2 = 1.8
alter Va3 = 0.0
alter Vb0 = 1.8
alter Vb1 = 0.0
alter Vb2 = 1.8
alter Vb3 = 1.8
op
print i(VDD) >> dc_current.txt
alter Va0 = 0.0
alter Va1 = 1.8
alter Va2 = 1.8
alter Va3 = 0.0
alter Vb0 = 1.8
alter Vb1 = 0.0
alter Vb2 = 1.8
alter Vb3 = 0.0
op
print i(VDD) >> dc_current.txt
alter Va0 = 0.0
alter Va1 = 1.8
alter Va2 = 1.8
alter Va3 = 0.0
alter Vb0 = 1.8
alter Vb1 = 0.0
alter Vb2 = 0.0
alter Vb3 = 1.8
op
print i(VDD) >> dc_current.txt
alter Va0 = 0.0
alter Va1 = 1.8
alter Va2 = 1.8
alter Va3 = 0.0
alter Vb0 = 1.8
alter Vb1 = 0.0
alter Vb2 = 0.0
alter Vb3 = 0.0
op
print i(VDD) >> dc_current.txt
alter Va0 = 0.0
alter Va1 = 1.8
alter Va2 = 1.8
alter Va3 = 0.0
alter Vb0 = 0.0
alter Vb1 = 1.8
alter Vb2 = 1.8
alter Vb3 = 1.8
op
print i(VDD) >> dc_current.txt
alter Va0 = 0.0
alter Va1 = 1.8
alter Va2 = 1.8
alter Va3 = 0.0
alter Vb0 = 0.0
alter Vb1 = 1.8
alter Vb2 = 1.8
alter Vb3 = 0.0
op
print i(VDD) >> dc_current.txt
alter Va0 = 0.0
alter Va1 = 1.8
alter Va2 = 1.8
alter Va3 = 0.0
alter Vb0 = 0.0
alter Vb1 = 1.8
alter Vb2 = 0.0
alter Vb3 = 1.8
op
print i(VDD) >> dc_current.txt
alter Va0 = 0.0
alter Va1 = 1.8
alter Va2 = 1.8
alter Va3 = 0.0
alter Vb0 = 0.0
alter Vb1 = 1.8
alter Vb2 = 0.0
alter Vb3 = 0.0
op
print i(VDD) >> dc_current.txt
alter Va0 = 0.0
alter Va1 = 1.8
alter Va2 = 1.8
alter Va3 = 0.0
alter Vb0 = 0.0
alter Vb1 = 0.0
alter Vb2 = 1.8
alter Vb3 = 1.8
op
print i(VDD) >> dc_current.txt
alter Va0 = 0.0
alter Va1 = 1.8
alter Va2 = 1.8
alter Va3 = 0.0
alter Vb0 = 0.0
alter Vb1 = 0.0
alter Vb2 = 1.8
alter Vb3 = 0.0
op
print i(VDD) >> dc_current.txt
alter Va0 = 0.0
alter Va1 = 1.8
alter Va2 = 1.8
alter Va3 = 0.0
alter Vb0 = 0.0
alter Vb1 = 0.0
alter Vb2 = 0.0
alter Vb3 = 1.8
op
print i(VDD) >> dc_current.txt
alter Va0 = 0.0
alter Va1 = 1.8
alter Va2 = 1.8
alter Va3 = 0.0
alter Vb0 = 0.0
alter Vb1 = 0.0
alter Vb2 = 0.0
alter Vb3 = 0.0
op
print i(VDD) >> dc_current.txt
alter Va0 = 0.0
alter Va1 = 1.8
alter Va2 = 0.0
alter Va3 = 1.8
alter Vb0 = 1.8
alter Vb1 = 1.8
alter Vb2 = 1.8
alter Vb3 = 1.8
op
print i(VDD) >> dc_current.txt
alter Va0 = 0.0
alter Va1 = 1.8
alter Va2 = 0.0
alter Va3 = 1.8
alter Vb0 = 1.8
alter Vb1 = 1.8
alter Vb2 = 1.8
alter Vb3 = 0.0
op
print i(VDD) >> dc_current.txt
alter Va0 = 0.0
alter Va1 = 1.8
alter Va2 = 0.0
alter Va3 = 1.8
alter Vb0 = 1.8
alter Vb1 = 1.8
alter Vb2 = 0.0
alter Vb3 = 1.8
op
print i(VDD) >> dc_current.txt
alter Va0 = 0.0
alter Va1 = 1.8
alter Va2 = 0.0
alter Va3 = 1.8
alter Vb0 = 1.8
alter Vb1 = 1.8
alter Vb2 = 0.0
alter Vb3 = 0.0
op
print i(VDD) >> dc_current.txt
alter Va0 = 0.0
alter Va1 = 1.8
alter Va2 = 0.0
alter Va3 = 1.8
alter Vb0 = 1.8
alter Vb1 = 0.0
alter Vb2 = 1.8
alter Vb3 = 1.8
op
print i(VDD) >> dc_current.txt
alter Va0 = 0.0
alter Va1 = 1.8
alter Va2 = 0.0
alter Va3 = 1.8
alter Vb0 = 1.8
alter Vb1 = 0.0
alter Vb2 = 1.8
alter Vb3 = 0.0
op
print i(VDD) >> dc_current.txt
alter Va0 = 0.0
alter Va1 = 1.8
alter Va2 = 0.0
alter Va3 = 1.8
alter Vb0 = 1.8
alter Vb1 = 0.0
alter Vb2 = 0.0
alter Vb3 = 1.8
op
print i(VDD) >> dc_current.txt
alter Va0 = 0.0
alter Va1 = 1.8
alter Va2 = 0.0
alter Va3 = 1.8
alter Vb0 = 1.8
alter Vb1 = 0.0
alter Vb2 = 0.0
alter Vb3 = 0.0
op
print i(VDD) >> dc_current.txt
alter Va0 = 0.0
alter Va1 = 1.8
alter Va2 = 0.0
alter Va3 = 1.8
alter Vb0 = 0.0
alter Vb1 = 1.8
alter Vb2 = 1.8
alter Vb3 = 1.8
op
print i(VDD) >> dc_current.txt
alter Va0 = 0.0
alter Va1 = 1.8
alter Va2 = 0.0
alter Va3 = 1.8
alter Vb0 = 0.0
alter Vb1 = 1.8
alter Vb2 = 1.8
alter Vb3 = 0.0
op
print i(VDD) >> dc_current.txt
alter Va0 = 0.0
alter Va1 = 1.8
alter Va2 = 0.0
alter Va3 = 1.8
alter Vb0 = 0.0
alter Vb1 = 1.8
alter Vb2 = 0.0
alter Vb3 = 1.8
op
print i(VDD) >> dc_current.txt
alter Va0 = 0.0
alter Va1 = 1.8
alter Va2 = 0.0
alter Va3 = 1.8
alter Vb0 = 0.0
alter Vb1 = 1.8
alter Vb2 = 0.0
alter Vb3 = 0.0
op
print i(VDD) >> dc_current.txt
alter Va0 = 0.0
alter Va1 = 1.8
alter Va2 = 0.0
alter Va3 = 1.8
alter Vb0 = 0.0
alter Vb1 = 0.0
alter Vb2 = 1.8
alter Vb3 = 1.8
op
print i(VDD) >> dc_current.txt
alter Va0 = 0.0
alter Va1 = 1.8
alter Va2 = 0.0
alter Va3 = 1.8
alter Vb0 = 0.0
alter Vb1 = 0.0
alter Vb2 = 1.8
alter Vb3 = 0.0
op
print i(VDD) >> dc_current.txt
alter Va0 = 0.0
alter Va1 = 1.8
alter Va2 = 0.0
alter Va3 = 1.8
alter Vb0 = 0.0
alter Vb1 = 0.0
alter Vb2 = 0.0
alter Vb3 = 1.8
op
print i(VDD) >> dc_current.txt
alter Va0 = 0.0
alter Va1 = 1.8
alter Va2 = 0.0
alter Va3 = 1.8
alter Vb0 = 0.0
alter Vb1 = 0.0
alter Vb2 = 0.0
alter Vb3 = 0.0
op
print i(VDD) >> dc_current.txt
alter Va0 = 0.0
alter Va1 = 1.8
alter Va2 = 0.0
alter Va3 = 0.0
alter Vb0 = 1.8
alter Vb1 = 1.8
alter Vb2 = 1.8
alter Vb3 = 1.8
op
print i(VDD) >> dc_current.txt
alter Va0 = 0.0
alter Va1 = 1.8
alter Va2 = 0.0
alter Va3 = 0.0
alter Vb0 = 1.8
alter Vb1 = 1.8
alter Vb2 = 1.8
alter Vb3 = 0.0
op
print i(VDD) >> dc_current.txt
alter Va0 = 0.0
alter Va1 = 1.8
alter Va2 = 0.0
alter Va3 = 0.0
alter Vb0 = 1.8
alter Vb1 = 1.8
alter Vb2 = 0.0
alter Vb3 = 1.8
op
print i(VDD) >> dc_current.txt
alter Va0 = 0.0
alter Va1 = 1.8
alter Va2 = 0.0
alter Va3 = 0.0
alter Vb0 = 1.8
alter Vb1 = 1.8
alter Vb2 = 0.0
alter Vb3 = 0.0
op
print i(VDD) >> dc_current.txt
alter Va0 = 0.0
alter Va1 = 1.8
alter Va2 = 0.0
alter Va3 = 0.0
alter Vb0 = 1.8
alter Vb1 = 0.0
alter Vb2 = 1.8
alter Vb3 = 1.8
op
print i(VDD) >> dc_current.txt
alter Va0 = 0.0
alter Va1 = 1.8
alter Va2 = 0.0
alter Va3 = 0.0
alter Vb0 = 1.8
alter Vb1 = 0.0
alter Vb2 = 1.8
alter Vb3 = 0.0
op
print i(VDD) >> dc_current.txt
alter Va0 = 0.0
alter Va1 = 1.8
alter Va2 = 0.0
alter Va3 = 0.0
alter Vb0 = 1.8
alter Vb1 = 0.0
alter Vb2 = 0.0
alter Vb3 = 1.8
op
print i(VDD) >> dc_current.txt
alter Va0 = 0.0
alter Va1 = 1.8
alter Va2 = 0.0
alter Va3 = 0.0
alter Vb0 = 1.8
alter Vb1 = 0.0
alter Vb2 = 0.0
alter Vb3 = 0.0
op
print i(VDD) >> dc_current.txt
alter Va0 = 0.0
alter Va1 = 1.8
alter Va2 = 0.0
alter Va3 = 0.0
alter Vb0 = 0.0
alter Vb1 = 1.8
alter Vb2 = 1.8
alter Vb3 = 1.8
op
print i(VDD) >> dc_current.txt
alter Va0 = 0.0
alter Va1 = 1.8
alter Va2 = 0.0
alter Va3 = 0.0
alter Vb0 = 0.0
alter Vb1 = 1.8
alter Vb2 = 1.8
alter Vb3 = 0.0
op
print i(VDD) >> dc_current.txt
alter Va0 = 0.0
alter Va1 = 1.8
alter Va2 = 0.0
alter Va3 = 0.0
alter Vb0 = 0.0
alter Vb1 = 1.8
alter Vb2 = 0.0
alter Vb3 = 1.8
op
print i(VDD) >> dc_current.txt
alter Va0 = 0.0
alter Va1 = 1.8
alter Va2 = 0.0
alter Va3 = 0.0
alter Vb0 = 0.0
alter Vb1 = 1.8
alter Vb2 = 0.0
alter Vb3 = 0.0
op
print i(VDD) >> dc_current.txt
alter Va0 = 0.0
alter Va1 = 1.8
alter Va2 = 0.0
alter Va3 = 0.0
alter Vb0 = 0.0
alter Vb1 = 0.0
alter Vb2 = 1.8
alter Vb3 = 1.8
op
print i(VDD) >> dc_current.txt
alter Va0 = 0.0
alter Va1 = 1.8
alter Va2 = 0.0
alter Va3 = 0.0
alter Vb0 = 0.0
alter Vb1 = 0.0
alter Vb2 = 1.8
alter Vb3 = 0.0
op
print i(VDD) >> dc_current.txt
alter Va0 = 0.0
alter Va1 = 1.8
alter Va2 = 0.0
alter Va3 = 0.0
alter Vb0 = 0.0
alter Vb1 = 0.0
alter Vb2 = 0.0
alter Vb3 = 1.8
op
print i(VDD) >> dc_current.txt
alter Va0 = 0.0
alter Va1 = 1.8
alter Va2 = 0.0
alter Va3 = 0.0
alter Vb0 = 0.0
alter Vb1 = 0.0
alter Vb2 = 0.0
alter Vb3 = 0.0
op
print i(VDD) >> dc_current.txt
alter Va0 = 0.0
alter Va1 = 0.0
alter Va2 = 1.8
alter Va3 = 1.8
alter Vb0 = 1.8
alter Vb1 = 1.8
alter Vb2 = 1.8
alter Vb3 = 1.8
op
print i(VDD) >> dc_current.txt
alter Va0 = 0.0
alter Va1 = 0.0
alter Va2 = 1.8
alter Va3 = 1.8
alter Vb0 = 1.8
alter Vb1 = 1.8
alter Vb2 = 1.8
alter Vb3 = 0.0
op
print i(VDD) >> dc_current.txt
alter Va0 = 0.0
alter Va1 = 0.0
alter Va2 = 1.8
alter Va3 = 1.8
alter Vb0 = 1.8
alter Vb1 = 1.8
alter Vb2 = 0.0
alter Vb3 = 1.8
op
print i(VDD) >> dc_current.txt
alter Va0 = 0.0
alter Va1 = 0.0
alter Va2 = 1.8
alter Va3 = 1.8
alter Vb0 = 1.8
alter Vb1 = 1.8
alter Vb2 = 0.0
alter Vb3 = 0.0
op
print i(VDD) >> dc_current.txt
alter Va0 = 0.0
alter Va1 = 0.0
alter Va2 = 1.8
alter Va3 = 1.8
alter Vb0 = 1.8
alter Vb1 = 0.0
alter Vb2 = 1.8
alter Vb3 = 1.8
op
print i(VDD) >> dc_current.txt
alter Va0 = 0.0
alter Va1 = 0.0
alter Va2 = 1.8
alter Va3 = 1.8
alter Vb0 = 1.8
alter Vb1 = 0.0
alter Vb2 = 1.8
alter Vb3 = 0.0
op
print i(VDD) >> dc_current.txt
alter Va0 = 0.0
alter Va1 = 0.0
alter Va2 = 1.8
alter Va3 = 1.8
alter Vb0 = 1.8
alter Vb1 = 0.0
alter Vb2 = 0.0
alter Vb3 = 1.8
op
print i(VDD) >> dc_current.txt
alter Va0 = 0.0
alter Va1 = 0.0
alter Va2 = 1.8
alter Va3 = 1.8
alter Vb0 = 1.8
alter Vb1 = 0.0
alter Vb2 = 0.0
alter Vb3 = 0.0
op
print i(VDD) >> dc_current.txt
alter Va0 = 0.0
alter Va1 = 0.0
alter Va2 = 1.8
alter Va3 = 1.8
alter Vb0 = 0.0
alter Vb1 = 1.8
alter Vb2 = 1.8
alter Vb3 = 1.8
op
print i(VDD) >> dc_current.txt
alter Va0 = 0.0
alter Va1 = 0.0
alter Va2 = 1.8
alter Va3 = 1.8
alter Vb0 = 0.0
alter Vb1 = 1.8
alter Vb2 = 1.8
alter Vb3 = 0.0
op
print i(VDD) >> dc_current.txt
alter Va0 = 0.0
alter Va1 = 0.0
alter Va2 = 1.8
alter Va3 = 1.8
alter Vb0 = 0.0
alter Vb1 = 1.8
alter Vb2 = 0.0
alter Vb3 = 1.8
op
print i(VDD) >> dc_current.txt
alter Va0 = 0.0
alter Va1 = 0.0
alter Va2 = 1.8
alter Va3 = 1.8
alter Vb0 = 0.0
alter Vb1 = 1.8
alter Vb2 = 0.0
alter Vb3 = 0.0
op
print i(VDD) >> dc_current.txt
alter Va0 = 0.0
alter Va1 = 0.0
alter Va2 = 1.8
alter Va3 = 1.8
alter Vb0 = 0.0
alter Vb1 = 0.0
alter Vb2 = 1.8
alter Vb3 = 1.8
op
print i(VDD) >> dc_current.txt
alter Va0 = 0.0
alter Va1 = 0.0
alter Va2 = 1.8
alter Va3 = 1.8
alter Vb0 = 0.0
alter Vb1 = 0.0
alter Vb2 = 1.8
alter Vb3 = 0.0
op
print i(VDD) >> dc_current.txt
alter Va0 = 0.0
alter Va1 = 0.0
alter Va2 = 1.8
alter Va3 = 1.8
alter Vb0 = 0.0
alter Vb1 = 0.0
alter Vb2 = 0.0
alter Vb3 = 1.8
op
print i(VDD) >> dc_current.txt
alter Va0 = 0.0
alter Va1 = 0.0
alter Va2 = 1.8
alter Va3 = 1.8
alter Vb0 = 0.0
alter Vb1 = 0.0
alter Vb2 = 0.0
alter Vb3 = 0.0
op
print i(VDD) >> dc_current.txt
alter Va0 = 0.0
alter Va1 = 0.0
alter Va2 = 1.8
alter Va3 = 0.0
alter Vb0 = 1.8
alter Vb1 = 1.8
alter Vb2 = 1.8
alter Vb3 = 1.8
op
print i(VDD) >> dc_current.txt
alter Va0 = 0.0
alter Va1 = 0.0
alter Va2 = 1.8
alter Va3 = 0.0
alter Vb0 = 1.8
alter Vb1 = 1.8
alter Vb2 = 1.8
alter Vb3 = 0.0
op
print i(VDD) >> dc_current.txt
alter Va0 = 0.0
alter Va1 = 0.0
alter Va2 = 1.8
alter Va3 = 0.0
alter Vb0 = 1.8
alter Vb1 = 1.8
alter Vb2 = 0.0
alter Vb3 = 1.8
op
print i(VDD) >> dc_current.txt
alter Va0 = 0.0
alter Va1 = 0.0
alter Va2 = 1.8
alter Va3 = 0.0
alter Vb0 = 1.8
alter Vb1 = 1.8
alter Vb2 = 0.0
alter Vb3 = 0.0
op
print i(VDD) >> dc_current.txt
alter Va0 = 0.0
alter Va1 = 0.0
alter Va2 = 1.8
alter Va3 = 0.0
alter Vb0 = 1.8
alter Vb1 = 0.0
alter Vb2 = 1.8
alter Vb3 = 1.8
op
print i(VDD) >> dc_current.txt
alter Va0 = 0.0
alter Va1 = 0.0
alter Va2 = 1.8
alter Va3 = 0.0
alter Vb0 = 1.8
alter Vb1 = 0.0
alter Vb2 = 1.8
alter Vb3 = 0.0
op
print i(VDD) >> dc_current.txt
alter Va0 = 0.0
alter Va1 = 0.0
alter Va2 = 1.8
alter Va3 = 0.0
alter Vb0 = 1.8
alter Vb1 = 0.0
alter Vb2 = 0.0
alter Vb3 = 1.8
op
print i(VDD) >> dc_current.txt
alter Va0 = 0.0
alter Va1 = 0.0
alter Va2 = 1.8
alter Va3 = 0.0
alter Vb0 = 1.8
alter Vb1 = 0.0
alter Vb2 = 0.0
alter Vb3 = 0.0
op
print i(VDD) >> dc_current.txt
alter Va0 = 0.0
alter Va1 = 0.0
alter Va2 = 1.8
alter Va3 = 0.0
alter Vb0 = 0.0
alter Vb1 = 1.8
alter Vb2 = 1.8
alter Vb3 = 1.8
op
print i(VDD) >> dc_current.txt
alter Va0 = 0.0
alter Va1 = 0.0
alter Va2 = 1.8
alter Va3 = 0.0
alter Vb0 = 0.0
alter Vb1 = 1.8
alter Vb2 = 1.8
alter Vb3 = 0.0
op
print i(VDD) >> dc_current.txt
alter Va0 = 0.0
alter Va1 = 0.0
alter Va2 = 1.8
alter Va3 = 0.0
alter Vb0 = 0.0
alter Vb1 = 1.8
alter Vb2 = 0.0
alter Vb3 = 1.8
op
print i(VDD) >> dc_current.txt
alter Va0 = 0.0
alter Va1 = 0.0
alter Va2 = 1.8
alter Va3 = 0.0
alter Vb0 = 0.0
alter Vb1 = 1.8
alter Vb2 = 0.0
alter Vb3 = 0.0
op
print i(VDD) >> dc_current.txt
alter Va0 = 0.0
alter Va1 = 0.0
alter Va2 = 1.8
alter Va3 = 0.0
alter Vb0 = 0.0
alter Vb1 = 0.0
alter Vb2 = 1.8
alter Vb3 = 1.8
op
print i(VDD) >> dc_current.txt
alter Va0 = 0.0
alter Va1 = 0.0
alter Va2 = 1.8
alter Va3 = 0.0
alter Vb0 = 0.0
alter Vb1 = 0.0
alter Vb2 = 1.8
alter Vb3 = 0.0
op
print i(VDD) >> dc_current.txt
alter Va0 = 0.0
alter Va1 = 0.0
alter Va2 = 1.8
alter Va3 = 0.0
alter Vb0 = 0.0
alter Vb1 = 0.0
alter Vb2 = 0.0
alter Vb3 = 1.8
op
print i(VDD) >> dc_current.txt
alter Va0 = 0.0
alter Va1 = 0.0
alter Va2 = 1.8
alter Va3 = 0.0
alter Vb0 = 0.0
alter Vb1 = 0.0
alter Vb2 = 0.0
alter Vb3 = 0.0
op
print i(VDD) >> dc_current.txt
alter Va0 = 0.0
alter Va1 = 0.0
alter Va2 = 0.0
alter Va3 = 1.8
alter Vb0 = 1.8
alter Vb1 = 1.8
alter Vb2 = 1.8
alter Vb3 = 1.8
op
print i(VDD) >> dc_current.txt
alter Va0 = 0.0
alter Va1 = 0.0
alter Va2 = 0.0
alter Va3 = 1.8
alter Vb0 = 1.8
alter Vb1 = 1.8
alter Vb2 = 1.8
alter Vb3 = 0.0
op
print i(VDD) >> dc_current.txt
alter Va0 = 0.0
alter Va1 = 0.0
alter Va2 = 0.0
alter Va3 = 1.8
alter Vb0 = 1.8
alter Vb1 = 1.8
alter Vb2 = 0.0
alter Vb3 = 1.8
op
print i(VDD) >> dc_current.txt
alter Va0 = 0.0
alter Va1 = 0.0
alter Va2 = 0.0
alter Va3 = 1.8
alter Vb0 = 1.8
alter Vb1 = 1.8
alter Vb2 = 0.0
alter Vb3 = 0.0
op
print i(VDD) >> dc_current.txt
alter Va0 = 0.0
alter Va1 = 0.0
alter Va2 = 0.0
alter Va3 = 1.8
alter Vb0 = 1.8
alter Vb1 = 0.0
alter Vb2 = 1.8
alter Vb3 = 1.8
op
print i(VDD) >> dc_current.txt
alter Va0 = 0.0
alter Va1 = 0.0
alter Va2 = 0.0
alter Va3 = 1.8
alter Vb0 = 1.8
alter Vb1 = 0.0
alter Vb2 = 1.8
alter Vb3 = 0.0
op
print i(VDD) >> dc_current.txt
alter Va0 = 0.0
alter Va1 = 0.0
alter Va2 = 0.0
alter Va3 = 1.8
alter Vb0 = 1.8
alter Vb1 = 0.0
alter Vb2 = 0.0
alter Vb3 = 1.8
op
print i(VDD) >> dc_current.txt
alter Va0 = 0.0
alter Va1 = 0.0
alter Va2 = 0.0
alter Va3 = 1.8
alter Vb0 = 1.8
alter Vb1 = 0.0
alter Vb2 = 0.0
alter Vb3 = 0.0
op
print i(VDD) >> dc_current.txt
alter Va0 = 0.0
alter Va1 = 0.0
alter Va2 = 0.0
alter Va3 = 1.8
alter Vb0 = 0.0
alter Vb1 = 1.8
alter Vb2 = 1.8
alter Vb3 = 1.8
op
print i(VDD) >> dc_current.txt
alter Va0 = 0.0
alter Va1 = 0.0
alter Va2 = 0.0
alter Va3 = 1.8
alter Vb0 = 0.0
alter Vb1 = 1.8
alter Vb2 = 1.8
alter Vb3 = 0.0
op
print i(VDD) >> dc_current.txt
alter Va0 = 0.0
alter Va1 = 0.0
alter Va2 = 0.0
alter Va3 = 1.8
alter Vb0 = 0.0
alter Vb1 = 1.8
alter Vb2 = 0.0
alter Vb3 = 1.8
op
print i(VDD) >> dc_current.txt
alter Va0 = 0.0
alter Va1 = 0.0
alter Va2 = 0.0
alter Va3 = 1.8
alter Vb0 = 0.0
alter Vb1 = 1.8
alter Vb2 = 0.0
alter Vb3 = 0.0
op
print i(VDD) >> dc_current.txt
alter Va0 = 0.0
alter Va1 = 0.0
alter Va2 = 0.0
alter Va3 = 1.8
alter Vb0 = 0.0
alter Vb1 = 0.0
alter Vb2 = 1.8
alter Vb3 = 1.8
op
print i(VDD) >> dc_current.txt
alter Va0 = 0.0
alter Va1 = 0.0
alter Va2 = 0.0
alter Va3 = 1.8
alter Vb0 = 0.0
alter Vb1 = 0.0
alter Vb2 = 1.8
alter Vb3 = 0.0
op
print i(VDD) >> dc_current.txt
alter Va0 = 0.0
alter Va1 = 0.0
alter Va2 = 0.0
alter Va3 = 1.8
alter Vb0 = 0.0
alter Vb1 = 0.0
alter Vb2 = 0.0
alter Vb3 = 1.8
op
print i(VDD) >> dc_current.txt
alter Va0 = 0.0
alter Va1 = 0.0
alter Va2 = 0.0
alter Va3 = 1.8
alter Vb0 = 0.0
alter Vb1 = 0.0
alter Vb2 = 0.0
alter Vb3 = 0.0
op
print i(VDD) >> dc_current.txt
alter Va0 = 0.0
alter Va1 = 0.0
alter Va2 = 0.0
alter Va3 = 0.0
alter Vb0 = 1.8
alter Vb1 = 1.8
alter Vb2 = 1.8
alter Vb3 = 1.8
op
print i(VDD) >> dc_current.txt
alter Va0 = 0.0
alter Va1 = 0.0
alter Va2 = 0.0
alter Va3 = 0.0
alter Vb0 = 1.8
alter Vb1 = 1.8
alter Vb2 = 1.8
alter Vb3 = 0.0
op
print i(VDD) >> dc_current.txt
alter Va0 = 0.0
alter Va1 = 0.0
alter Va2 = 0.0
alter Va3 = 0.0
alter Vb0 = 1.8
alter Vb1 = 1.8
alter Vb2 = 0.0
alter Vb3 = 1.8
op
print i(VDD) >> dc_current.txt
alter Va0 = 0.0
alter Va1 = 0.0
alter Va2 = 0.0
alter Va3 = 0.0
alter Vb0 = 1.8
alter Vb1 = 1.8
alter Vb2 = 0.0
alter Vb3 = 0.0
op
print i(VDD) >> dc_current.txt
alter Va0 = 0.0
alter Va1 = 0.0
alter Va2 = 0.0
alter Va3 = 0.0
alter Vb0 = 1.8
alter Vb1 = 0.0
alter Vb2 = 1.8
alter Vb3 = 1.8
op
print i(VDD) >> dc_current.txt
alter Va0 = 0.0
alter Va1 = 0.0
alter Va2 = 0.0
alter Va3 = 0.0
alter Vb0 = 1.8
alter Vb1 = 0.0
alter Vb2 = 1.8
alter Vb3 = 0.0
op
print i(VDD) >> dc_current.txt
alter Va0 = 0.0
alter Va1 = 0.0
alter Va2 = 0.0
alter Va3 = 0.0
alter Vb0 = 1.8
alter Vb1 = 0.0
alter Vb2 = 0.0
alter Vb3 = 1.8
op
print i(VDD) >> dc_current.txt
alter Va0 = 0.0
alter Va1 = 0.0
alter Va2 = 0.0
alter Va3 = 0.0
alter Vb0 = 1.8
alter Vb1 = 0.0
alter Vb2 = 0.0
alter Vb3 = 0.0
op
print i(VDD) >> dc_current.txt
alter Va0 = 0.0
alter Va1 = 0.0
alter Va2 = 0.0
alter Va3 = 0.0
alter Vb0 = 0.0
alter Vb1 = 1.8
alter Vb2 = 1.8
alter Vb3 = 1.8
op
print i(VDD) >> dc_current.txt
alter Va0 = 0.0
alter Va1 = 0.0
alter Va2 = 0.0
alter Va3 = 0.0
alter Vb0 = 0.0
alter Vb1 = 1.8
alter Vb2 = 1.8
alter Vb3 = 0.0
op
print i(VDD) >> dc_current.txt
alter Va0 = 0.0
alter Va1 = 0.0
alter Va2 = 0.0
alter Va3 = 0.0
alter Vb0 = 0.0
alter Vb1 = 1.8
alter Vb2 = 0.0
alter Vb3 = 1.8
op
print i(VDD) >> dc_current.txt
alter Va0 = 0.0
alter Va1 = 0.0
alter Va2 = 0.0
alter Va3 = 0.0
alter Vb0 = 0.0
alter Vb1 = 1.8
alter Vb2 = 0.0
alter Vb3 = 0.0
op
print i(VDD) >> dc_current.txt
alter Va0 = 0.0
alter Va1 = 0.0
alter Va2 = 0.0
alter Va3 = 0.0
alter Vb0 = 0.0
alter Vb1 = 0.0
alter Vb2 = 1.8
alter Vb3 = 1.8
op
print i(VDD) >> dc_current.txt
alter Va0 = 0.0
alter Va1 = 0.0
alter Va2 = 0.0
alter Va3 = 0.0
alter Vb0 = 0.0
alter Vb1 = 0.0
alter Vb2 = 1.8
alter Vb3 = 0.0
op
print i(VDD) >> dc_current.txt
alter Va0 = 0.0
alter Va1 = 0.0
alter Va2 = 0.0
alter Va3 = 0.0
alter Vb0 = 0.0
alter Vb1 = 0.0
alter Vb2 = 0.0
alter Vb3 = 1.8
op
print i(VDD) >> dc_current.txt
alter Va0 = 0.0
alter Va1 = 0.0
alter Va2 = 0.0
alter Va3 = 0.0
alter Vb0 = 0.0
alter Vb1 = 0.0
alter Vb2 = 0.0
alter Vb3 = 0.0
op
print i(VDD) >> dc_current.txt
quit
.endc
.end
