* block timing sum2_sch
.include ../../../spice/models/TSMC_180nm.txt
.options reltol=1e-4
VDD vdd gnd 1.8
* xor_aoi22_x0p8_1p25: dual-rail XOR, AOI22 with c-bar inverter
* GENERATED from part1/cells/library.py. Do not edit by hand.
.subckt xor_aoi22_x0p8_1p25 p pb c s vdd gnd
Ms0p1 cb c vdd vdd CMOSP W=2.2500e-06 L=1.8000e-07 AS=1.2150e-12 PS=5.5800e-06 AD=1.2150e-12 PD=5.5800e-06
Ms0n1 cb c gnd gnd CMOSN W=1.0800e-06 L=1.8000e-07 AS=5.8320e-13 PS=3.2400e-06 AD=5.8320e-13 PD=3.2400e-06
Ms1p1 s1xp1 p vdd vdd CMOSP W=2.8800e-06 L=1.8000e-07 AS=1.5552e-12 PS=6.8400e-06 AD=1.5552e-12 PD=6.8400e-06
Ms1p2 s1xp1 c vdd vdd CMOSP W=2.8800e-06 L=1.8000e-07 AS=1.5552e-12 PS=6.8400e-06 AD=1.5552e-12 PD=6.8400e-06
Ms1p3 s pb s1xp1 vdd CMOSP W=2.8800e-06 L=1.8000e-07 AS=1.5552e-12 PS=6.8400e-06 AD=1.5552e-12 PD=6.8400e-06
Ms1p4 s cb s1xp1 vdd CMOSP W=2.8800e-06 L=1.8000e-07 AS=1.5552e-12 PS=6.8400e-06 AD=1.5552e-12 PD=6.8400e-06
Ms1n1 s p s1xn1 gnd CMOSN W=1.4400e-06 L=1.8000e-07 AS=3.8880e-13 PS=3.4200e-06 AD=7.7760e-13 PD=3.9600e-06
Ms1n2 s1xn1 c gnd gnd CMOSN W=1.4400e-06 L=1.8000e-07 AS=7.7760e-13 PS=3.9600e-06 AD=3.8880e-13 PD=3.4200e-06
Ms1n3 s pb s1xn2 gnd CMOSN W=1.4400e-06 L=1.8000e-07 AS=3.8880e-13 PS=3.4200e-06 AD=7.7760e-13 PD=3.9600e-06
Ms1n4 s1xn2 cb gnd gnd CMOSN W=1.4400e-06 L=1.8000e-07 AS=7.7760e-13 PS=3.9600e-06 AD=3.8880e-13 PD=3.4200e-06
.ends xor_aoi22_x0p8_1p25
* sum2_b: tile sum2
* GENERATED from part1/cells/library.py. Do not edit by hand.
.subckt sum2_b c2 p2 p2b s2 vdd gnd
Xx2 p2 p2b c2 s2 vdd gnd xor_aoi22_x0p8_1p25
.ends sum2_b
.subckt tb_x1 a y vdd gnd
mp y a vdd vdd CMOSP W=1.8e-06 L=1.8e-07 AS=9.72e-13 PS=4.68e-06 AD=9.72e-13 PD=4.68e-06
mn y a gnd gnd CMOSN W=9.0e-07 L=1.8e-07 AS=4.86e-13 PS=2.88e-06 AD=4.86e-13 PD=2.88e-06
.ends
Vc2 src_c2 gnd PWL(
+ 0.00000e+00 1.800 2.00000e-09 1.800 2.02000e-09 0.000 4.00000e-09 0.000 4.02000e-09 1.800 8.00000e-09 1.800
+ 8.02000e-09 0.000 1.40000e-08 0.000 1.40200e-08 1.800 1.80000e-08 1.800
+ )
Xd_c2 src_c2 c2 vdd gnd tb_x1
Vp2 src_p2 gnd PWL(
+ 0.00000e+00 1.800 6.00000e-09 1.800 6.02000e-09 0.000 1.00000e-08 0.000 1.00200e-08 1.800 1.20000e-08 1.800
+ 1.20200e-08 0.000 1.60000e-08 0.000 1.60200e-08 1.800 1.80000e-08 1.800
+ )
Xd_p2 src_p2 p2 vdd gnd tb_x1
Vp2b src_p2b gnd PWL(
+ 0.00000e+00 0.000 6.00000e-09 0.000 6.02000e-09 1.800 1.00000e-08 1.800 1.00200e-08 0.000 1.20000e-08 0.000
+ 1.20200e-08 1.800 1.60000e-08 1.800 1.60200e-08 0.000 1.80000e-08 0.000
+ )
Xd_p2b src_p2b p2b vdd gnd tb_x1
Xl_s2 s2 lo_s2 vdd gnd tb_x1
X0 c2 p2 p2b s2 vdd gnd sum2_b
.tran 20p 1.80000e-08
.control
set wr_singlescale
set wr_vecnames
run
wrdata sum2_sch.txt v(c2) v(p2) v(p2b) v(s2)
quit
.endc
.end
