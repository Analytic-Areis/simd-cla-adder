* DC supply current of aoi21_x1
.include ../../../../spice/models/TSMC_180nm.txt
VDD vdd gnd 1.8
* aoi21_x1: NOT(a b + c)
* GENERATED from part1/cells/library.py. Do not edit by hand.
.subckt aoi21_x1 a b c y vdd gnd
Mp1 xp1 a vdd vdd CMOSP W=3.6000e-06 L=1.8000e-07 AS=1.9440e-12 PS=8.2800e-06 AD=1.9440e-12 PD=8.2800e-06
Mp2 xp1 b vdd vdd CMOSP W=3.6000e-06 L=1.8000e-07 AS=1.9440e-12 PS=8.2800e-06 AD=1.9440e-12 PD=8.2800e-06
Mp3 y c xp1 vdd CMOSP W=3.6000e-06 L=1.8000e-07 AS=1.9440e-12 PS=8.2800e-06 AD=1.9440e-12 PD=8.2800e-06
Mn1 y a xn1 gnd CMOSN W=1.8000e-06 L=1.8000e-07 AS=4.8600e-13 PS=4.1400e-06 AD=9.7200e-13 PD=4.6800e-06
Mn2 xn1 b gnd gnd CMOSN W=1.8000e-06 L=1.8000e-07 AS=9.7200e-13 PS=4.6800e-06 AD=4.8600e-13 PD=4.1400e-06
Mn3 y c gnd gnd CMOSN W=9.0000e-07 L=1.8000e-07 AS=4.8600e-13 PS=2.8800e-06 AD=4.8600e-13 PD=2.8800e-06
.ends aoi21_x1
.subckt tb_inv a y vdd gnd
mp y a vdd vdd CMOSP W=1.8e-06 L=1.8e-07 AS=9.72e-13 PS=4.68e-06 AD=9.72e-13 PD=4.68e-06
mn y a gnd gnd CMOSN W=9.0e-07 L=1.8e-07 AS=4.86e-13 PS=2.88e-06 AD=4.86e-13 PD=2.88e-06
.ends
Va src_a gnd 1.8
Xd_a src_a a vdd gnd tb_inv
Vb src_b gnd 1.8
Xd_b src_b b vdd gnd tb_inv
Vc src_c gnd 1.8
Xd_c src_c c vdd gnd tb_inv
Xl_y y lo_y vdd gnd tb_inv
X0 a b c y vdd gnd aoi21_x1
.control
alter Va = 1.8
alter Vb = 1.8
alter Vc = 1.8
op
print i(VDD) >> dc_current.txt
alter Va = 1.8
alter Vb = 1.8
alter Vc = 0.0
op
print i(VDD) >> dc_current.txt
alter Va = 1.8
alter Vb = 0.0
alter Vc = 1.8
op
print i(VDD) >> dc_current.txt
alter Va = 1.8
alter Vb = 0.0
alter Vc = 0.0
op
print i(VDD) >> dc_current.txt
alter Va = 0.0
alter Vb = 1.8
alter Vc = 1.8
op
print i(VDD) >> dc_current.txt
alter Va = 0.0
alter Vb = 1.8
alter Vc = 0.0
op
print i(VDD) >> dc_current.txt
alter Va = 0.0
alter Vb = 0.0
alter Vc = 1.8
op
print i(VDD) >> dc_current.txt
alter Va = 0.0
alter Vb = 0.0
alter Vc = 0.0
op
print i(VDD) >> dc_current.txt
quit
.endc
.end
