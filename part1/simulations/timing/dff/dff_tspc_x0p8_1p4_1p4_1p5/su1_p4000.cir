* dff_tspc_x0p8_1p4_1p4_1p5 timing
.include ../../../../spice/models/TSMC_180nm.txt
.options reltol=1e-4
VDD vdd gnd 1.8
* dff_tspc_x0p8_1p4_1p4_1p5: TSPC positive-edge flip-flop
* GENERATED from part1/cells/library.py. Do not edit by hand.
.subckt dff_tspc_x0p8_1p4_1p4_1p5 d clk q vdd gnd
Ms0p1 s0xp1 d vdd vdd CMOSP W=2.8800e-06 L=1.8000e-07 AS=1.5552e-12 PS=6.8400e-06 AD=7.7760e-13 PD=6.3000e-06
Ms0p2 a clk s0xp1 vdd CMOSP W=2.8800e-06 L=1.8000e-07 AS=7.7760e-13 PS=6.3000e-06 AD=1.5552e-12 PD=6.8400e-06
Ms0n1 a d gnd gnd CMOSN W=7.2000e-07 L=1.8000e-07 AS=3.8880e-13 PS=2.5200e-06 AD=3.8880e-13 PD=2.5200e-06
Ms1p1 b clk vdd vdd CMOSP W=2.5200e-06 L=1.8000e-07 AS=1.3608e-12 PS=6.1200e-06 AD=1.3608e-12 PD=6.1200e-06
Ms1n1 b a s1xn1 gnd CMOSN W=2.5200e-06 L=1.8000e-07 AS=6.8040e-13 PS=5.5800e-06 AD=1.3608e-12 PD=6.1200e-06
Ms1n2 s1xn1 clk gnd gnd CMOSN W=2.5200e-06 L=1.8000e-07 AS=1.3608e-12 PS=6.1200e-06 AD=6.8040e-13 PD=5.5800e-06
Ms2p1 qb b vdd vdd CMOSP W=2.5200e-06 L=1.8000e-07 AS=1.3608e-12 PS=6.1200e-06 AD=1.3608e-12 PD=6.1200e-06
Ms2n1 qb clk s2xn1 gnd CMOSN W=2.5200e-06 L=1.8000e-07 AS=6.8040e-13 PS=5.5800e-06 AD=1.3608e-12 PD=6.1200e-06
Ms2n2 s2xn1 b gnd gnd CMOSN W=2.5200e-06 L=1.8000e-07 AS=1.3608e-12 PS=6.1200e-06 AD=6.8040e-13 PD=5.5800e-06
Ms3p1 q qb vdd vdd CMOSP W=2.7000e-06 L=1.8000e-07 AS=1.4580e-12 PS=6.4800e-06 AD=1.4580e-12 PD=6.4800e-06
Ms3n1 q qb gnd gnd CMOSN W=1.3500e-06 L=1.8000e-07 AS=7.2900e-13 PS=3.7800e-06 AD=7.2900e-13 PD=3.7800e-06
.ends dff_tspc_x0p8_1p4_1p4_1p5
.subckt tb_x1 a y vdd gnd
mp y a vdd vdd CMOSP W=1.8e-06 L=1.8e-07 AS=9.72e-13 PS=4.68e-06 AD=9.72e-13 PD=4.68e-06
mn y a gnd gnd CMOSN W=9.0e-07 L=1.8e-07 AS=4.86e-13 PS=2.88e-06 AD=4.86e-13 PD=2.88e-06
.ends
.subckt tb_x4 a y vdd gnd
mp y a vdd vdd CMOSP W=7.2e-06 L=1.8e-07 AS=3.888e-12 PS=1.548e-05 AD=3.888e-12 PD=1.548e-05
mn y a gnd gnd CMOSN W=3.6e-06 L=1.8e-07 AS=1.944e-12 PS=8.28e-06 AD=1.944e-12 PD=8.28e-06
.ends
Vd sd gnd PWL(0.00000e+00 1.800 3.59000e-09 1.800 3.61000e-09 0.000 5.00000e-09 0.000)
Xd sd d vdd gnd tb_x1
Vc sc gnd PWL(0 1.8 1.0e-9 1.8 1.02e-9 0 1.99000e-09 0 2.01000e-09 1.8 3.0e-9 1.8 3.02e-9 0 3.99000e-09 0 4.01000e-09 1.8 5.00000e-09 1.8)
Xci sc clkn vdd gnd tb_x4
Xc clkn clk vdd gnd tb_x4
X0 d clk q vdd gnd dff_tspc_x0p8_1p4_1p4_1p5
Xl q ql vdd gnd tb_x1
Cload q gnd 25.0f
.tran 1p 5.00000e-09
.control
set wr_singlescale
set wr_vecnames
run
wrdata su1_p4000.txt v(clk) v(d) v(q)
quit
.endc
.end
