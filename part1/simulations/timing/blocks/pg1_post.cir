* block timing pg1_post
.include ../../../spice/models/TSMC_180nm.txt
.options reltol=1e-4
VDD vdd gnd 1.8
* NGSPICE file created from pg1_b.ext - technology: scmos

.subckt pg1_b a1 b1 g1b p1 p1b t1b vdd gnd
M1000 a_106_103# a1 vdd vdd CMOSP w=1.44u l=0.18u
+  ad=0.4536p pd=2.07u as=0.7776p ps=3.96u
M1001 a_43_103# a1 vdd vdd CMOSP w=7.02u l=0.18u
+  ad=2.2113p pd=7.65u as=3.7908p ps=15.12u
M1002 t1b b1 gnd Gnd CMOSN w=1.8u l=0.18u
+  ad=0.81p pd=4.5u as=0.567p ps=2.43u
M1003 vdd g1b p1b vdd CMOSP w=0.72u l=0.18u
+  ad=0.324p pd=2.34u as=0.3888p ps=2.07u
M1004 oai1_xn1 b1 p1b Gnd CMOSN w=0.72u l=0.18u
+  ad=0.2268p pd=1.35u as=0.2268p ps=1.35u
M1005 gnd g1b oai1_xn1 Gnd CMOSN w=0.72u l=0.18u
+  ad=0.324p pd=2.34u as=0.2268p ps=1.35u
M1006 a_70_27# a1 p1 Gnd CMOSN w=0.72u l=0.18u
+  ad=0.2268p pd=1.35u as=0.3888p ps=2.52u
M1007 vdd a1 g1b vdd CMOSP w=2.25u l=0.18u
+  ad=0.7047p pd=2.88u as=1.215p ps=5.58u
M1008 aoi1_xp1 b1 vdd vdd CMOSP w=1.44u l=0.18u
+  ad=0.4536p pd=2.07u as=0.4536p ps=2.07u
M1009 p1 t1b gnd Gnd CMOSN w=0.36u l=0.18u
+  ad=0.162p pd=1.62u as=0.1944p ps=1.35u
M1010 p1b b1 a_106_103# vdd CMOSP w=1.44u l=0.18u
+  ad=0.3888p pd=2.07u as=0.4536p ps=2.07u
M1011 a_16_10# a1 g1b Gnd CMOSN w=2.25u l=0.18u
+  ad=0.7047p pd=2.88u as=1.215p ps=5.58u
M1012 gnd b1 a_70_27# Gnd CMOSN w=0.72u l=0.18u
+  ad=0.1944p pd=1.35u as=0.2268p ps=1.35u
M1013 t1b b1 a_43_103# vdd CMOSP w=7.02u l=0.18u
+  ad=3.159p pd=14.94u as=2.2113p ps=7.65u
M1014 gnd b1 a_16_10# Gnd CMOSN w=2.25u l=0.18u
+  ad=1.0125p pd=5.4u as=0.7047p ps=2.88u
M1015 vdd a1 aoi1_xp1 vdd CMOSP w=1.44u l=0.18u
+  ad=0.4536p pd=2.07u as=0.7776p ps=3.96u
M1016 gnd a1 t1b Gnd CMOSN w=1.8u l=0.18u
+  ad=0.567p pd=2.43u as=0.972p ps=4.68u
M1017 p1b a1 oai1_xn1 Gnd CMOSN w=0.72u l=0.18u
+  ad=0.2268p pd=1.35u as=0.3888p ps=2.52u
M1018 g1b b1 vdd vdd CMOSP w=2.25u l=0.18u
+  ad=1.0125p pd=5.4u as=0.7047p ps=2.88u
M1019 p1 t1b aoi1_xp1 vdd CMOSP w=1.44u l=0.18u
+  ad=0.648p pd=3.78u as=0.4536p ps=2.07u
C0 vdd a1 0.09017f
C1 oai1_xn1 b1 0.21867f
C2 a_43_103# t1b 0.00221f
C3 aoi1_xp1 vdd 0.28719f
C4 t1b gnd 0.49659f
C5 a1 gnd 0.00371f
C6 b1 p1b 0.02342f
C7 g1b p1 0.1561f
C8 a_70_27# gnd 0
C9 vdd p1 0.14324f
C10 oai1_xn1 p1b 0.62747f
C11 a1 t1b 0.04892f
C12 b1 g1b 0.28588f
C13 vdd b1 0.0808f
C14 a_106_103# p1b 0
C15 oai1_xn1 g1b 0.15985f
C16 aoi1_xp1 t1b 0.23065f
C17 a_106_103# vdd 0
C18 aoi1_xp1 a1 0.01183f
C19 p1 gnd 0.03306f
C20 t1b p1 0.56955f
C21 g1b p1b 0.08267f
C22 b1 gnd 0.00783f
C23 vdd p1b 0.14385f
C24 oai1_xn1 gnd 0.06612f
C25 a1 p1 0.02977f
C26 b1 t1b 0.88659f
C27 a_70_27# p1 0
C28 a1 b1 1.92212f
C29 vdd g1b 0.66386f
C30 oai1_xn1 a1 0.02027f
C31 a_16_10# g1b 0
C32 aoi1_xp1 p1 0.4769f
C33 aoi1_xp1 b1 0.01183f
C34 a_43_103# vdd 0.00193f
C35 g1b gnd 0.04266f
C36 a1 p1b 0.00644f
C37 b1 p1 0.02787f
C38 g1b t1b 0.24926f
C39 oai1_xn1 p1 0.19757f
C40 a1 g1b 1.06204f
C41 a_16_10# gnd 0
C42 vdd t1b 0.07549f
.ends

.subckt pg1x_post a1 b1 g1b p1 p1b t1b vdd gnd
X0 a1 b1 g1b p1 p1b t1b vdd gnd pg1_b
.ends
.subckt tb_x1 a y vdd gnd
mp y a vdd vdd CMOSP W=1.8e-06 L=1.8e-07 AS=9.72e-13 PS=4.68e-06 AD=9.72e-13 PD=4.68e-06
mn y a gnd gnd CMOSN W=9.0e-07 L=1.8e-07 AS=4.86e-13 PS=2.88e-06 AD=4.86e-13 PD=2.88e-06
.ends
Va1 src_a1 gnd PWL(
+ 0.00000e+00 1.800 2.00000e-09 1.800 2.02000e-09 0.000 4.00000e-09 0.000 4.02000e-09 1.800 8.00000e-09 1.800
+ 8.02000e-09 0.000 1.40000e-08 0.000 1.40200e-08 1.800 1.80000e-08 1.800
+ )
Xd_a1 src_a1 a1 vdd gnd tb_x1
Vb1 src_b1 gnd PWL(
+ 0.00000e+00 1.800 6.00000e-09 1.800 6.02000e-09 0.000 1.00000e-08 0.000 1.00200e-08 1.800 1.20000e-08 1.800
+ 1.20200e-08 0.000 1.60000e-08 0.000 1.60200e-08 1.800 1.80000e-08 1.800
+ )
Xd_b1 src_b1 b1 vdd gnd tb_x1
Xl_g1b g1b lo_g1b vdd gnd tb_x1
Xl_p1 p1 lo_p1 vdd gnd tb_x1
Xl_p1b p1b lo_p1b vdd gnd tb_x1
Xl_t1b t1b lo_t1b vdd gnd tb_x1
X0 a1 b1 g1b p1 p1b t1b vdd gnd pg1x_post
.tran 20p 1.80000e-08
.control
set wr_singlescale
set wr_vecnames
run
wrdata pg1_post.txt v(a1) v(b1) v(g1b) v(p1) v(p1b) v(t1b)
quit
.endc
.end
