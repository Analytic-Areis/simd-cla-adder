* Truth table of c3_x1: inputs through unit inverters, outputs load 20L/10L inverter
.include ../../../../spice/models/TSMC_180nm.txt
.options reltol=1e-3
VDD vdd gnd 1.8
* c3_x1: C3 complex gate, stack 4
* GENERATED from part1/cells/library.py. Do not edit by hand.
.subckt c3_x1 g0b t0b g1b t1b g2b t2b c0b c3 vdd gnd
Mp1 c3 g2b vdd vdd CMOSP W=1.8000e-06 L=1.8000e-07 AS=9.7200e-13 PS=4.6800e-06 AD=9.7200e-13 PD=4.6800e-06
Mp2 xp1 t2b vdd vdd CMOSP W=7.2000e-06 L=1.8000e-07 AS=3.8880e-12 PS=1.5480e-05 AD=3.8880e-12 PD=1.5480e-05
Mp3 c3 g1b xp1 vdd CMOSP W=3.6000e-06 L=1.8000e-07 AS=1.9440e-12 PS=8.2800e-06 AD=1.9440e-12 PD=8.2800e-06
Mp4 xp2 t1b xp1 vdd CMOSP W=7.2000e-06 L=1.8000e-07 AS=3.8880e-12 PS=1.5480e-05 AD=3.8880e-12 PD=1.5480e-05
Mp5 c3 g0b xp2 vdd CMOSP W=5.4000e-06 L=1.8000e-07 AS=2.9160e-12 PS=1.1880e-05 AD=2.9160e-12 PD=1.1880e-05
Mp6 xp3 t0b xp2 vdd CMOSP W=7.2000e-06 L=1.8000e-07 AS=3.8880e-12 PS=1.5480e-05 AD=1.9440e-12 PD=1.4940e-05
Mp7 c3 c0b xp3 vdd CMOSP W=7.2000e-06 L=1.8000e-07 AS=1.9440e-12 PS=1.4940e-05 AD=3.8880e-12 PD=1.5480e-05
Mn1 c3 g2b xn1 gnd CMOSN W=3.6000e-06 L=1.8000e-07 AS=1.9440e-12 PS=8.2800e-06 AD=1.9440e-12 PD=8.2800e-06
Mn2 xn1 t2b gnd gnd CMOSN W=1.8000e-06 L=1.8000e-07 AS=9.7200e-13 PS=4.6800e-06 AD=9.7200e-13 PD=4.6800e-06
Mn3 xn1 g1b xn2 gnd CMOSN W=3.6000e-06 L=1.8000e-07 AS=1.9440e-12 PS=8.2800e-06 AD=1.9440e-12 PD=8.2800e-06
Mn4 xn2 t1b gnd gnd CMOSN W=2.7000e-06 L=1.8000e-07 AS=1.4580e-12 PS=6.4800e-06 AD=1.4580e-12 PD=6.4800e-06
Mn5 xn2 g0b xn3 gnd CMOSN W=3.6000e-06 L=1.8000e-07 AS=1.9440e-12 PS=8.2800e-06 AD=1.9440e-12 PD=8.2800e-06
Mn6 xn3 t0b gnd gnd CMOSN W=3.6000e-06 L=1.8000e-07 AS=1.9440e-12 PS=8.2800e-06 AD=1.9440e-12 PD=8.2800e-06
Mn7 xn3 c0b gnd gnd CMOSN W=3.6000e-06 L=1.8000e-07 AS=1.9440e-12 PS=8.2800e-06 AD=1.9440e-12 PD=8.2800e-06
.ends c3_x1
.subckt tb_inv a y vdd gnd
mp y a vdd vdd CMOSP W=1.8e-06 L=1.8e-07 AS=9.72e-13 PS=4.68e-06 AD=9.72e-13 PD=4.68e-06
mn y a gnd gnd CMOSN W=9.0e-07 L=1.8e-07 AS=4.86e-13 PS=2.88e-06 AD=4.86e-13 PD=2.88e-06
.ends
Vg0b src_g0b gnd PWL(
+ 0.00000e+00 1.800 6.40000e-08 1.800 6.40500e-08 0.000 1.28000e-07 0.000 1.28050e-07 1.800 1.30000e-07 1.800
+ 1.30050e-07 0.000 1.31000e-07 0.000 1.31050e-07 1.800 1.32000e-07 1.800 1.32050e-07 0.000 1.35000e-07 0.000
+ 1.35050e-07 1.800 1.38000e-07 1.800 1.38050e-07 0.000 1.44000e-07 0.000 1.44050e-07 1.800 1.45000e-07 1.800
+ 1.45050e-07 0.000 1.46000e-07 0.000 1.46050e-07 1.800 1.51000e-07 1.800 1.51050e-07 0.000 1.53000e-07 0.000
+ 1.53050e-07 1.800 1.54000e-07 1.800 1.54050e-07 0.000 1.56000e-07 0.000 1.56050e-07 1.800 1.60000e-07 1.800
+ 1.60050e-07 0.000 1.62000e-07 0.000 1.62050e-07 1.800 1.63000e-07 1.800 1.63050e-07 0.000 1.64000e-07 0.000
+ 1.64050e-07 1.800 1.68000e-07 1.800 1.68050e-07 0.000 1.69000e-07 0.000 1.69050e-07 1.800 1.73000e-07 1.800
+ 1.73050e-07 0.000 1.74000e-07 0.000 1.74050e-07 1.800 1.75000e-07 1.800 1.75050e-07 0.000 1.78000e-07 0.000
+ 1.78050e-07 1.800 1.79000e-07 1.800 1.79050e-07 0.000 1.80000e-07 0.000 1.80050e-07 1.800 1.81000e-07 1.800
+ 1.81050e-07 0.000 1.83000e-07 0.000 1.83050e-07 1.800 1.84000e-07 1.800 1.84050e-07 0.000 1.86000e-07 0.000
+ 1.86050e-07 1.800 1.87000e-07 1.800 1.87050e-07 0.000 1.89000e-07 0.000 1.89050e-07 1.800 1.92000e-07 1.800
+ 1.92050e-07 0.000 1.94000e-07 0.000 1.94050e-07 1.800 1.95000e-07 1.800 1.95050e-07 0.000 1.97000e-07 0.000
+ 1.97050e-07 1.800 1.98000e-07 1.800 1.98050e-07 0.000 1.99000e-07 0.000 1.99050e-07 1.800 2.00000e-07 1.800
+ 2.00050e-07 0.000 2.01000e-07 0.000 2.01050e-07 1.800 2.03000e-07 1.800 2.03050e-07 0.000 2.05000e-07 0.000
+ 2.05050e-07 1.800 2.06000e-07 1.800 2.06050e-07 0.000 2.09000e-07 0.000 2.09050e-07 1.800 2.11000e-07 1.800
+ 2.11050e-07 0.000 2.13000e-07 0.000 2.13050e-07 1.800 2.15000e-07 1.800 2.15050e-07 0.000 2.16000e-07 0.000
+ 2.16050e-07 1.800 2.17000e-07 1.800 2.17050e-07 0.000 2.20000e-07 0.000 2.20050e-07 1.800 2.21000e-07 1.800
+ 2.21050e-07 0.000 2.22000e-07 0.000 2.22050e-07 1.800 2.24000e-07 1.800 2.24050e-07 0.000 2.25000e-07 0.000
+ 2.25050e-07 1.800 2.26000e-07 1.800 2.26050e-07 0.000 2.30000e-07 0.000 2.30050e-07 1.800 2.31000e-07 1.800
+ 2.31050e-07 0.000 2.34000e-07 0.000 2.34050e-07 1.800 2.36000e-07 1.800 2.36050e-07 0.000 2.37000e-07 0.000
+ 2.37050e-07 1.800 2.41000e-07 1.800 2.41050e-07 0.000 2.42000e-07 0.000 2.42050e-07 1.800 2.43000e-07 1.800
+ 2.43050e-07 0.000 2.44000e-07 0.000 2.44050e-07 1.800 2.46000e-07 1.800 2.46050e-07 0.000 2.47000e-07 0.000
+ 2.47050e-07 1.800 2.51000e-07 1.800 2.51050e-07 0.000 2.55000e-07 0.000 2.55050e-07 1.800 2.56000e-07 1.800
+ )
Xd_g0b src_g0b g0b vdd gnd tb_inv
Vt0b src_t0b gnd PWL(
+ 0.00000e+00 1.800 3.20000e-08 1.800 3.20500e-08 0.000 6.40000e-08 0.000 6.40500e-08 1.800 9.60000e-08 1.800
+ 9.60500e-08 0.000 1.28000e-07 0.000 1.28050e-07 1.800 1.29000e-07 1.800 1.29050e-07 0.000 1.30000e-07 0.000
+ 1.30050e-07 1.800 1.31000e-07 1.800 1.31050e-07 0.000 1.32000e-07 0.000 1.32050e-07 1.800 1.33000e-07 1.800
+ 1.33050e-07 0.000 1.34000e-07 0.000 1.34050e-07 1.800 1.37000e-07 1.800 1.37050e-07 0.000 1.39000e-07 0.000
+ 1.39050e-07 1.800 1.41000e-07 1.800 1.41050e-07 0.000 1.42000e-07 0.000 1.42050e-07 1.800 1.44000e-07 1.800
+ 1.44050e-07 0.000 1.46000e-07 0.000 1.46050e-07 1.800 1.49000e-07 1.800 1.49050e-07 0.000 1.50000e-07 0.000
+ 1.50050e-07 1.800 1.52000e-07 1.800 1.52050e-07 0.000 1.55000e-07 0.000 1.55050e-07 1.800 1.58000e-07 1.800
+ 1.58050e-07 0.000 1.60000e-07 0.000 1.60050e-07 1.800 1.62000e-07 1.800 1.62050e-07 0.000 1.65000e-07 0.000
+ 1.65050e-07 1.800 1.67000e-07 1.800 1.67050e-07 0.000 1.69000e-07 0.000 1.69050e-07 1.800 1.70000e-07 1.800
+ 1.70050e-07 0.000 1.74000e-07 0.000 1.74050e-07 1.800 1.76000e-07 1.800 1.76050e-07 0.000 1.79000e-07 0.000
+ 1.79050e-07 1.800 1.81000e-07 1.800 1.81050e-07 0.000 1.83000e-07 0.000 1.83050e-07 1.800 1.84000e-07 1.800
+ 1.84050e-07 0.000 1.85000e-07 0.000 1.85050e-07 1.800 1.94000e-07 1.800 1.94050e-07 0.000 1.96000e-07 0.000
+ 1.96050e-07 1.800 1.98000e-07 1.800 1.98050e-07 0.000 2.03000e-07 0.000 2.03050e-07 1.800 2.05000e-07 1.800
+ 2.05050e-07 0.000 2.07000e-07 0.000 2.07050e-07 1.800 2.08000e-07 1.800 2.08050e-07 0.000 2.10000e-07 0.000
+ 2.10050e-07 1.800 2.13000e-07 1.800 2.13050e-07 0.000 2.14000e-07 0.000 2.14050e-07 1.800 2.15000e-07 1.800
+ 2.15050e-07 0.000 2.16000e-07 0.000 2.16050e-07 1.800 2.18000e-07 1.800 2.18050e-07 0.000 2.19000e-07 0.000
+ 2.19050e-07 1.800 2.21000e-07 1.800 2.21050e-07 0.000 2.23000e-07 0.000 2.23050e-07 1.800 2.27000e-07 1.800
+ 2.27050e-07 0.000 2.29000e-07 0.000 2.29050e-07 1.800 2.31000e-07 1.800 2.31050e-07 0.000 2.33000e-07 0.000
+ 2.33050e-07 1.800 2.34000e-07 1.800 2.34050e-07 0.000 2.37000e-07 0.000 2.37050e-07 1.800 2.38000e-07 1.800
+ 2.38050e-07 0.000 2.39000e-07 0.000 2.39050e-07 1.800 2.41000e-07 1.800 2.41050e-07 0.000 2.43000e-07 0.000
+ 2.43050e-07 1.800 2.44000e-07 1.800 2.44050e-07 0.000 2.48000e-07 0.000 2.48050e-07 1.800 2.49000e-07 1.800
+ 2.49050e-07 0.000 2.50000e-07 0.000 2.50050e-07 1.800 2.51000e-07 1.800 2.51050e-07 0.000 2.54000e-07 0.000
+ 2.54050e-07 1.800 2.55000e-07 1.800 2.55050e-07 0.000 2.56000e-07 0.000
+ )
Xd_t0b src_t0b t0b vdd gnd tb_inv
Vg1b src_g1b gnd PWL(
+ 0.00000e+00 1.800 1.60000e-08 1.800 1.60500e-08 0.000 3.20000e-08 0.000 3.20500e-08 1.800 4.80000e-08 1.800
+ 4.80500e-08 0.000 6.40000e-08 0.000 6.40500e-08 1.800 8.00000e-08 1.800 8.00500e-08 0.000 9.60000e-08 0.000
+ 9.60500e-08 1.800 1.12000e-07 1.800 1.12050e-07 0.000 1.28000e-07 0.000 1.28050e-07 1.800 1.32000e-07 1.800
+ 1.32050e-07 0.000 1.36000e-07 0.000 1.36050e-07 1.800 1.37000e-07 1.800 1.37050e-07 0.000 1.38000e-07 0.000
+ 1.38050e-07 1.800 1.40000e-07 1.800 1.40050e-07 0.000 1.44000e-07 0.000 1.44050e-07 1.800 1.45000e-07 1.800
+ 1.45050e-07 0.000 1.46000e-07 0.000 1.46050e-07 1.800 1.47000e-07 1.800 1.47050e-07 0.000 1.49000e-07 0.000
+ 1.49050e-07 1.800 1.50000e-07 1.800 1.50050e-07 0.000 1.51000e-07 0.000 1.51050e-07 1.800 1.53000e-07 1.800
+ 1.53050e-07 0.000 1.54000e-07 0.000 1.54050e-07 1.800 1.55000e-07 1.800 1.55050e-07 0.000 1.57000e-07 0.000
+ 1.57050e-07 1.800 1.59000e-07 1.800 1.59050e-07 0.000 1.61000e-07 0.000 1.61050e-07 1.800 1.62000e-07 1.800
+ 1.62050e-07 0.000 1.63000e-07 0.000 1.63050e-07 1.800 1.67000e-07 1.800 1.67050e-07 0.000 1.68000e-07 0.000
+ 1.68050e-07 1.800 1.76000e-07 1.800 1.76050e-07 0.000 1.78000e-07 0.000 1.78050e-07 1.800 1.79000e-07 1.800
+ 1.79050e-07 0.000 1.85000e-07 0.000 1.85050e-07 1.800 1.86000e-07 1.800 1.86050e-07 0.000 1.88000e-07 0.000
+ 1.88050e-07 1.800 1.89000e-07 1.800 1.89050e-07 0.000 1.93000e-07 0.000 1.93050e-07 1.800 1.95000e-07 1.800
+ 1.95050e-07 0.000 1.96000e-07 0.000 1.96050e-07 1.800 1.97000e-07 1.800 1.97050e-07 0.000 1.98000e-07 0.000
+ 1.98050e-07 1.800 1.99000e-07 1.800 1.99050e-07 0.000 2.00000e-07 0.000 2.00050e-07 1.800 2.02000e-07 1.800
+ 2.02050e-07 0.000 2.04000e-07 0.000 2.04050e-07 1.800 2.08000e-07 1.800 2.08050e-07 0.000 2.11000e-07 0.000
+ 2.11050e-07 1.800 2.12000e-07 1.800 2.12050e-07 0.000 2.16000e-07 0.000 2.16050e-07 1.800 2.18000e-07 1.800
+ 2.18050e-07 0.000 2.20000e-07 0.000 2.20050e-07 1.800 2.25000e-07 1.800 2.25050e-07 0.000 2.30000e-07 0.000
+ 2.30050e-07 1.800 2.32000e-07 1.800 2.32050e-07 0.000 2.33000e-07 0.000 2.33050e-07 1.800 2.34000e-07 1.800
+ 2.34050e-07 0.000 2.36000e-07 0.000 2.36050e-07 1.800 2.38000e-07 1.800 2.38050e-07 0.000 2.39000e-07 0.000
+ 2.39050e-07 1.800 2.40000e-07 1.800 2.40050e-07 0.000 2.41000e-07 0.000 2.41050e-07 1.800 2.42000e-07 1.800
+ 2.42050e-07 0.000 2.48000e-07 0.000 2.48050e-07 1.800 2.56000e-07 1.800
+ )
Xd_g1b src_g1b g1b vdd gnd tb_inv
Vt1b src_t1b gnd PWL(
+ 0.00000e+00 1.800 8.00000e-09 1.800 8.05000e-09 0.000 1.60000e-08 0.000 1.60500e-08 1.800 2.40000e-08 1.800
+ 2.40500e-08 0.000 3.20000e-08 0.000 3.20500e-08 1.800 4.00000e-08 1.800 4.00500e-08 0.000 4.80000e-08 0.000
+ 4.80500e-08 1.800 5.60000e-08 1.800 5.60500e-08 0.000 6.40000e-08 0.000 6.40500e-08 1.800 7.20000e-08 1.800
+ 7.20500e-08 0.000 8.00000e-08 0.000 8.00500e-08 1.800 8.80000e-08 1.800 8.80500e-08 0.000 9.60000e-08 0.000
+ 9.60500e-08 1.800 1.04000e-07 1.800 1.04050e-07 0.000 1.12000e-07 0.000 1.12050e-07 1.800 1.20000e-07 1.800
+ 1.20050e-07 0.000 1.30000e-07 0.000 1.30050e-07 1.800 1.32000e-07 1.800 1.32050e-07 0.000 1.33000e-07 0.000
+ 1.33050e-07 1.800 1.39000e-07 1.800 1.39050e-07 0.000 1.42000e-07 0.000 1.42050e-07 1.800 1.45000e-07 1.800
+ 1.45050e-07 0.000 1.46000e-07 0.000 1.46050e-07 1.800 1.49000e-07 1.800 1.49050e-07 0.000 1.50000e-07 0.000
+ 1.50050e-07 1.800 1.51000e-07 1.800 1.51050e-07 0.000 1.55000e-07 0.000 1.55050e-07 1.800 1.57000e-07 1.800
+ 1.57050e-07 0.000 1.58000e-07 0.000 1.58050e-07 1.800 1.60000e-07 1.800 1.60050e-07 0.000 1.62000e-07 0.000
+ 1.62050e-07 1.800 1.63000e-07 1.800 1.63050e-07 0.000 1.64000e-07 0.000 1.64050e-07 1.800 1.65000e-07 1.800
+ 1.65050e-07 0.000 1.66000e-07 0.000 1.66050e-07 1.800 1.67000e-07 1.800 1.67050e-07 0.000 1.68000e-07 0.000
+ 1.68050e-07 1.800 1.70000e-07 1.800 1.70050e-07 0.000 1.72000e-07 0.000 1.72050e-07 1.800 1.74000e-07 1.800
+ 1.74050e-07 0.000 1.75000e-07 0.000 1.75050e-07 1.800 1.77000e-07 1.800 1.77050e-07 0.000 1.82000e-07 0.000
+ 1.82050e-07 1.800 1.83000e-07 1.800 1.83050e-07 0.000 1.85000e-07 0.000 1.85050e-07 1.800 1.86000e-07 1.800
+ 1.86050e-07 0.000 1.87000e-07 0.000 1.87050e-07 1.800 1.91000e-07 1.800 1.91050e-07 0.000 1.92000e-07 0.000
+ 1.92050e-07 1.800 1.94000e-07 1.800 1.94050e-07 0.000 1.97000e-07 0.000 1.97050e-07 1.800 1.98000e-07 1.800
+ 1.98050e-07 0.000 1.99000e-07 0.000 1.99050e-07 1.800 2.02000e-07 1.800 2.02050e-07 0.000 2.03000e-07 0.000
+ 2.03050e-07 1.800 2.04000e-07 1.800 2.04050e-07 0.000 2.07000e-07 0.000 2.07050e-07 1.800 2.09000e-07 1.800
+ 2.09050e-07 0.000 2.11000e-07 0.000 2.11050e-07 1.800 2.12000e-07 1.800 2.12050e-07 0.000 2.13000e-07 0.000
+ 2.13050e-07 1.800 2.14000e-07 1.800 2.14050e-07 0.000 2.15000e-07 0.000 2.15050e-07 1.800 2.19000e-07 1.800
+ 2.19050e-07 0.000 2.20000e-07 0.000 2.20050e-07 1.800 2.21000e-07 1.800 2.21050e-07 0.000 2.28000e-07 0.000
+ 2.28050e-07 1.800 2.29000e-07 1.800 2.29050e-07 0.000 2.30000e-07 0.000 2.30050e-07 1.800 2.33000e-07 1.800
+ 2.33050e-07 0.000 2.34000e-07 0.000 2.34050e-07 1.800 2.36000e-07 1.800 2.36050e-07 0.000 2.37000e-07 0.000
+ 2.37050e-07 1.800 2.38000e-07 1.800 2.38050e-07 0.000 2.41000e-07 0.000 2.41050e-07 1.800 2.44000e-07 1.800
+ 2.44050e-07 0.000 2.49000e-07 0.000 2.49050e-07 1.800 2.50000e-07 1.800 2.50050e-07 0.000 2.51000e-07 0.000
+ 2.51050e-07 1.800 2.53000e-07 1.800 2.53050e-07 0.000 2.55000e-07 0.000 2.55050e-07 1.800 2.56000e-07 1.800
+ )
Xd_t1b src_t1b t1b vdd gnd tb_inv
Vg2b src_g2b gnd PWL(
+ 0.00000e+00 1.800 4.00000e-09 1.800 4.05000e-09 0.000 8.00000e-09 0.000 8.05000e-09 1.800 1.20000e-08 1.800
+ 1.20500e-08 0.000 1.60000e-08 0.000 1.60500e-08 1.800 2.00000e-08 1.800 2.00500e-08 0.000 2.40000e-08 0.000
+ 2.40500e-08 1.800 2.80000e-08 1.800 2.80500e-08 0.000 3.20000e-08 0.000 3.20500e-08 1.800 3.60000e-08 1.800
+ 3.60500e-08 0.000 4.00000e-08 0.000 4.00500e-08 1.800 4.40000e-08 1.800 4.40500e-08 0.000 4.80000e-08 0.000
+ 4.80500e-08 1.800 5.20000e-08 1.800 5.20500e-08 0.000 5.60000e-08 0.000 5.60500e-08 1.800 6.00000e-08 1.800
+ 6.00500e-08 0.000 6.40000e-08 0.000 6.40500e-08 1.800 6.80000e-08 1.800 6.80500e-08 0.000 7.20000e-08 0.000
+ 7.20500e-08 1.800 7.60000e-08 1.800 7.60500e-08 0.000 8.00000e-08 0.000 8.00500e-08 1.800 8.40000e-08 1.800
+ 8.40500e-08 0.000 8.80000e-08 0.000 8.80500e-08 1.800 9.20000e-08 1.800 9.20500e-08 0.000 9.60000e-08 0.000
+ 9.60500e-08 1.800 1.00000e-07 1.800 1.00050e-07 0.000 1.04000e-07 0.000 1.04050e-07 1.800 1.08000e-07 1.800
+ 1.08050e-07 0.000 1.12000e-07 0.000 1.12050e-07 1.800 1.16000e-07 1.800 1.16050e-07 0.000 1.20000e-07 0.000
+ 1.20050e-07 1.800 1.24000e-07 1.800 1.24050e-07 0.000 1.33000e-07 0.000 1.33050e-07 1.800 1.34000e-07 1.800
+ 1.34050e-07 0.000 1.35000e-07 0.000 1.35050e-07 1.800 1.36000e-07 1.800 1.36050e-07 0.000 1.37000e-07 0.000
+ 1.37050e-07 1.800 1.39000e-07 1.800 1.39050e-07 0.000 1.41000e-07 0.000 1.41050e-07 1.800 1.42000e-07 1.800
+ 1.42050e-07 0.000 1.43000e-07 0.000 1.43050e-07 1.800 1.44000e-07 1.800 1.44050e-07 0.000 1.47000e-07 0.000
+ 1.47050e-07 1.800 1.48000e-07 1.800 1.48050e-07 0.000 1.49000e-07 0.000 1.49050e-07 1.800 1.50000e-07 1.800
+ 1.50050e-07 0.000 1.52000e-07 0.000 1.52050e-07 1.800 1.53000e-07 1.800 1.53050e-07 0.000 1.57000e-07 0.000
+ 1.57050e-07 1.800 1.58000e-07 1.800 1.58050e-07 0.000 1.60000e-07 0.000 1.60050e-07 1.800 1.66000e-07 1.800
+ 1.66050e-07 0.000 1.67000e-07 0.000 1.67050e-07 1.800 1.69000e-07 1.800 1.69050e-07 0.000 1.71000e-07 0.000
+ 1.71050e-07 1.800 1.73000e-07 1.800 1.73050e-07 0.000 1.74000e-07 0.000 1.74050e-07 1.800 1.77000e-07 1.800
+ 1.77050e-07 0.000 1.79000e-07 0.000 1.79050e-07 1.800 1.80000e-07 1.800 1.80050e-07 0.000 1.83000e-07 0.000
+ 1.83050e-07 1.800 1.86000e-07 1.800 1.86050e-07 0.000 1.87000e-07 0.000 1.87050e-07 1.800 1.88000e-07 1.800
+ 1.88050e-07 0.000 1.89000e-07 0.000 1.89050e-07 1.800 1.92000e-07 1.800 1.92050e-07 0.000 1.93000e-07 0.000
+ 1.93050e-07 1.800 1.97000e-07 1.800 1.97050e-07 0.000 2.02000e-07 0.000 2.02050e-07 1.800 2.04000e-07 1.800
+ 2.04050e-07 0.000 2.06000e-07 0.000 2.06050e-07 1.800 2.07000e-07 1.800 2.07050e-07 0.000 2.09000e-07 0.000
+ 2.09050e-07 1.800 2.10000e-07 1.800 2.10050e-07 0.000 2.11000e-07 0.000 2.11050e-07 1.800 2.13000e-07 1.800
+ 2.13050e-07 0.000 2.14000e-07 0.000 2.14050e-07 1.800 2.17000e-07 1.800 2.17050e-07 0.000 2.18000e-07 0.000
+ 2.18050e-07 1.800 2.19000e-07 1.800 2.19050e-07 0.000 2.20000e-07 0.000 2.20050e-07 1.800 2.21000e-07 1.800
+ 2.21050e-07 0.000 2.22000e-07 0.000 2.22050e-07 1.800 2.23000e-07 1.800 2.23050e-07 0.000 2.24000e-07 0.000
+ 2.24050e-07 1.800 2.25000e-07 1.800 2.25050e-07 0.000 2.29000e-07 0.000 2.29050e-07 1.800 2.32000e-07 1.800
+ 2.32050e-07 0.000 2.35000e-07 0.000 2.35050e-07 1.800 2.38000e-07 1.800 2.38050e-07 0.000 2.40000e-07 0.000
+ 2.40050e-07 1.800 2.41000e-07 1.800 2.41050e-07 0.000 2.42000e-07 0.000 2.42050e-07 1.800 2.44000e-07 1.800
+ 2.44050e-07 0.000 2.45000e-07 0.000 2.45050e-07 1.800 2.47000e-07 1.800 2.47050e-07 0.000 2.49000e-07 0.000
+ 2.49050e-07 1.800 2.52000e-07 1.800 2.52050e-07 0.000 2.54000e-07 0.000 2.54050e-07 1.800 2.56000e-07 1.800
+ )
Xd_g2b src_g2b g2b vdd gnd tb_inv
Vt2b src_t2b gnd PWL(
+ 0.00000e+00 1.800 2.00000e-09 1.800 2.05000e-09 0.000 4.00000e-09 0.000 4.05000e-09 1.800 6.00000e-09 1.800
+ 6.05000e-09 0.000 8.00000e-09 0.000 8.05000e-09 1.800 1.00000e-08 1.800 1.00500e-08 0.000 1.20000e-08 0.000
+ 1.20500e-08 1.800 1.40000e-08 1.800 1.40500e-08 0.000 1.60000e-08 0.000 1.60500e-08 1.800 1.80000e-08 1.800
+ 1.80500e-08 0.000 2.00000e-08 0.000 2.00500e-08 1.800 2.20000e-08 1.800 2.20500e-08 0.000 2.40000e-08 0.000
+ 2.40500e-08 1.800 2.60000e-08 1.800 2.60500e-08 0.000 2.80000e-08 0.000 2.80500e-08 1.800 3.00000e-08 1.800
+ 3.00500e-08 0.000 3.20000e-08 0.000 3.20500e-08 1.800 3.40000e-08 1.800 3.40500e-08 0.000 3.60000e-08 0.000
+ 3.60500e-08 1.800 3.80000e-08 1.800 3.80500e-08 0.000 4.00000e-08 0.000 4.00500e-08 1.800 4.20000e-08 1.800
+ 4.20500e-08 0.000 4.40000e-08 0.000 4.40500e-08 1.800 4.60000e-08 1.800 4.60500e-08 0.000 4.80000e-08 0.000
+ 4.80500e-08 1.800 5.00000e-08 1.800 5.00500e-08 0.000 5.20000e-08 0.000 5.20500e-08 1.800 5.40000e-08 1.800
+ 5.40500e-08 0.000 5.60000e-08 0.000 5.60500e-08 1.800 5.80000e-08 1.800 5.80500e-08 0.000 6.00000e-08 0.000
+ 6.00500e-08 1.800 6.20000e-08 1.800 6.20500e-08 0.000 6.40000e-08 0.000 6.40500e-08 1.800 6.60000e-08 1.800
+ 6.60500e-08 0.000 6.80000e-08 0.000 6.80500e-08 1.800 7.00000e-08 1.800 7.00500e-08 0.000 7.20000e-08 0.000
+ 7.20500e-08 1.800 7.40000e-08 1.800 7.40500e-08 0.000 7.60000e-08 0.000 7.60500e-08 1.800 7.80000e-08 1.800
+ 7.80500e-08 0.000 8.00000e-08 0.000 8.00500e-08 1.800 8.20000e-08 1.800 8.20500e-08 0.000 8.40000e-08 0.000
+ 8.40500e-08 1.800 8.60000e-08 1.800 8.60500e-08 0.000 8.80000e-08 0.000 8.80500e-08 1.800 9.00000e-08 1.800
+ 9.00500e-08 0.000 9.20000e-08 0.000 9.20500e-08 1.800 9.40000e-08 1.800 9.40500e-08 0.000 9.60000e-08 0.000
+ 9.60500e-08 1.800 9.80000e-08 1.800 9.80500e-08 0.000 1.00000e-07 0.000 1.00050e-07 1.800 1.02000e-07 1.800
+ 1.02050e-07 0.000 1.04000e-07 0.000 1.04050e-07 1.800 1.06000e-07 1.800 1.06050e-07 0.000 1.08000e-07 0.000
+ 1.08050e-07 1.800 1.10000e-07 1.800 1.10050e-07 0.000 1.12000e-07 0.000 1.12050e-07 1.800 1.14000e-07 1.800
+ 1.14050e-07 0.000 1.16000e-07 0.000 1.16050e-07 1.800 1.18000e-07 1.800 1.18050e-07 0.000 1.20000e-07 0.000
+ 1.20050e-07 1.800 1.22000e-07 1.800 1.22050e-07 0.000 1.24000e-07 0.000 1.24050e-07 1.800 1.26000e-07 1.800
+ 1.26050e-07 0.000 1.31000e-07 0.000 1.31050e-07 1.800 1.32000e-07 1.800 1.32050e-07 0.000 1.33000e-07 0.000
+ 1.33050e-07 1.800 1.37000e-07 1.800 1.37050e-07 0.000 1.39000e-07 0.000 1.39050e-07 1.800 1.40000e-07 1.800
+ 1.40050e-07 0.000 1.43000e-07 0.000 1.43050e-07 1.800 1.44000e-07 1.800 1.44050e-07 0.000 1.45000e-07 0.000
+ 1.45050e-07 1.800 1.46000e-07 1.800 1.46050e-07 0.000 1.47000e-07 0.000 1.47050e-07 1.800 1.51000e-07 1.800
+ 1.51050e-07 0.000 1.52000e-07 0.000 1.52050e-07 1.800 1.54000e-07 1.800 1.54050e-07 0.000 1.57000e-07 0.000
+ 1.57050e-07 1.800 1.58000e-07 1.800 1.58050e-07 0.000 1.59000e-07 0.000 1.59050e-07 1.800 1.61000e-07 1.800
+ 1.61050e-07 0.000 1.64000e-07 0.000 1.64050e-07 1.800 1.65000e-07 1.800 1.65050e-07 0.000 1.68000e-07 0.000
+ 1.68050e-07 1.800 1.71000e-07 1.800 1.71050e-07 0.000 1.73000e-07 0.000 1.73050e-07 1.800 1.74000e-07 1.800
+ 1.74050e-07 0.000 1.76000e-07 0.000 1.76050e-07 1.800 1.78000e-07 1.800 1.78050e-07 0.000 1.82000e-07 0.000
+ 1.82050e-07 1.800 1.86000e-07 1.800 1.86050e-07 0.000 1.87000e-07 0.000 1.87050e-07 1.800 1.89000e-07 1.800
+ 1.89050e-07 0.000 1.91000e-07 0.000 1.91050e-07 1.800 1.94000e-07 1.800 1.94050e-07 0.000 1.95000e-07 0.000
+ 1.95050e-07 1.800 1.97000e-07 1.800 1.97050e-07 0.000 1.99000e-07 0.000 1.99050e-07 1.800 2.00000e-07 1.800
+ 2.00050e-07 0.000 2.01000e-07 0.000 2.01050e-07 1.800 2.02000e-07 1.800 2.02050e-07 0.000 2.05000e-07 0.000
+ 2.05050e-07 1.800 2.07000e-07 1.800 2.07050e-07 0.000 2.09000e-07 0.000 2.09050e-07 1.800 2.11000e-07 1.800
+ 2.11050e-07 0.000 2.16000e-07 0.000 2.16050e-07 1.800 2.18000e-07 1.800 2.18050e-07 0.000 2.19000e-07 0.000
+ 2.19050e-07 1.800 2.20000e-07 1.800 2.20050e-07 0.000 2.21000e-07 0.000 2.21050e-07 1.800 2.24000e-07 1.800
+ 2.24050e-07 0.000 2.25000e-07 0.000 2.25050e-07 1.800 2.27000e-07 1.800 2.27050e-07 0.000 2.28000e-07 0.000
+ 2.28050e-07 1.800 2.31000e-07 1.800 2.31050e-07 0.000 2.33000e-07 0.000 2.33050e-07 1.800 2.34000e-07 1.800
+ 2.34050e-07 0.000 2.35000e-07 0.000 2.35050e-07 1.800 2.36000e-07 1.800 2.36050e-07 0.000 2.39000e-07 0.000
+ 2.39050e-07 1.800 2.40000e-07 1.800 2.40050e-07 0.000 2.41000e-07 0.000 2.41050e-07 1.800 2.43000e-07 1.800
+ 2.43050e-07 0.000 2.44000e-07 0.000 2.44050e-07 1.800 2.46000e-07 1.800 2.46050e-07 0.000 2.49000e-07 0.000
+ 2.49050e-07 1.800 2.52000e-07 1.800 2.52050e-07 0.000 2.53000e-07 0.000 2.53050e-07 1.800 2.55000e-07 1.800
+ 2.55050e-07 0.000 2.56000e-07 0.000
+ )
Xd_t2b src_t2b t2b vdd gnd tb_inv
Vc0b src_c0b gnd PWL(
+ 0.00000e+00 1.800 1.00000e-09 1.800 1.05000e-09 0.000 2.00000e-09 0.000 2.05000e-09 1.800 3.00000e-09 1.800
+ 3.05000e-09 0.000 4.00000e-09 0.000 4.05000e-09 1.800 5.00000e-09 1.800 5.05000e-09 0.000 6.00000e-09 0.000
+ 6.05000e-09 1.800 7.00000e-09 1.800 7.05000e-09 0.000 8.00000e-09 0.000 8.05000e-09 1.800 9.00000e-09 1.800
+ 9.05000e-09 0.000 1.00000e-08 0.000 1.00500e-08 1.800 1.10000e-08 1.800 1.10500e-08 0.000 1.20000e-08 0.000
+ 1.20500e-08 1.800 1.30000e-08 1.800 1.30500e-08 0.000 1.40000e-08 0.000 1.40500e-08 1.800 1.50000e-08 1.800
+ 1.50500e-08 0.000 1.60000e-08 0.000 1.60500e-08 1.800 1.70000e-08 1.800 1.70500e-08 0.000 1.80000e-08 0.000
+ 1.80500e-08 1.800 1.90000e-08 1.800 1.90500e-08 0.000 2.00000e-08 0.000 2.00500e-08 1.800 2.10000e-08 1.800
+ 2.10500e-08 0.000 2.20000e-08 0.000 2.20500e-08 1.800 2.30000e-08 1.800 2.30500e-08 0.000 2.40000e-08 0.000
+ 2.40500e-08 1.800 2.50000e-08 1.800 2.50500e-08 0.000 2.60000e-08 0.000 2.60500e-08 1.800 2.70000e-08 1.800
+ 2.70500e-08 0.000 2.80000e-08 0.000 2.80500e-08 1.800 2.90000e-08 1.800 2.90500e-08 0.000 3.00000e-08 0.000
+ 3.00500e-08 1.800 3.10000e-08 1.800 3.10500e-08 0.000 3.20000e-08 0.000 3.20500e-08 1.800 3.30000e-08 1.800
+ 3.30500e-08 0.000 3.40000e-08 0.000 3.40500e-08 1.800 3.50000e-08 1.800 3.50500e-08 0.000 3.60000e-08 0.000
+ 3.60500e-08 1.800 3.70000e-08 1.800 3.70500e-08 0.000 3.80000e-08 0.000 3.80500e-08 1.800 3.90000e-08 1.800
+ 3.90500e-08 0.000 4.00000e-08 0.000 4.00500e-08 1.800 4.10000e-08 1.800 4.10500e-08 0.000 4.20000e-08 0.000
+ 4.20500e-08 1.800 4.30000e-08 1.800 4.30500e-08 0.000 4.40000e-08 0.000 4.40500e-08 1.800 4.50000e-08 1.800
+ 4.50500e-08 0.000 4.60000e-08 0.000 4.60500e-08 1.800 4.70000e-08 1.800 4.70500e-08 0.000 4.80000e-08 0.000
+ 4.80500e-08 1.800 4.90000e-08 1.800 4.90500e-08 0.000 5.00000e-08 0.000 5.00500e-08 1.800 5.10000e-08 1.800
+ 5.10500e-08 0.000 5.20000e-08 0.000 5.20500e-08 1.800 5.30000e-08 1.800 5.30500e-08 0.000 5.40000e-08 0.000
+ 5.40500e-08 1.800 5.50000e-08 1.800 5.50500e-08 0.000 5.60000e-08 0.000 5.60500e-08 1.800 5.70000e-08 1.800
+ 5.70500e-08 0.000 5.80000e-08 0.000 5.80500e-08 1.800 5.90000e-08 1.800 5.90500e-08 0.000 6.00000e-08 0.000
+ 6.00500e-08 1.800 6.10000e-08 1.800 6.10500e-08 0.000 6.20000e-08 0.000 6.20500e-08 1.800 6.30000e-08 1.800
+ 6.30500e-08 0.000 6.40000e-08 0.000 6.40500e-08 1.800 6.50000e-08 1.800 6.50500e-08 0.000 6.60000e-08 0.000
+ 6.60500e-08 1.800 6.70000e-08 1.800 6.70500e-08 0.000 6.80000e-08 0.000 6.80500e-08 1.800 6.90000e-08 1.800
+ 6.90500e-08 0.000 7.00000e-08 0.000 7.00500e-08 1.800 7.10000e-08 1.800 7.10500e-08 0.000 7.20000e-08 0.000
+ 7.20500e-08 1.800 7.30000e-08 1.800 7.30500e-08 0.000 7.40000e-08 0.000 7.40500e-08 1.800 7.50000e-08 1.800
+ 7.50500e-08 0.000 7.60000e-08 0.000 7.60500e-08 1.800 7.70000e-08 1.800 7.70500e-08 0.000 7.80000e-08 0.000
+ 7.80500e-08 1.800 7.90000e-08 1.800 7.90500e-08 0.000 8.00000e-08 0.000 8.00500e-08 1.800 8.10000e-08 1.800
+ 8.10500e-08 0.000 8.20000e-08 0.000 8.20500e-08 1.800 8.30000e-08 1.800 8.30500e-08 0.000 8.40000e-08 0.000
+ 8.40500e-08 1.800 8.50000e-08 1.800 8.50500e-08 0.000 8.60000e-08 0.000 8.60500e-08 1.800 8.70000e-08 1.800
+ 8.70500e-08 0.000 8.80000e-08 0.000 8.80500e-08 1.800 8.90000e-08 1.800 8.90500e-08 0.000 9.00000e-08 0.000
+ 9.00500e-08 1.800 9.10000e-08 1.800 9.10500e-08 0.000 9.20000e-08 0.000 9.20500e-08 1.800 9.30000e-08 1.800
+ 9.30500e-08 0.000 9.40000e-08 0.000 9.40500e-08 1.800 9.50000e-08 1.800 9.50500e-08 0.000 9.60000e-08 0.000
+ 9.60500e-08 1.800 9.70000e-08 1.800 9.70500e-08 0.000 9.80000e-08 0.000 9.80500e-08 1.800 9.90000e-08 1.800
+ 9.90500e-08 0.000 1.00000e-07 0.000 1.00050e-07 1.800 1.01000e-07 1.800 1.01050e-07 0.000 1.02000e-07 0.000
+ 1.02050e-07 1.800 1.03000e-07 1.800 1.03050e-07 0.000 1.04000e-07 0.000 1.04050e-07 1.800 1.05000e-07 1.800
+ 1.05050e-07 0.000 1.06000e-07 0.000 1.06050e-07 1.800 1.07000e-07 1.800 1.07050e-07 0.000 1.08000e-07 0.000
+ 1.08050e-07 1.800 1.09000e-07 1.800 1.09050e-07 0.000 1.10000e-07 0.000 1.10050e-07 1.800 1.11000e-07 1.800
+ 1.11050e-07 0.000 1.12000e-07 0.000 1.12050e-07 1.800 1.13000e-07 1.800 1.13050e-07 0.000 1.14000e-07 0.000
+ 1.14050e-07 1.800 1.15000e-07 1.800 1.15050e-07 0.000 1.16000e-07 0.000 1.16050e-07 1.800 1.17000e-07 1.800
+ 1.17050e-07 0.000 1.18000e-07 0.000 1.18050e-07 1.800 1.19000e-07 1.800 1.19050e-07 0.000 1.20000e-07 0.000
+ 1.20050e-07 1.800 1.21000e-07 1.800 1.21050e-07 0.000 1.22000e-07 0.000 1.22050e-07 1.800 1.23000e-07 1.800
+ 1.23050e-07 0.000 1.24000e-07 0.000 1.24050e-07 1.800 1.25000e-07 1.800 1.25050e-07 0.000 1.26000e-07 0.000
+ 1.26050e-07 1.800 1.27000e-07 1.800 1.27050e-07 0.000 1.28000e-07 0.000 1.28050e-07 1.800 1.30000e-07 1.800
+ 1.30050e-07 0.000 1.31000e-07 0.000 1.31050e-07 1.800 1.32000e-07 1.800 1.32050e-07 0.000 1.34000e-07 0.000
+ 1.34050e-07 1.800 1.35000e-07 1.800 1.35050e-07 0.000 1.36000e-07 0.000 1.36050e-07 1.800 1.37000e-07 1.800
+ 1.37050e-07 0.000 1.39000e-07 0.000 1.39050e-07 1.800 1.42000e-07 1.800 1.42050e-07 0.000 1.43000e-07 0.000
+ 1.43050e-07 1.800 1.46000e-07 1.800 1.46050e-07 0.000 1.47000e-07 0.000 1.47050e-07 1.800 1.48000e-07 1.800
+ 1.48050e-07 0.000 1.50000e-07 0.000 1.50050e-07 1.800 1.51000e-07 1.800 1.51050e-07 0.000 1.54000e-07 0.000
+ 1.54050e-07 1.800 1.57000e-07 1.800 1.57050e-07 0.000 1.59000e-07 0.000 1.59050e-07 1.800 1.63000e-07 1.800
+ 1.63050e-07 0.000 1.65000e-07 0.000 1.65050e-07 1.800 1.67000e-07 1.800 1.67050e-07 0.000 1.68000e-07 0.000
+ 1.68050e-07 1.800 1.69000e-07 1.800 1.69050e-07 0.000 1.75000e-07 0.000 1.75050e-07 1.800 1.77000e-07 1.800
+ 1.77050e-07 0.000 1.79000e-07 0.000 1.79050e-07 1.800 1.83000e-07 1.800 1.83050e-07 0.000 1.88000e-07 0.000
+ 1.88050e-07 1.800 1.90000e-07 1.800 1.90050e-07 0.000 1.91000e-07 0.000 1.91050e-07 1.800 1.92000e-07 1.800
+ 1.92050e-07 0.000 1.93000e-07 0.000 1.93050e-07 1.800 1.96000e-07 1.800 1.96050e-07 0.000 2.02000e-07 0.000
+ 2.02050e-07 1.800 2.08000e-07 1.800 2.08050e-07 0.000 2.09000e-07 0.000 2.09050e-07 1.800 2.11000e-07 1.800
+ 2.11050e-07 0.000 2.13000e-07 0.000 2.13050e-07 1.800 2.14000e-07 1.800 2.14050e-07 0.000 2.15000e-07 0.000
+ 2.15050e-07 1.800 2.16000e-07 1.800 2.16050e-07 0.000 2.20000e-07 0.000 2.20050e-07 1.800 2.21000e-07 1.800
+ 2.21050e-07 0.000 2.22000e-07 0.000 2.22050e-07 1.800 2.23000e-07 1.800 2.23050e-07 0.000 2.26000e-07 0.000
+ 2.26050e-07 1.800 2.27000e-07 1.800 2.27050e-07 0.000 2.30000e-07 0.000 2.30050e-07 1.800 2.33000e-07 1.800
+ 2.33050e-07 0.000 2.36000e-07 0.000 2.36050e-07 1.800 2.37000e-07 1.800 2.37050e-07 0.000 2.38000e-07 0.000
+ 2.38050e-07 1.800 2.43000e-07 1.800 2.43050e-07 0.000 2.44000e-07 0.000 2.44050e-07 1.800 2.45000e-07 1.800
+ 2.45050e-07 0.000 2.49000e-07 0.000 2.49050e-07 1.800 2.51000e-07 1.800 2.51050e-07 0.000 2.52000e-07 0.000
+ 2.52050e-07 1.800 2.56000e-07 1.800
+ )
Xd_c0b src_c0b c0b vdd gnd tb_inv
Xl_c3 c3 lo_c3 vdd gnd tb_inv
X0 g0b t0b g1b t1b g2b t2b c0b c3 vdd gnd c3_x1
.tran 200p 2.56000e-07
.control
set wr_singlescale
set wr_vecnames
run
set curplottitle=Bhargav-2025102061-1.3-c3_x1-function
wrdata wave.txt v(g0b) v(t0b) v(g1b) v(t1b) v(g2b) v(t2b) v(c0b) v(c3) i(VDD)
quit
.endc
.end
