* Truth table of c3b_mirror_x1: inputs through unit inverters, outputs load 20L/10L inverter
.include ../../../../spice/models/TSMC_180nm.txt
.options reltol=1e-3
VDD vdd gnd 1.8
* c3b_mirror_x1: C3-bar mirror gate, stack 2
* GENERATED from part1/cells/library.py. Do not edit by hand.
.subckt c3b_mirror_x1 a2 b2 c2 c3b vdd gnd
Mp1 xp1 b2 vdd vdd CMOSP W=3.6000e-06 L=1.8000e-07 AS=1.9440e-12 PS=8.2800e-06 AD=9.7200e-13 PD=7.7400e-06
Mp2 c3b a2 xp1 vdd CMOSP W=3.6000e-06 L=1.8000e-07 AS=9.7200e-13 PS=7.7400e-06 AD=1.9440e-12 PD=8.2800e-06
Mp3 xp2 a2 vdd vdd CMOSP W=3.6000e-06 L=1.8000e-07 AS=1.9440e-12 PS=8.2800e-06 AD=1.9440e-12 PD=8.2800e-06
Mp4 xp2 b2 vdd vdd CMOSP W=3.6000e-06 L=1.8000e-07 AS=1.9440e-12 PS=8.2800e-06 AD=1.9440e-12 PD=8.2800e-06
Mp5 c3b c2 xp2 vdd CMOSP W=3.6000e-06 L=1.8000e-07 AS=1.9440e-12 PS=8.2800e-06 AD=1.9440e-12 PD=8.2800e-06
Mn1 c3b a2 xn1 gnd CMOSN W=1.8000e-06 L=1.8000e-07 AS=4.8600e-13 PS=4.1400e-06 AD=9.7200e-13 PD=4.6800e-06
Mn2 xn1 b2 gnd gnd CMOSN W=1.8000e-06 L=1.8000e-07 AS=9.7200e-13 PS=4.6800e-06 AD=4.8600e-13 PD=4.1400e-06
Mn3 c3b c2 xn2 gnd CMOSN W=1.8000e-06 L=1.8000e-07 AS=9.7200e-13 PS=4.6800e-06 AD=9.7200e-13 PD=4.6800e-06
Mn4 xn2 a2 gnd gnd CMOSN W=1.8000e-06 L=1.8000e-07 AS=9.7200e-13 PS=4.6800e-06 AD=9.7200e-13 PD=4.6800e-06
Mn5 xn2 b2 gnd gnd CMOSN W=1.8000e-06 L=1.8000e-07 AS=9.7200e-13 PS=4.6800e-06 AD=9.7200e-13 PD=4.6800e-06
.ends c3b_mirror_x1
.subckt tb_inv a y vdd gnd
mp y a vdd vdd CMOSP W=1.8e-06 L=1.8e-07 AS=9.72e-13 PS=4.68e-06 AD=9.72e-13 PD=4.68e-06
mn y a gnd gnd CMOSN W=9.0e-07 L=1.8e-07 AS=4.86e-13 PS=2.88e-06 AD=4.86e-13 PD=2.88e-06
.ends
Va2 src_a2 gnd PWL(
+ 0.00000e+00 1.800 4.00000e-09 1.800 4.05000e-09 0.000 8.00000e-09 0.000 8.05000e-09 1.800 9.00000e-09 1.800
+ 9.05000e-09 0.000 1.00000e-08 0.000 1.00500e-08 1.800 1.10000e-08 1.800 1.10500e-08 0.000 1.30000e-08 0.000
+ 1.30500e-08 1.800 1.40000e-08 1.800 1.40500e-08 0.000 1.50000e-08 0.000 1.50500e-08 1.800 1.60000e-08 1.800
+ )
Xd_a2 src_a2 a2 vdd gnd tb_inv
Vb2 src_b2 gnd PWL(
+ 0.00000e+00 1.800 2.00000e-09 1.800 2.05000e-09 0.000 4.00000e-09 0.000 4.05000e-09 1.800 6.00000e-09 1.800
+ 6.05000e-09 0.000 1.00000e-08 0.000 1.00500e-08 1.800 1.20000e-08 1.800 1.20500e-08 0.000 1.30000e-08 0.000
+ 1.30500e-08 1.800 1.50000e-08 1.800 1.50500e-08 0.000 1.60000e-08 0.000
+ )
Xd_b2 src_b2 b2 vdd gnd tb_inv
Vc2 src_c2 gnd PWL(
+ 0.00000e+00 1.800 1.00000e-09 1.800 1.05000e-09 0.000 2.00000e-09 0.000 2.05000e-09 1.800 3.00000e-09 1.800
+ 3.05000e-09 0.000 4.00000e-09 0.000 4.05000e-09 1.800 5.00000e-09 1.800 5.05000e-09 0.000 6.00000e-09 0.000
+ 6.05000e-09 1.800 7.00000e-09 1.800 7.05000e-09 0.000 9.00000e-09 0.000 9.05000e-09 1.800 1.00000e-08 1.800
+ 1.00500e-08 0.000 1.30000e-08 0.000 1.30500e-08 1.800 1.60000e-08 1.800
+ )
Xd_c2 src_c2 c2 vdd gnd tb_inv
Xl_c3b c3b lo_c3b vdd gnd tb_inv
X0 a2 b2 c2 c3b vdd gnd c3b_mirror_x1
.tran 200p 1.60000e-08
.control
set wr_singlescale
set wr_vecnames
run
set curplottitle=Bhargav-2025102061-1.3-c3b_mirror_x1-function
wrdata wave.txt v(a2) v(b2) v(c2) v(c3b) i(VDD)
quit
.endc
.end
