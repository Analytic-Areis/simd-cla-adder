* Phase 0 check 2: generated inverter against flow check schematic
* Uses generator-produced subcircuits only.
.include ../../spice/models/TSMC_180nm.txt
.options reltol=1e-4
VDD vdd gnd 1.8
Vin in0 gnd PULSE(0 1.8 1n 20p 20p 2n 4n)
* idrv: inverter
* GENERATED from part1/cells/library.py. Do not edit by hand.
.subckt idrv a y vdd gnd
Mp1 y a vdd vdd CMOSP W=3.6000e-06 L=1.8000e-07 AS=1.9440e-12 PS=8.2800e-06 AD=1.9440e-12 PD=8.2800e-06
Mn1 y a gnd gnd CMOSN W=1.8000e-06 L=1.8000e-07 AS=9.7200e-13 PS=4.6800e-06 AD=9.7200e-13 PD=4.6800e-06
.ends idrv
* igate: inverter
* GENERATED from part1/cells/library.py. Do not edit by hand.
.subckt igate a y vdd gnd
Mp1 y a vdd vdd CMOSP W=1.8000e-06 L=1.8000e-07 AS=9.7200e-13 PS=4.6800e-06 AD=9.7200e-13 PD=4.6800e-06
Mn1 y a gnd gnd CMOSN W=9.0000e-07 L=1.8000e-07 AS=4.8600e-13 PS=2.8800e-06 AD=4.8600e-13 PD=2.8800e-06
.ends igate
XD in0 b vdd gnd idrv
XG b os vdd gnd igate
XL os l2 vdd gnd igate
.tran 0.5p 11n
.meas tran sch_tphl TRIG v(b) VAL=0.9 RISE=2 TARG v(os) VAL=0.9 FALL=2
.meas tran sch_tplh TRIG v(b) VAL=0.9 FALL=2 TARG v(os) VAL=0.9 RISE=2
.end
