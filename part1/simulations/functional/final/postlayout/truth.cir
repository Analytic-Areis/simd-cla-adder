* Truth table of final_post_post: inputs through unit inverters, outputs load 20L/10L inverter
.include ../../../../spice/models/TSMC_180nm.txt
.options reltol=1e-3
VDD vdd gnd 1.8
* NGSPICE file created from top_final_C4_aoi22_1.ext - technology: scmos

.subckt top_final_C4_aoi22_1 a0 a1 a2 a3 b0 b1 b2 b3 c0 c4 s0 s1 s2 s3 vdd gnd
M1000 pg2_0/a_106_103# a2 vdd vdd CMOSP w=2.88u l=0.18u
+  ad=0.9072p pd=3.51u as=1.5552p ps=6.84u
M1001 pg2_0/a_43_103# a2 vdd vdd CMOSP w=4.5u l=0.18u
+  ad=1.4175p pd=5.13u as=2.43p ps=10.08u
M1002 pg2_0/oai2_xn1 b2 pg2_0/p2b Gnd CMOSN w=1.44u l=0.18u
+  ad=0.4536p pd=2.07u as=0.4536p ps=2.07u
M1003 vdd pg2_0/g2b pg2_0/p2b vdd CMOSP w=1.44u l=0.18u
+  ad=0.648p pd=3.78u as=0.7776p ps=3.51u
M1004 pg2_0/t2b b2 gnd Gnd CMOSN w=1.08u l=0.18u
+  ad=0.486p pd=3.06u as=0.3402p ps=1.71u
M1005 gnd pg2_0/g2b pg2_0/oai2_xn1 Gnd CMOSN w=1.44u l=0.18u
+  ad=0.648p pd=3.78u as=0.4536p ps=2.07u
M1006 pg2_0/a_70_19# a2 pg2_0/p2 Gnd CMOSN w=1.44u l=0.18u
+  ad=0.4536p pd=2.07u as=0.7776p ps=3.96u
M1007 vdd a2 pg2_0/g2b vdd CMOSP w=2.25u l=0.18u
+  ad=0.7047p pd=2.88u as=1.215p ps=5.58u
M1008 pg2_0/aoi2_xp1 b2 vdd vdd CMOSP w=2.88u l=0.18u
+  ad=0.9072p pd=3.51u as=0.9072p ps=3.51u
M1009 pg2_0/p2b b2 pg2_0/a_106_103# vdd CMOSP w=2.88u l=0.18u
+  ad=0.7776p pd=3.51u as=0.9072p ps=3.51u
M1010 pg2_0/a_16_10# a2 pg2_0/g2b Gnd CMOSN w=2.25u l=0.18u
+  ad=0.7047p pd=2.88u as=1.215p ps=5.58u
M1011 gnd b2 pg2_0/a_70_19# Gnd CMOSN w=1.44u l=0.18u
+  ad=0.3888p pd=2.07u as=0.4536p ps=2.07u
M1012 pg2_0/t2b b2 pg2_0/a_43_103# vdd CMOSP w=4.5u l=0.18u
+  ad=2.025p pd=9.9u as=1.4175p ps=5.13u
M1013 gnd b2 pg2_0/a_16_10# Gnd CMOSN w=2.25u l=0.18u
+  ad=1.0125p pd=5.4u as=0.7047p ps=2.88u
M1014 vdd a2 pg2_0/aoi2_xp1 vdd CMOSP w=2.88u l=0.18u
+  ad=0.9072p pd=3.51u as=1.5552p ps=6.84u
M1015 pg2_0/p2 pg2_0/t2b gnd Gnd CMOSN w=0.72u l=0.18u
+  ad=0.324p pd=2.34u as=0.3888p ps=2.07u
M1016 gnd a2 pg2_0/t2b Gnd CMOSN w=1.08u l=0.18u
+  ad=0.3402p pd=1.71u as=0.5832p ps=3.24u
M1017 pg2_0/p2b a2 pg2_0/oai2_xn1 Gnd CMOSN w=1.44u l=0.18u
+  ad=0.4536p pd=2.07u as=0.7776p ps=3.96u
M1018 pg2_0/g2b b2 vdd vdd CMOSP w=2.25u l=0.18u
+  ad=1.0125p pd=5.4u as=0.7047p ps=2.88u
M1019 pg2_0/p2 pg2_0/t2b pg2_0/aoi2_xp1 vdd CMOSP w=2.88u l=0.18u
+  ad=1.296p pd=6.66u as=0.9072p ps=3.51u
M1020 sum2_0/a_34_19# pg2_0/p2b s2 Gnd CMOSN w=1.44u l=0.18u
+  ad=0.4536p pd=2.07u as=0.4536p ps=2.07u
M1021 sum2_0/x2_s1xp1 sum2_0/x2_cb s2 vdd CMOSP w=2.88u l=0.18u
+  ad=0.9072p pd=3.51u as=0.9072p ps=3.51u
M1022 sum2_0/x2_cb sum2_0/c2 gnd Gnd CMOSN w=1.08u l=0.18u
+  ad=0.486p pd=3.06u as=0.4212p ps=2.07u
M1023 gnd sum2_0/x2_cb sum2_0/a_34_19# Gnd CMOSN w=1.44u l=0.18u
+  ad=0.4212p pd=2.07u as=0.4536p ps=2.07u
M1024 vdd sum2_0/c2 sum2_0/x2_cb vdd CMOSP w=2.25u l=0.18u
+  ad=0.8748p pd=3.51u as=1.215p ps=5.58u
M1025 s2 pg2_0/p2b sum2_0/x2_s1xp1 vdd CMOSP w=2.88u l=0.18u
+  ad=0.9072p pd=3.51u as=0.9072p ps=3.51u
M1026 sum2_0/a_16_19# sum2_0/c2 gnd Gnd CMOSN w=1.44u l=0.18u
+  ad=0.4536p pd=2.07u as=0.7776p ps=3.96u
M1027 vdd sum2_0/c2 sum2_0/x2_s1xp1 vdd CMOSP w=2.88u l=0.18u
+  ad=1.296p pd=6.66u as=0.9072p ps=3.51u
M1028 s2 pg2_0/p2 sum2_0/a_16_19# Gnd CMOSN w=1.44u l=0.18u
+  ad=0.4536p pd=2.07u as=0.4536p ps=2.07u
M1029 sum2_0/x2_s1xp1 pg2_0/p2 vdd vdd CMOSP w=2.88u l=0.18u
+  ad=0.9072p pd=3.51u as=0.8748p ps=3.51u
M1030 carry_0/a_34_148# pg0_0/t0b vdd vdd CMOSP w=1.8u l=0.18u
+  ad=0.567p pd=2.43u as=0.972p ps=4.68u
M1031 gnd carry_0/t1_0 carry_0/a_277_10# Gnd CMOSN w=2.25u l=0.18u
+  ad=1.0125p pd=5.4u as=0.7047p ps=2.88u
M1032 carry_0/g32_xn1 pg2_0/g2b carry_0/g3_2 Gnd CMOSN w=1.44u l=0.18u
+  ad=0.4536p pd=2.07u as=0.4536p ps=2.07u
M1033 carry_0/t1_0 pg0_0/t0b carry_0/a_106_148# vdd CMOSP w=5.58u l=0.18u
+  ad=2.511p pd=12.06u as=1.7577p ps=6.21u
M1034 sum2_0/c2 carry_0/c0b carry_0/a_169_148# vdd CMOSP w=4.5u l=0.18u
+  ad=1.215p pd=5.13u as=1.4175p ps=5.13u
M1035 carry_0/g30_xp1 carry_0/g3_2 vdd vdd CMOSP w=1.44u l=0.18u
+  ad=0.4536p pd=2.07u as=0.7776p ps=3.96u
M1036 carry_0/a_466_148# carry_0/c0b vdd vdd CMOSP w=2.88u l=0.18u
+  ad=0.9072p pd=3.51u as=1.5552p ps=6.84u
M1037 carry_0/c2_xn1 carry_0/c0b gnd Gnd CMOSN w=2.25u l=0.18u
+  ad=0.7047p pd=2.88u as=0.7047p ps=2.88u
M1038 sum3_0/c3 carry_0/c0b carry_0/a_304_148# vdd CMOSP w=4.5u l=0.18u
+  ad=1.215p pd=5.13u as=1.4175p ps=5.13u
M1039 carry_0/a_376_148# pg3_0/t3b vdd vdd CMOSP w=2.88u l=0.18u
+  ad=0.9072p pd=3.51u as=1.5552p ps=6.84u
M1040 carry_0/g2_0b carry_0/g1_0 carry_0/a_250_15# Gnd CMOSN w=1.8u l=0.18u
+  ad=0.81p pd=4.5u as=0.567p ps=2.43u
M1041 carry_0/t1_0 pg0_0/t0b gnd Gnd CMOSN w=1.44u l=0.18u
+  ad=0.648p pd=3.78u as=0.4536p ps=2.07u
M1042 vdd pg0_0/g0b sum1_0/c1 vdd CMOSP w=0.9u l=0.18u
+  ad=0.405p pd=2.7u as=0.486p ps=2.43u
M1043 vdd pg2_0/t2b carry_0/t2 vdd CMOSP w=3.51u l=0.18u
+  ad=1.5795p pd=7.92u as=1.8954p ps=8.1u
M1044 carry_0/t2_0b carry_0/t1_0 vdd vdd CMOSP w=2.25u l=0.18u
+  ad=1.0125p pd=5.4u as=0.7047p ps=2.88u
M1045 vdd carry_0/g1_0 carry_0/g1_0b vdd CMOSP w=1.8u l=0.18u
+  ad=0.81p pd=4.5u as=0.972p ps=4.68u
M1046 vdd carry_0/g3_0b c4 vdd CMOSP w=1.44u l=0.18u
+  ad=0.648p pd=3.78u as=0.7776p ps=3.51u
M1047 carry_0/g3_0b carry_0/g1_0 carry_0/a_412_27# Gnd CMOSN w=0.72u l=0.18u
+  ad=0.324p pd=2.34u as=0.2268p ps=1.35u
M1048 carry_0/g30_xp1 carry_0/g1_0 carry_0/g3_0b vdd CMOSP w=1.44u l=0.18u
+  ad=0.648p pd=3.78u as=0.4536p ps=2.07u
M1049 gnd carry_0/c0b carry_0/c4g_xn1 Gnd CMOSN w=1.44u l=0.18u
+  ad=0.4536p pd=2.07u as=0.7776p ps=3.96u
M1050 sum2_0/c2 carry_0/g1_0b carry_0/c2_xn1 Gnd CMOSN w=2.25u l=0.18u
+  ad=1.0125p pd=5.4u as=0.7047p ps=2.88u
M1051 gnd pg3_0/g3b carry_0/g32_xn1 Gnd CMOSN w=1.44u l=0.18u
+  ad=0.648p pd=3.78u as=0.4536p ps=2.07u
M1052 carry_0/g20_xp1 carry_0/g2 vdd vdd CMOSP w=3.6u l=0.18u
+  ad=1.134p pd=4.23u as=1.944p ps=8.28u
M1053 carry_0/a_70_148# pg1_0/t1b vdd vdd CMOSP w=4.5u l=0.18u
+  ad=1.4175p pd=5.13u as=2.43p ps=10.08u
M1054 vdd carry_0/t1_0 carry_0/t1_0b vdd CMOSP w=2.79u l=0.18u
+  ad=1.2555p pd=6.48u as=1.5066p ps=6.66u
M1055 vdd carry_0/t3_2 carry_0/t3_0b vdd CMOSP w=0.72u l=0.18u
+  ad=0.2268p pd=1.35u as=0.3888p ps=2.52u
M1056 gnd pg1_0/t1b carry_0/g10_xn1 Gnd CMOSN w=2.25u l=0.18u
+  ad=0.7047p pd=2.88u as=1.215p ps=5.58u
M1057 gnd pg2_0/g2b carry_0/g2 Gnd CMOSN w=1.08u l=0.18u
+  ad=0.486p pd=3.06u as=0.5832p ps=3.24u
M1058 gnd carry_0/g2 carry_0/g2_0b Gnd CMOSN w=0.9u l=0.18u
+  ad=0.5265p pd=2.43u as=0.486p ps=2.88u
M1059 carry_0/g3_2 pg2_0/g2b carry_0/a_340_148# vdd CMOSP w=2.88u l=0.18u
+  ad=0.7776p pd=3.51u as=0.9072p ps=3.51u
M1060 sum1_0/c1 pg0_0/t0b carry_0/c1_xn1 Gnd CMOSN w=0.9u l=0.18u
+  ad=0.2835p pd=1.53u as=0.486p ps=2.88u
M1061 carry_0/g20_xp1 carry_0/g1_0 carry_0/g2_0b vdd CMOSP w=3.6u l=0.18u
+  ad=1.62p pd=8.1u as=1.134p ps=4.23u
M1062 gnd carry_0/t2_0b carry_0/c3_xn1 Gnd CMOSN w=2.25u l=0.18u
+  ad=0.7047p pd=2.88u as=1.215p ps=5.58u
M1063 carry_0/c4g_xn1 carry_0/t3_0b gnd Gnd CMOSN w=1.44u l=0.18u
+  ad=0.4536p pd=2.07u as=0.4536p ps=2.07u
M1064 vdd pg1_0/g1b carry_0/g1_0 vdd CMOSP w=2.25u l=0.18u
+  ad=1.0125p pd=5.4u as=1.215p ps=5.13u
M1065 gnd carry_0/t1_0 carry_0/t1_0b Gnd CMOSN w=1.44u l=0.18u
+  ad=0.648p pd=3.78u as=0.7776p ps=3.96u
M1066 carry_0/a_106_148# pg1_0/t1b vdd vdd CMOSP w=5.58u l=0.18u
+  ad=1.7577p pd=6.21u as=3.0132p ps=12.24u
M1067 carry_0/a_169_148# carry_0/t1_0b vdd vdd CMOSP w=4.5u l=0.18u
+  ad=1.4175p pd=5.13u as=2.43p ps=10.08u
M1068 carry_0/a_412_27# carry_0/t3_2 gnd Gnd CMOSN w=0.72u l=0.18u
+  ad=0.2268p pd=1.35u as=0.2106p ps=1.35u
M1069 carry_0/a_304_148# carry_0/t2_0b vdd vdd CMOSP w=4.5u l=0.18u
+  ad=1.4175p pd=5.13u as=2.43p ps=10.08u
M1070 vdd carry_0/t2 carry_0/t2_0b vdd CMOSP w=2.25u l=0.18u
+  ad=0.7047p pd=2.88u as=1.215p ps=5.58u
M1071 carry_0/g10_xn1 pg0_0/g0b gnd Gnd CMOSN w=2.25u l=0.18u
+  ad=0.7047p pd=2.88u as=0.7047p ps=2.88u
M1072 sum1_0/c1 carry_0/c0b carry_0/a_34_148# vdd CMOSP w=1.8u l=0.18u
+  ad=0.486p pd=2.43u as=0.567p ps=2.43u
M1073 carry_0/a_439_27# carry_0/t3_2 carry_0/t3_0b Gnd CMOSN w=0.72u l=0.18u
+  ad=0.2268p pd=1.35u as=0.3888p ps=2.52u
M1074 vdd carry_0/g1_0b sum2_0/c2 vdd CMOSP w=2.25u l=0.18u
+  ad=1.0125p pd=5.4u as=1.215p ps=5.13u
M1075 carry_0/g3_0b carry_0/t3_2 carry_0/g30_xp1 vdd CMOSP w=1.44u l=0.18u
+  ad=0.4536p pd=2.07u as=0.4536p ps=2.07u
M1076 c4 carry_0/t3_0b carry_0/a_466_148# vdd CMOSP w=2.88u l=0.18u
+  ad=0.7776p pd=3.51u as=0.9072p ps=3.51u
M1077 carry_0/c1_xn1 carry_0/c0b sum1_0/c1 Gnd CMOSN w=0.9u l=0.18u
+  ad=0.2835p pd=1.53u as=0.2835p ps=1.53u
M1078 vdd carry_0/g2_0b sum3_0/c3 vdd CMOSP w=2.25u l=0.18u
+  ad=1.0125p pd=5.4u as=1.215p ps=5.13u
M1079 carry_0/t3_2 pg2_0/t2b carry_0/a_376_148# vdd CMOSP w=2.88u l=0.18u
+  ad=1.296p pd=6.66u as=0.9072p ps=3.51u
M1080 carry_0/c3_xn1 carry_0/c0b gnd Gnd CMOSN w=2.25u l=0.18u
+  ad=0.7047p pd=2.88u as=0.7047p ps=2.88u
M1081 c4 carry_0/g3_0b carry_0/c4g_xn1 Gnd CMOSN w=1.44u l=0.18u
+  ad=0.648p pd=3.78u as=0.4536p ps=2.07u
M1082 gnd pg3_0/t3b carry_0/t3_2 Gnd CMOSN w=0.72u l=0.18u
+  ad=0.2268p pd=1.35u as=0.3888p ps=2.52u
M1083 carry_0/g1_0 pg1_0/g1b carry_0/g10_xn1 Gnd CMOSN w=2.25u l=0.18u
+  ad=1.0125p pd=5.4u as=0.7047p ps=2.88u
M1084 gnd pg2_0/t2b carry_0/t2 Gnd CMOSN w=1.8u l=0.18u
+  ad=0.81p pd=4.5u as=0.972p ps=4.68u
M1085 carry_0/a_277_10# carry_0/t2 carry_0/t2_0b Gnd CMOSN w=2.25u l=0.18u
+  ad=0.7047p pd=2.88u as=1.215p ps=5.58u
M1086 carry_0/g3_2 pg3_0/t3b carry_0/g32_xn1 Gnd CMOSN w=1.44u l=0.18u
+  ad=0.4536p pd=2.07u as=0.7776p ps=3.96u
M1087 gnd carry_0/t1_0 carry_0/a_439_27# Gnd CMOSN w=0.72u l=0.18u
+  ad=0.324p pd=2.34u as=0.2268p ps=1.35u
M1088 carry_0/a_340_148# pg3_0/t3b vdd vdd CMOSP w=2.88u l=0.18u
+  ad=0.9072p pd=3.51u as=1.5552p ps=6.84u
M1089 gnd pg0_0/g0b carry_0/c1_xn1 Gnd CMOSN w=0.9u l=0.18u
+  ad=0.405p pd=2.7u as=0.2835p ps=1.53u
M1090 gnd carry_0/t1_0b carry_0/c2_xn1 Gnd CMOSN w=2.25u l=0.18u
+  ad=0.7047p pd=2.88u as=1.215p ps=5.58u
M1091 sum3_0/c3 carry_0/g2_0b carry_0/c3_xn1 Gnd CMOSN w=2.25u l=0.18u
+  ad=1.0125p pd=5.4u as=0.7047p ps=2.88u
M1092 carry_0/g2_0b carry_0/t2 carry_0/g20_xp1 vdd CMOSP w=3.6u l=0.18u
+  ad=1.134p pd=4.23u as=1.134p ps=4.23u
M1093 carry_0/a_250_15# carry_0/t2 gnd Gnd CMOSN w=1.8u l=0.18u
+  ad=0.567p pd=2.43u as=0.5265p ps=2.43u
M1094 carry_0/t3_2 pg2_0/t2b gnd Gnd CMOSN w=0.72u l=0.18u
+  ad=0.324p pd=2.34u as=0.2268p ps=1.35u
M1095 vdd c0 carry_0/c0b vdd CMOSP w=1.8u l=0.18u
+  ad=0.81p pd=4.5u as=0.972p ps=4.68u
M1096 carry_0/g1_0 pg0_0/g0b carry_0/a_70_148# vdd CMOSP w=4.5u l=0.18u
+  ad=1.215p pd=5.13u as=1.4175p ps=5.13u
M1097 gnd carry_0/g1_0 carry_0/g1_0b Gnd CMOSN w=0.9u l=0.18u
+  ad=0.405p pd=2.7u as=0.486p ps=2.88u
M1098 carry_0/t3_0b carry_0/t1_0 vdd vdd CMOSP w=0.72u l=0.18u
+  ad=0.324p pd=2.34u as=0.2268p ps=1.35u
M1099 gnd pg1_0/t1b carry_0/t1_0 Gnd CMOSN w=1.44u l=0.18u
+  ad=0.4536p pd=2.07u as=0.7776p ps=3.96u
M1100 gnd carry_0/g3_2 carry_0/g3_0b Gnd CMOSN w=0.36u l=0.18u
+  ad=0.2106p pd=1.35u as=0.1944p ps=1.8u
M1101 vdd pg3_0/g3b carry_0/g3_2 vdd CMOSP w=1.44u l=0.18u
+  ad=0.648p pd=3.78u as=0.7776p ps=3.51u
M1102 gnd c0 carry_0/c0b Gnd CMOSN w=0.9u l=0.18u
+  ad=0.405p pd=2.7u as=0.486p ps=2.88u
M1103 vdd pg2_0/g2b carry_0/g2 vdd CMOSP w=2.25u l=0.18u
+  ad=1.0125p pd=5.4u as=1.215p ps=5.58u
M1104 pg0_0/a_106_103# a0 vdd vdd CMOSP w=1.44u l=0.18u
+  ad=0.4536p pd=2.07u as=0.7776p ps=3.96u
M1105 pg0_0/a_43_103# a0 vdd vdd CMOSP w=5.58u l=0.18u
+  ad=1.7577p pd=6.21u as=3.0132p ps=12.24u
M1106 vdd pg0_0/g0b pg0_0/p0b vdd CMOSP w=0.72u l=0.18u
+  ad=0.324p pd=2.34u as=0.3888p ps=2.07u
M1107 pg0_0/oai0_xn1 b0 pg0_0/p0b Gnd CMOSN w=0.72u l=0.18u
+  ad=0.2268p pd=1.35u as=0.2268p ps=1.35u
M1108 gnd a0 pg0_0/t0b Gnd CMOSN w=1.44u l=0.18u
+  ad=0.4536p pd=2.07u as=0.7776p ps=3.96u
M1109 gnd pg0_0/g0b pg0_0/oai0_xn1 Gnd CMOSN w=0.72u l=0.18u
+  ad=0.324p pd=2.34u as=0.2268p ps=1.35u
M1110 pg0_0/a_70_27# a0 pg0_0/p0 Gnd CMOSN w=0.72u l=0.18u
+  ad=0.2268p pd=1.35u as=0.3888p ps=2.52u
M1111 vdd a0 pg0_0/g0b vdd CMOSP w=2.25u l=0.18u
+  ad=0.7047p pd=2.88u as=1.215p ps=5.58u
M1112 pg0_0/aoi0_xp1 b0 vdd vdd CMOSP w=1.44u l=0.18u
+  ad=0.4536p pd=2.07u as=0.4536p ps=2.07u
M1113 pg0_0/t0b b0 gnd Gnd CMOSN w=1.44u l=0.18u
+  ad=0.648p pd=3.78u as=0.4536p ps=2.07u
M1114 pg0_0/p0 pg0_0/t0b gnd Gnd CMOSN w=0.36u l=0.18u
+  ad=0.162p pd=1.62u as=0.1944p ps=1.35u
M1115 pg0_0/p0b b0 pg0_0/a_106_103# vdd CMOSP w=1.44u l=0.18u
+  ad=0.3888p pd=2.07u as=0.4536p ps=2.07u
M1116 pg0_0/a_16_10# a0 pg0_0/g0b Gnd CMOSN w=2.25u l=0.18u
+  ad=0.7047p pd=2.88u as=1.215p ps=5.58u
M1117 gnd b0 pg0_0/a_70_27# Gnd CMOSN w=0.72u l=0.18u
+  ad=0.1944p pd=1.35u as=0.2268p ps=1.35u
M1118 pg0_0/t0b b0 pg0_0/a_43_103# vdd CMOSP w=5.58u l=0.18u
+  ad=2.511p pd=12.06u as=1.7577p ps=6.21u
M1119 gnd b0 pg0_0/a_16_10# Gnd CMOSN w=2.25u l=0.18u
+  ad=1.0125p pd=5.4u as=0.7047p ps=2.88u
M1120 vdd a0 pg0_0/aoi0_xp1 vdd CMOSP w=1.44u l=0.18u
+  ad=0.4536p pd=2.07u as=0.7776p ps=3.96u
M1121 pg0_0/p0b a0 pg0_0/oai0_xn1 Gnd CMOSN w=0.72u l=0.18u
+  ad=0.2268p pd=1.35u as=0.3888p ps=2.52u
M1122 pg0_0/g0b b0 vdd vdd CMOSP w=2.25u l=0.18u
+  ad=1.0125p pd=5.4u as=0.7047p ps=2.88u
M1123 pg0_0/p0 pg0_0/t0b pg0_0/aoi0_xp1 vdd CMOSP w=1.44u l=0.18u
+  ad=0.648p pd=3.78u as=0.4536p ps=2.07u
M1124 sum0_0/x0_s1xp1 sum0_0/x0_cb s0 vdd CMOSP w=4.5u l=0.18u
+  ad=1.4175p pd=5.13u as=1.4175p ps=5.13u
M1125 gnd sum0_0/x0_cb sum0_0/a_34_10# Gnd CMOSN w=2.25u l=0.18u
+  ad=0.5427p pd=2.88u as=0.7047p ps=2.88u
M1126 vdd c0 sum0_0/x0_cb vdd CMOSP w=0.9u l=0.18u
+  ad=1.2555p pd=5.13u as=0.486p ps=2.88u
M1127 s0 pg0_0/p0b sum0_0/x0_s1xp1 vdd CMOSP w=4.5u l=0.18u
+  ad=1.4175p pd=5.13u as=1.4175p ps=5.13u
M1128 sum0_0/a_16_10# c0 gnd Gnd CMOSN w=2.25u l=0.18u
+  ad=0.7047p pd=2.88u as=1.215p ps=5.58u
M1129 vdd c0 sum0_0/x0_s1xp1 vdd CMOSP w=4.5u l=0.18u
+  ad=2.025p pd=9.9u as=1.4175p ps=5.13u
M1130 s0 pg0_0/p0 sum0_0/a_16_10# Gnd CMOSN w=2.25u l=0.18u
+  ad=0.7047p pd=2.88u as=0.7047p ps=2.88u
M1131 sum0_0/x0_cb c0 gnd Gnd CMOSN w=0.45u l=0.18u
+  ad=0.2025p pd=1.8u as=0.5427p ps=2.88u
M1132 sum0_0/x0_s1xp1 pg0_0/p0 vdd vdd CMOSP w=4.5u l=0.18u
+  ad=1.4175p pd=5.13u as=1.2555p ps=5.13u
M1133 sum0_0/a_34_10# pg0_0/p0b s0 Gnd CMOSN w=2.25u l=0.18u
+  ad=0.7047p pd=2.88u as=0.7047p ps=2.88u
M1134 pg3_0/a_106_103# a3 vdd vdd CMOSP w=3.6u l=0.18u
+  ad=1.134p pd=4.23u as=1.944p ps=8.28u
M1135 pg3_0/a_70_15# a3 pg3_0/p3 Gnd CMOSN w=1.8u l=0.18u
+  ad=0.567p pd=2.43u as=0.972p ps=4.68u
M1136 pg3_0/a_43_103# a3 vdd vdd CMOSP w=4.5u l=0.18u
+  ad=1.4175p pd=5.13u as=2.43p ps=10.08u
M1137 vdd pg3_0/g3b pg3_0/p3b vdd CMOSP w=1.8u l=0.18u
+  ad=0.81p pd=4.5u as=0.972p ps=4.23u
M1138 pg3_0/t3b b3 gnd Gnd CMOSN w=1.08u l=0.18u
+  ad=0.486p pd=3.06u as=0.3402p ps=1.71u
M1139 pg3_0/p3 pg3_0/t3b gnd Gnd CMOSN w=0.9u l=0.18u
+  ad=0.405p pd=2.7u as=0.486p ps=2.43u
M1140 gnd b3 pg3_0/a_70_15# Gnd CMOSN w=1.8u l=0.18u
+  ad=0.486p pd=2.43u as=0.567p ps=2.43u
M1141 pg3_0/a_16_15# a3 pg3_0/g3b Gnd CMOSN w=1.8u l=0.18u
+  ad=0.567p pd=2.43u as=0.972p ps=4.68u
M1142 vdd a3 pg3_0/g3b vdd CMOSP w=1.8u l=0.18u
+  ad=0.567p pd=2.43u as=0.972p ps=4.68u
M1143 pg3_0/aoi3_xp1 b3 vdd vdd CMOSP w=3.6u l=0.18u
+  ad=1.134p pd=4.23u as=1.134p ps=4.23u
M1144 gnd b3 pg3_0/a_16_15# Gnd CMOSN w=1.8u l=0.18u
+  ad=0.81p pd=4.5u as=0.567p ps=2.43u
M1145 pg3_0/p3b a3 pg3_0/oai3_xn1 Gnd CMOSN w=1.8u l=0.18u
+  ad=0.567p pd=2.43u as=0.972p ps=4.68u
M1146 pg3_0/p3b b3 pg3_0/a_106_103# vdd CMOSP w=3.6u l=0.18u
+  ad=0.972p pd=4.23u as=1.134p ps=4.23u
M1147 pg3_0/t3b b3 pg3_0/a_43_103# vdd CMOSP w=4.5u l=0.18u
+  ad=2.025p pd=9.9u as=1.4175p ps=5.13u
M1148 pg3_0/oai3_xn1 b3 pg3_0/p3b Gnd CMOSN w=1.8u l=0.18u
+  ad=0.567p pd=2.43u as=0.567p ps=2.43u
M1149 vdd a3 pg3_0/aoi3_xp1 vdd CMOSP w=3.6u l=0.18u
+  ad=1.134p pd=4.23u as=1.944p ps=8.28u
M1150 gnd a3 pg3_0/t3b Gnd CMOSN w=1.08u l=0.18u
+  ad=0.3402p pd=1.71u as=0.5832p ps=3.24u
M1151 pg3_0/g3b b3 vdd vdd CMOSP w=1.8u l=0.18u
+  ad=0.81p pd=4.5u as=0.567p ps=2.43u
M1152 pg3_0/p3 pg3_0/t3b pg3_0/aoi3_xp1 vdd CMOSP w=3.6u l=0.18u
+  ad=1.62p pd=8.1u as=1.134p ps=4.23u
M1153 gnd pg3_0/g3b pg3_0/oai3_xn1 Gnd CMOSN w=1.8u l=0.18u
+  ad=0.81p pd=4.5u as=0.567p ps=2.43u
M1154 sum3_0/x3_s1xp1 sum3_0/x3_cb s3 vdd CMOSP w=1.8u l=0.18u
+  ad=0.567p pd=2.43u as=0.567p ps=2.43u
M1155 s3 pg3_0/p3 sum3_0/a_16_25# Gnd CMOSN w=0.9u l=0.18u
+  ad=0.2835p pd=1.53u as=0.2835p ps=1.53u
M1156 sum3_0/a_34_25# pg3_0/p3b s3 Gnd CMOSN w=0.9u l=0.18u
+  ad=0.2835p pd=1.53u as=0.2835p ps=1.53u
M1157 vdd sum3_0/c3 sum3_0/x3_cb vdd CMOSP w=1.8u l=0.18u
+  ad=0.567p pd=2.43u as=0.972p ps=4.68u
M1158 s3 pg3_0/p3b sum3_0/x3_s1xp1 vdd CMOSP w=1.8u l=0.18u
+  ad=0.567p pd=2.43u as=0.567p ps=2.43u
M1159 gnd sum3_0/x3_cb sum3_0/a_34_25# Gnd CMOSN w=0.9u l=0.18u
+  ad=0.2835p pd=1.53u as=0.2835p ps=1.53u
M1160 vdd sum3_0/c3 sum3_0/x3_s1xp1 vdd CMOSP w=1.8u l=0.18u
+  ad=0.81p pd=4.5u as=0.567p ps=2.43u
M1161 sum3_0/x3_cb sum3_0/c3 gnd Gnd CMOSN w=0.9u l=0.18u
+  ad=0.405p pd=2.7u as=0.2835p ps=1.53u
M1162 sum3_0/a_16_25# sum3_0/c3 gnd Gnd CMOSN w=0.9u l=0.18u
+  ad=0.2835p pd=1.53u as=0.486p ps=2.88u
M1163 sum3_0/x3_s1xp1 pg3_0/p3 vdd vdd CMOSP w=1.8u l=0.18u
+  ad=0.567p pd=2.43u as=0.567p ps=2.43u
M1164 pg1_0/a_106_103# a1 vdd vdd CMOSP w=1.44u l=0.18u
+  ad=0.4536p pd=2.07u as=0.7776p ps=3.96u
M1165 pg1_0/a_43_103# a1 vdd vdd CMOSP w=7.02u l=0.18u
+  ad=2.2113p pd=7.65u as=3.7908p ps=15.12u
M1166 pg1_0/t1b b1 gnd Gnd CMOSN w=1.8u l=0.18u
+  ad=0.81p pd=4.5u as=0.567p ps=2.43u
M1167 vdd pg1_0/g1b pg1_0/p1b vdd CMOSP w=0.72u l=0.18u
+  ad=0.324p pd=2.34u as=0.3888p ps=2.07u
M1168 pg1_0/oai1_xn1 b1 pg1_0/p1b Gnd CMOSN w=0.72u l=0.18u
+  ad=0.2268p pd=1.35u as=0.2268p ps=1.35u
M1169 gnd pg1_0/g1b pg1_0/oai1_xn1 Gnd CMOSN w=0.72u l=0.18u
+  ad=0.324p pd=2.34u as=0.2268p ps=1.35u
M1170 pg1_0/a_70_27# a1 pg1_0/p1 Gnd CMOSN w=0.72u l=0.18u
+  ad=0.2268p pd=1.35u as=0.3888p ps=2.52u
M1171 vdd a1 pg1_0/g1b vdd CMOSP w=2.25u l=0.18u
+  ad=0.7047p pd=2.88u as=1.215p ps=5.58u
M1172 pg1_0/aoi1_xp1 b1 vdd vdd CMOSP w=1.44u l=0.18u
+  ad=0.4536p pd=2.07u as=0.4536p ps=2.07u
M1173 pg1_0/p1 pg1_0/t1b gnd Gnd CMOSN w=0.36u l=0.18u
+  ad=0.162p pd=1.62u as=0.1944p ps=1.35u
M1174 pg1_0/p1b b1 pg1_0/a_106_103# vdd CMOSP w=1.44u l=0.18u
+  ad=0.3888p pd=2.07u as=0.4536p ps=2.07u
M1175 pg1_0/a_16_10# a1 pg1_0/g1b Gnd CMOSN w=2.25u l=0.18u
+  ad=0.7047p pd=2.88u as=1.215p ps=5.58u
M1176 gnd b1 pg1_0/a_70_27# Gnd CMOSN w=0.72u l=0.18u
+  ad=0.1944p pd=1.35u as=0.2268p ps=1.35u
M1177 pg1_0/t1b b1 pg1_0/a_43_103# vdd CMOSP w=7.02u l=0.18u
+  ad=3.159p pd=14.94u as=2.2113p ps=7.65u
M1178 gnd b1 pg1_0/a_16_10# Gnd CMOSN w=2.25u l=0.18u
+  ad=1.0125p pd=5.4u as=0.7047p ps=2.88u
M1179 vdd a1 pg1_0/aoi1_xp1 vdd CMOSP w=1.44u l=0.18u
+  ad=0.4536p pd=2.07u as=0.7776p ps=3.96u
M1180 gnd a1 pg1_0/t1b Gnd CMOSN w=1.8u l=0.18u
+  ad=0.567p pd=2.43u as=0.972p ps=4.68u
M1181 pg1_0/p1b a1 pg1_0/oai1_xn1 Gnd CMOSN w=0.72u l=0.18u
+  ad=0.2268p pd=1.35u as=0.3888p ps=2.52u
M1182 pg1_0/g1b b1 vdd vdd CMOSP w=2.25u l=0.18u
+  ad=1.0125p pd=5.4u as=0.7047p ps=2.88u
M1183 pg1_0/p1 pg1_0/t1b pg1_0/aoi1_xp1 vdd CMOSP w=1.44u l=0.18u
+  ad=0.648p pd=3.78u as=0.4536p ps=2.07u
M1184 sum1_0/x1_s1xp1 sum1_0/x1_cb s1 vdd CMOSP w=3.6u l=0.18u
+  ad=1.134p pd=4.23u as=1.134p ps=4.23u
M1185 sum1_0/x1_cb sum1_0/c1 gnd Gnd CMOSN w=0.54u l=0.18u
+  ad=0.243p pd=1.98u as=0.4536p ps=2.43u
M1186 sum1_0/a_16_15# sum1_0/c1 gnd Gnd CMOSN w=1.8u l=0.18u
+  ad=0.567p pd=2.43u as=0.972p ps=4.68u
M1187 vdd sum1_0/c1 sum1_0/x1_cb vdd CMOSP w=1.17u l=0.18u
+  ad=1.0206p pd=4.23u as=0.6318p ps=3.42u
M1188 s1 pg1_0/p1 sum1_0/a_16_15# Gnd CMOSN w=1.8u l=0.18u
+  ad=0.567p pd=2.43u as=0.567p ps=2.43u
M1189 s1 pg1_0/p1b sum1_0/x1_s1xp1 vdd CMOSP w=3.6u l=0.18u
+  ad=1.134p pd=4.23u as=1.134p ps=4.23u
M1190 vdd sum1_0/c1 sum1_0/x1_s1xp1 vdd CMOSP w=3.6u l=0.18u
+  ad=1.62p pd=8.1u as=1.134p ps=4.23u
M1191 sum1_0/a_34_15# pg1_0/p1b s1 Gnd CMOSN w=1.8u l=0.18u
+  ad=0.567p pd=2.43u as=0.567p ps=2.43u
M1192 gnd sum1_0/x1_cb sum1_0/a_34_15# Gnd CMOSN w=1.8u l=0.18u
+  ad=0.4536p pd=2.43u as=0.567p ps=2.43u
M1193 sum1_0/x1_s1xp1 pg1_0/p1 vdd vdd CMOSP w=3.6u l=0.18u
+  ad=1.134p pd=4.23u as=1.0206p ps=4.23u
C0 pg2_0/g2b pg1_0/aoi1_xp1 0.00538f
C1 carry_0/g10_xn1 pg0_0/t0b 0.25561f
C2 carry_0/g3_0b gnd 0.03306f
C3 carry_0/c0b pg3_0/t3b 0.01965f
C4 pg2_0/t2b pg2_0/p2 0.6143f
C5 pg2_0/g2b pg2_0/p2b 0.08407f
C6 c0 pg3_0/p3 0.00496f
C7 pg0_0/p0 gnd 0.03686f
C8 pg1_0/p1 s1 0.1594f
C9 carry_0/g2 pg1_0/t1b 0.01092f
C10 carry_0/t2 pg1_0/g1b 0.03493f
C11 pg2_0/p2b carry_0/t3_2 0.00119f
C12 carry_0/c0b carry_0/t2_0b 0.47836f
C13 pg3_0/a_43_103# pg3_0/t3b 0.00142f
C14 carry_0/g1_0b c0 0.02508f
C15 carry_0/t1_0 sum2_0/c2 0.00934f
C16 sum2_0/x2_s1xp1 vdd 0.55276f
C17 b2 gnd 0.00751f
C18 c0 c4 0.0295f
C19 carry_0/g30_xp1 carry_0/g3_0b 0.9464f
C20 carry_0/g2_0b carry_0/c3_xn1 0.00541f
C21 pg3_0/p3 pg1_0/g1b 0.00541f
C22 a2 pg2_0/p2 0.03709f
C23 b2 pg2_0/t2b 0.88431f
C24 vdd sum0_0/x0_s1xp1 0.93422f
C25 b0 gnd 0.00719f
C26 pg0_0/t0b pg0_0/p0 0.58199f
C27 pg0_0/g0b pg0_0/p0b 0.08267f
C28 carry_0/t1_0 pg1_0/p1b 0
C29 carry_0/g1_0b pg1_0/g1b 0.02265f
C30 pg2_0/p2 carry_0/g3_2 0.00113f
C31 vdd pg1_0/aoi1_xp1 0.28719f
C32 c4 pg1_0/g1b 0.01727f
C33 carry_0/t1_0 c0 3.69057f
C34 pg2_0/p2b vdd 0.32078f
C35 pg2_0/oai2_xn1 gnd 0.13223f
C36 c0 sum3_0/c3 0.01541f
C37 carry_0/g3_2 carry_0/g3_0b 0.01092f
C38 carry_0/a_466_148# vdd 0
C39 carry_0/t3_0b gnd 0.00202f
C40 pg2_0/a_70_19# pg2_0/p2 0
C41 a2 b2 1.92223f
C42 vdd pg0_0/p0b 0.1806f
C43 pg0_0/oai0_xn1 gnd 0.06612f
C44 a0 pg0_0/p0 0.0298f
C45 b0 pg0_0/t0b 0.88516f
C46 pg1_0/p1b sum1_0/x1_s1xp1 0.27828f
C47 carry_0/g1_0 pg1_0/p1 0.00113f
C48 carry_0/g32_xn1 pg3_0/g3b 0.00463f
C49 carry_0/t1_0 pg1_0/g1b 0.03902f
C50 sum2_0/c2 pg1_0/p1b 0.00472f
C51 sum1_0/c1 sum1_0/x1_cb 0.71387f
C52 vdd s3 0.01113f
C53 sum3_0/c3 pg1_0/g1b 0.01641f
C54 carry_0/a_34_148# sum1_0/c1 0
C55 pg2_0/g2b vdd 0.71682f
C56 c0 sum2_0/c2 0.01541f
C57 carry_0/t2_0b carry_0/c3_xn1 0.08187f
C58 carry_0/t3_0b carry_0/g30_xp1 0.27792f
C59 sum3_0/a_16_25# s3 0
C60 carry_0/t3_2 vdd 0.31536f
C61 pg2_0/oai2_xn1 a2 0.02092f
C62 pg2_0/a_16_10# pg2_0/g2b 0
C63 pg2_0/aoi2_xp1 pg2_0/p2 0.60913f
C64 pg0_0/a_70_27# pg0_0/p0 0
C65 a0 b0 1.92212f
C66 vdd pg0_0/g0b 0.72385f
C67 carry_0/c0b pg1_0/p1 0.00113f
C68 pg2_0/g2b carry_0/g2_0b 0.02918f
C69 c0 pg1_0/p1b 0.00472f
C70 gnd pg3_0/p3b 0.00136f
C71 sum1_0/c1 pg1_0/p1 0.58401f
C72 sum2_0/c2 pg1_0/g1b 0.21236f
C73 carry_0/c0b carry_0/c4g_xn1 0.09002f
C74 pg2_0/p2b pg3_0/t3b 0.29272f
C75 carry_0/a_340_148# vdd 0
C76 pg2_0/aoi2_xp1 b2 0.01312f
C77 sum1_0/c1 s0 0.01569f
C78 pg0_0/oai0_xn1 a0 0.02027f
C79 pg0_0/a_16_10# pg0_0/g0b 0
C80 pg0_0/aoi0_xp1 pg0_0/p0 0.4769f
C81 pg1_0/t1b pg1_0/p1 0.57863f
C82 pg1_0/g1b pg1_0/p1b 0.08772f
C83 carry_0/g3_0b pg3_0/p3 0
C84 pg2_0/g2b carry_0/g2 0.4627f
C85 gnd pg3_0/g3b 0.00611f
C86 c0 pg1_0/g1b 0.01586f
C87 carry_0/c0b carry_0/g32_xn1 0.15571f
C88 carry_0/t1_0b gnd 0.26799f
C89 pg2_0/t2b pg3_0/g3b 0.0182f
C90 pg2_0/g2b pg3_0/t3b 0.55301f
C91 carry_0/g2_0b vdd 0.03358f
C92 carry_0/g3_0b c4 0.1291f
C93 pg0_0/a_43_103# pg0_0/g0b 0
C94 pg0_0/aoi0_xp1 b0 0.01183f
C95 a1 pg1_0/p1 0.0326f
C96 b1 pg1_0/t1b 0.88714f
C97 carry_0/t3_2 pg3_0/t3b 0.01933f
C98 carry_0/g30_xp1 pg3_0/g3b 0.15641f
C99 pg2_0/p2 carry_0/t1_0 0.00113f
C100 pg2_0/g2b carry_0/t2_0b 0.40992f
C101 pg2_0/p2 sum3_0/c3 0.00472f
C102 sum2_0/x2_cb sum2_0/c2 0.71253f
C103 pg2_0/a_43_103# vdd 0.00113f
C104 carry_0/t1_0 carry_0/g3_0b 0.02841f
C105 gnd sum1_0/a_16_15# 0
C106 sum3_0/x3_cb sum3_0/x3_s1xp1 0.01217f
C107 carry_0/t1_0 pg0_0/p0 0.01378f
C108 carry_0/g3_0b sum3_0/c3 0.00692f
C109 carry_0/a_106_148# pg0_0/p0b 0.01666f
C110 carry_0/g2 vdd 0.44752f
C111 carry_0/g1_0 gnd 0.04312f
C112 sum1_0/c1 sum0_0/a_16_10# 0
C113 pg0_0/a_43_103# vdd 0.00141f
C114 pg1_0/a_70_27# pg1_0/p1 0
C115 a1 b1 1.92216f
C116 carry_0/g3_2 pg3_0/g3b 0.53929f
C117 pg2_0/t2b carry_0/g1_0 0.02751f
C118 sum2_0/x2_s1xp1 s2 0.92999f
C119 gnd pg3_0/a_16_15# 0
C120 vdd pg3_0/t3b 0.0912f
C121 pg2_0/p2 sum2_0/c2 0.58463f
C122 carry_0/c0b carry_0/c1_xn1 0.16716f
C123 carry_0/g1_0 carry_0/g30_xp1 0.21968f
C124 carry_0/t2 carry_0/g20_xp1 0.01377f
C125 carry_0/g2 carry_0/g2_0b 0.02101f
C126 pg3_0/p3 sum3_0/x3_s1xp1 0.00494f
C127 pg3_0/p3b sum3_0/x3_cb 0.26268f
C128 carry_0/g10_xn1 c0 0.25717f
C129 carry_0/g1_0 pg0_0/t0b 0.01944f
C130 carry_0/c0b gnd 0.09225f
C131 carry_0/t3_0b c4 0.00895f
C132 carry_0/t2_0b vdd 0.66659f
C133 carry_0/c1_xn1 sum1_0/c1 0.45573f
C134 sum1_0/c1 gnd 0.00545f
C135 c0 sum0_0/x0_cb 0.70539f
C136 pg1_0/oai1_xn1 a1 0.02027f
C137 pg1_0/a_16_10# pg1_0/g1b 0
C138 pg1_0/aoi1_xp1 pg1_0/p1 0.4769f
C139 pg2_0/t2b carry_0/c0b 0.02762f
C140 pg2_0/p2b s2 0.09334f
C141 vdd a3 0.09033f
C142 sum0_0/x0_s1xp1 s0 1.2274f
C143 pg2_0/p2 c0 0.0054f
C144 carry_0/g10_xn1 pg1_0/g1b 0.00534f
C145 carry_0/t1_0 carry_0/t3_0b 0.0211f
C146 carry_0/g1_0 carry_0/g3_2 0.01906f
C147 carry_0/t2_0b carry_0/g2_0b 0.49971f
C148 pg3_0/p3 pg3_0/p3b 0.2539f
C149 gnd pg1_0/t1b 0.51013f
C150 carry_0/t3_0b sum3_0/c3 0
C151 carry_0/a_106_148# vdd 0.00156f
C152 carry_0/c0b pg0_0/t0b 0.41754f
C153 carry_0/g3_0b c0 0.04172f
C154 c0 pg0_0/p0 0.93689f
C155 sum1_0/c1 pg0_0/t0b 0.19664f
C156 pg1_0/aoi1_xp1 b1 0.01183f
C157 pg2_0/g2b pg1_0/p1 0.00933f
C158 pg2_0/p2 pg1_0/g1b 0.0054f
C159 carry_0/a_439_27# gnd 0
C160 sum3_0/c3 sum3_0/x3_s1xp1 0.00492f
C161 pg0_0/p0b s0 0.09552f
C162 carry_0/g3_0b pg1_0/g1b 0.02552f
C163 carry_0/c0b carry_0/g3_2 0.08692f
C164 pg0_0/p0 pg1_0/g1b 0.00114f
C165 vdd sum1_0/x1_cb 0.13768f
C166 gnd a1 0.00371f
C167 b3 pg3_0/p3b 0.02645f
C168 pg3_0/g3b pg3_0/p3 0.16151f
C169 pg0_0/t0b pg1_0/t1b 0.84223f
C170 carry_0/a_34_148# vdd 0
C171 carry_0/g3_0b carry_0/a_412_27# 0
C172 pg2_0/g2b b1 0.00397f
C173 carry_0/c3_xn1 gnd 0.70201f
C174 sum3_0/c3 pg3_0/p3b 0.01832f
C175 vdd pg3_0/aoi3_xp1 0.68583f
C176 c4 pg3_0/g3b 0.0856f
C177 pg2_0/g2b carry_0/g32_xn1 0.20822f
C178 carry_0/g1_0 carry_0/t2 1.08743f
C179 carry_0/t1_0b carry_0/g1_0b 0.30772f
C180 gnd pg1_0/a_70_27# 0
C181 vdd pg1_0/p1 0.1839f
C182 pg3_0/oai3_xn1 pg3_0/p3b 0.826f
C183 a3 pg3_0/t3b 0.04915f
C184 b3 pg3_0/g3b 0.28625f
C185 carry_0/t3_0b c0 0.0252f
C186 s2 vdd 0.01161f
C187 pg2_0/g2b pg1_0/oai1_xn1 0.01296f
C188 carry_0/t1_0 pg3_0/g3b 0.0202f
C189 carry_0/c2_xn1 gnd 0.70201f
C190 pg2_0/p2 sum2_0/x2_cb 0.01812f
C191 sum3_0/c3 pg3_0/g3b 0.01333f
C192 vdd s0 0.05358f
C193 sum1_0/x1_s1xp1 s1 1.06215f
C194 carry_0/g2_0b pg1_0/p1 0.00428f
C195 carry_0/g20_xp1 pg1_0/p1b 0
C196 carry_0/t3_0b pg1_0/g1b 0.51814f
C197 carry_0/c0b carry_0/t2 0.09675f
C198 carry_0/t1_0 carry_0/t1_0b 0.03519f
C199 carry_0/g1_0 carry_0/g1_0b 0.03416f
C200 vdd b1 0.0808f
C201 pg3_0/a_106_103# pg3_0/p3b 0.01188f
C202 pg3_0/oai3_xn1 pg3_0/g3b 0.16082f
C203 pg2_0/p2b gnd 0.00911f
C204 carry_0/a_169_148# sum2_0/c2 0.00142f
C205 pg0_0/p0b gnd 0.01016f
C206 pg0_0/p0 sum0_0/x0_cb 0.01812f
C207 pg1_0/p1b s1 0.09459f
C208 carry_0/t2 pg1_0/t1b 0
C209 carry_0/g2 pg1_0/p1 0
C210 pg2_0/p2b carry_0/g30_xp1 0.02148f
C211 carry_0/g1_0 carry_0/t1_0 0.3289f
C212 carry_0/c0b carry_0/g1_0b 0.4769f
C213 pg3_0/aoi3_xp1 pg3_0/t3b 0.43054f
C214 carry_0/g1_0 sum3_0/c3 0.01035f
C215 pg2_0/g2b gnd 0.04643f
C216 carry_0/c1_xn1 pg0_0/g0b 0.00506f
C217 carry_0/t3_2 gnd 0.19959f
C218 a2 pg2_0/p2b 0.00708f
C219 b2 pg2_0/p2 0.02789f
C220 pg2_0/g2b pg2_0/t2b 0.26722f
C221 pg0_0/t0b pg0_0/p0b 0
C222 c0 pg3_0/g3b 0.01448f
C223 pg0_0/g0b gnd 0.04961f
C224 carry_0/g1_0b pg1_0/t1b 0.01742f
C225 pg2_0/p2b carry_0/g3_2 0
C226 pg2_0/p2 carry_0/a_376_148# 0.0086f
C227 pg2_0/t2b carry_0/t3_2 0.01886f
C228 carry_0/a_70_148# carry_0/g1_0 0.00142f
C229 carry_0/c0b carry_0/t1_0 0.20187f
C230 vdd pg1_0/a_106_103# 0
C231 pg3_0/aoi3_xp1 a3 0.01377f
C232 carry_0/g1_0 sum2_0/c2 0.0098f
C233 carry_0/t1_0b c0 0.02566f
C234 carry_0/c0b sum3_0/c3 0.085f
C235 carry_0/t3_2 carry_0/g30_xp1 0.01162f
C236 carry_0/g2_0b carry_0/a_250_15# 0
C237 pg3_0/g3b pg1_0/g1b 0.01449f
C238 pg2_0/oai2_xn1 pg2_0/p2 0.23155f
C239 a2 pg2_0/g2b 1.06244f
C240 vdd gnd 1.12746f
C241 a0 pg0_0/p0b 0.00647f
C242 b0 pg0_0/p0 0.02787f
C243 pg0_0/g0b pg0_0/t0b 0.28742f
C244 carry_0/g1_0 pg1_0/p1b 0
C245 carry_0/t1_0b pg1_0/g1b 0.02785f
C246 carry_0/g32_xn1 pg3_0/t3b 0.01155f
C247 carry_0/t1_0 pg1_0/t1b 0.02227f
C248 pg2_0/g2b carry_0/g3_2 0.0258f
C249 sum1_0/c1 sum1_0/x1_s1xp1 0.00654f
C250 gnd sum3_0/a_16_25# 0
C251 carry_0/c0b sum2_0/c2 0.08507f
C252 carry_0/g1_0 c0 0.06299f
C253 pg2_0/a_16_10# gnd 0
C254 pg2_0/t2b vdd 0.08349f
C255 carry_0/g3_2 carry_0/t3_2 0.40038f
C256 carry_0/t3_0b carry_0/g3_0b 0.65418f
C257 sum3_0/a_34_25# s3 0
C258 carry_0/g30_xp1 vdd 0.15458f
C259 carry_0/g2_0b gnd 0.16617f
C260 pg2_0/a_106_103# pg2_0/p2 0
C261 pg2_0/oai2_xn1 b2 0.21932f
C262 pg0_0/a_16_10# gnd 0
C263 pg0_0/oai0_xn1 pg0_0/p0 0.19864f
C264 a0 pg0_0/g0b 1.06257f
C265 vdd pg0_0/t0b 0.08596f
C266 pg1_0/p1 sum1_0/x1_cb 0.01812f
C267 carry_0/c0b pg1_0/p1b 0
C268 carry_0/g1_0 pg1_0/g1b 3.54044f
C269 pg2_0/t2b carry_0/g2_0b 0.9934f
C270 sum2_0/c2 pg1_0/t1b 0.00638f
C271 sum1_0/c1 pg1_0/p1b 0.01832f
C272 carry_0/c0b c0 4.75172f
C273 a2 vdd 0.08944f
C274 c0 sum1_0/c1 0.1256f
C275 carry_0/a_340_148# carry_0/g3_2 0
C276 carry_0/t1_0 carry_0/c3_xn1 0.0196f
C277 carry_0/g1_0b carry_0/c2_xn1 0.02502f
C278 sum3_0/x3_cb s3 0.08338f
C279 carry_0/g2 gnd 0.10071f
C280 carry_0/g3_2 vdd 0.29764f
C281 carry_0/c3_xn1 sum3_0/c3 0.41817f
C282 pg2_0/a_43_103# pg2_0/t2b 0.00142f
C283 pg0_0/a_106_103# pg0_0/p0 0
C284 vdd a0 0.08783f
C285 pg0_0/oai0_xn1 b0 0.21867f
C286 carry_0/c0b pg1_0/g1b 0.03788f
C287 pg2_0/g2b carry_0/t2 0.72735f
C288 pg2_0/t2b carry_0/g2 0.01822f
C289 gnd pg3_0/t3b 0.30166f
C290 c0 pg1_0/t1b 0.04784f
C291 carry_0/t1_0 carry_0/c2_xn1 0.01921f
C292 pg3_0/p3 s3 0.15857f
C293 pg2_0/p2 pg3_0/g3b 0
C294 carry_0/t2_0b gnd 0.04508f
C295 carry_0/a_304_148# vdd 0.00113f
C296 carry_0/a_466_148# c4 0
C297 pg2_0/t2b pg3_0/t3b 0.41035f
C298 pg0_0/a_43_103# pg0_0/t0b 0.00176f
C299 a1 pg1_0/p1b 0.00644f
C300 b1 pg1_0/p1 0.0279f
C301 pg1_0/g1b pg1_0/t1b 0.27266f
C302 carry_0/g30_xp1 pg3_0/t3b 0.00599f
C303 carry_0/g3_0b pg3_0/g3b 0.08892f
C304 pg2_0/p2b carry_0/t1_0 0.00113f
C305 pg2_0/t2b carry_0/t2_0b 0.04132f
C306 vdd sum3_0/x3_cb 0.1959f
C307 gnd a3 0.00266f
C308 pg2_0/p2b sum3_0/c3 0.00472f
C309 sum2_0/x2_s1xp1 sum2_0/c2 0.00589f
C310 pg2_0/aoi2_xp1 vdd 0.55295f
C311 carry_0/g1_0 carry_0/g10_xn1 0.3477f
C312 gnd sum1_0/a_34_15# 0
C313 carry_0/t1_0 pg0_0/p0b 0.00394f
C314 carry_0/c2_xn1 sum2_0/c2 0.41817f
C315 carry_0/c3_xn1 c0 0.03258f
C316 carry_0/t2 vdd 0.69668f
C317 sum1_0/c1 sum0_0/a_34_10# 0
C318 pg0_0/aoi0_xp1 vdd 0.28719f
C319 pg1_0/oai1_xn1 pg1_0/p1 0.19846f
C320 a1 pg1_0/g1b 1.06233f
C321 carry_0/g3_2 pg3_0/t3b 0.03667f
C322 pg2_0/p2 carry_0/g1_0 0.00114f
C323 pg2_0/g2b carry_0/t1_0 0.02716f
C324 sum2_0/a_16_19# s2 0
C325 sum3_0/c3 s3 0.02365f
C326 gnd pg3_0/a_70_15# 0
C327 vdd pg3_0/p3 0.40059f
C328 pg2_0/g2b sum3_0/c3 0.01062f
C329 pg2_0/p2b sum2_0/c2 0.01832f
C330 carry_0/a_250_15# pg1_0/p1 0
C331 carry_0/t2 carry_0/g2_0b 0.04213f
C332 carry_0/g1_0 carry_0/g3_0b 0.02348f
C333 carry_0/t1_0 carry_0/t3_2 1.18118f
C334 carry_0/c0b carry_0/g10_xn1 0.15648f
C335 gnd sum1_0/x1_cb 0.05225f
C336 pg3_0/p3b sum3_0/x3_s1xp1 0.27667f
C337 carry_0/g1_0 pg0_0/p0 0.00234f
C338 carry_0/t3_2 sum3_0/c3 0.00693f
C339 carry_0/g1_0b vdd 0.19837f
C340 carry_0/c2_xn1 c0 0.03258f
C341 sum1_0/c1 sum0_0/x0_cb 0.00793f
C342 c0 sum0_0/x0_s1xp1 0.00735f
C343 c4 vdd 0.27679f
C344 pg1_0/a_106_103# pg1_0/p1 0.00288f
C345 pg1_0/oai1_xn1 b1 0.21867f
C346 carry_0/t3_0b pg3_0/g3b 0.17949f
C347 pg2_0/p2 carry_0/c0b 0.00113f
C348 vdd b3 0.08128f
C349 sum0_0/a_16_10# s0 0
C350 pg2_0/p2b c0 0.00528f
C351 pg2_0/g2b sum2_0/c2 0
C352 carry_0/g10_xn1 pg1_0/t1b 0.01355f
C353 carry_0/g2 carry_0/t2 0.40008f
C354 carry_0/c0b carry_0/g3_0b 0.16568f
C355 gnd pg1_0/p1 0.0425f
C356 carry_0/c0b pg0_0/p0 0
C357 carry_0/t1_0 vdd 0.11961f
C358 sum1_0/c1 pg0_0/p0 0.00451f
C359 c0 pg0_0/p0b 0.02403f
C360 sum3_0/c3 vdd 0.47834f
C361 pg1_0/a_43_103# pg1_0/t1b 0.00221f
C362 pg2_0/g2b pg1_0/p1b 0.00639f
C363 pg2_0/t2b pg1_0/p1 0.00528f
C364 pg2_0/p2b pg1_0/g1b 0.00473f
C365 carry_0/c4g_xn1 gnd 0.39643f
C366 sum3_0/c3 sum3_0/a_16_25# 0
C367 gnd s0 0.04131f
C368 pg2_0/g2b c0 0.02278f
C369 pg2_0/p2b carry_0/a_412_27# 0
C370 carry_0/t1_0 carry_0/g2_0b 0.03812f
C371 carry_0/t2_0b carry_0/t2 0.02524f
C372 pg0_0/p0b pg1_0/g1b 0.00114f
C373 pg0_0/p0 pg1_0/t1b 0.00572f
C374 vdd sum1_0/x1_s1xp1 0.68564f
C375 gnd b1 0.00783f
C376 pg3_0/t3b pg3_0/p3 0.60628f
C377 pg3_0/g3b pg3_0/p3b 0.08454f
C378 carry_0/g2_0b sum3_0/c3 0.124f
C379 carry_0/a_70_148# vdd 0.00113f
C380 carry_0/t3_2 c0 0.05054f
C381 c0 pg0_0/g0b 0.01801f
C382 sum2_0/c2 vdd 0.48744f
C383 carry_0/g32_xn1 gnd 0.13223f
C384 pg2_0/g2b pg1_0/g1b 0.02977f
C385 sum2_0/x2_cb sum2_0/x2_s1xp1 0.01314f
C386 vdd pg3_0/a_106_103# 0
C387 carry_0/t3_2 pg1_0/g1b 0.0355f
C388 pg2_0/t2b carry_0/g32_xn1 0.00111f
C389 carry_0/c0b carry_0/t3_0b 0.47836f
C390 carry_0/t1_0 carry_0/g2 0.49291f
C391 carry_0/g1_0 carry_0/g20_xp1 0.01377f
C392 vdd pg1_0/p1b 0.18654f
C393 gnd pg1_0/oai1_xn1 0.06612f
C394 a3 pg3_0/p3 0.03077f
C395 b3 pg3_0/t3b 0.88476f
C396 pg0_0/g0b pg1_0/g1b 0.38198f
C397 sum2_0/a_16_19# gnd 0
C398 c0 vdd 0.08372f
C399 carry_0/a_250_15# gnd 0
C400 carry_0/t1_0 pg3_0/t3b 0.019f
C401 pg2_0/p2 sum2_0/x2_s1xp1 0.00591f
C402 pg2_0/p2b sum2_0/x2_cb 0.26268f
C403 sum3_0/c3 pg3_0/t3b 0
C404 sum0_0/x0_cb sum0_0/x0_s1xp1 0.01459f
C405 gnd sum0_0/a_16_10# 0
C406 sum1_0/a_16_15# s1 0
C407 carry_0/g2_0b pg1_0/p1b 0.00163f
C408 carry_0/t1_0 carry_0/t2_0b 0.41362f
C409 pg3_0/a_70_15# pg3_0/p3 0
C410 a3 b3 1.92216f
C411 vdd pg1_0/g1b 0.70046f
C412 carry_0/g2_0b c0 0.04166f
C413 carry_0/g2 sum2_0/c2 0.38923f
C414 carry_0/t3_0b carry_0/a_439_27# 0
C415 carry_0/g3_2 carry_0/g32_xn1 0.60189f
C416 carry_0/g1_0 pg3_0/g3b 0.01852f
C417 carry_0/c1_xn1 gnd 0.16512f
C418 pg2_0/p2 pg2_0/p2b 0.25546f
C419 pg0_0/p0 sum0_0/x0_s1xp1 0.00737f
C420 pg0_0/p0b sum0_0/x0_cb 0.26268f
C421 carry_0/t2 pg1_0/p1 0.00122f
C422 carry_0/g2_0b pg1_0/g1b 0.04132f
C423 pg2_0/p2b carry_0/g3_0b 0.0032f
C424 carry_0/a_106_148# carry_0/t1_0 0.00176f
C425 carry_0/g1_0 carry_0/t1_0b 0.01912f
C426 sum1_0/c1 s1 0.02334f
C427 pg3_0/oai3_xn1 a3 0.02124f
C428 pg3_0/a_16_15# pg3_0/g3b 0
C429 pg3_0/aoi3_xp1 pg3_0/p3 0.67759f
C430 carry_0/g2 c0 0.02508f
C431 pg2_0/t2b gnd 0.30411f
C432 carry_0/c0b pg3_0/g3b 0.02012f
C433 carry_0/g10_xn1 pg0_0/g0b 0.01227f
C434 carry_0/c1_xn1 pg0_0/t0b 0.21053f
C435 b2 pg2_0/p2b 0.02536f
C436 pg2_0/g2b pg2_0/p2 0.1561f
C437 pg0_0/p0 pg0_0/p0b 0.79725f
C438 pg0_0/t0b gnd 0.40095f
C439 c0 pg3_0/t3b 0.02345f
C440 carry_0/c4g_xn1 pg3_0/p3 0
C441 carry_0/t2_0b pg1_0/p1b 0.04634f
C442 carry_0/g2 pg1_0/g1b 0.02529f
C443 pg2_0/p2 carry_0/t3_2 0.00431f
C444 carry_0/c0b carry_0/t1_0b 0.47874f
C445 pg3_0/aoi3_xp1 b3 0.01377f
C446 carry_0/t2_0b c0 0.02508f
C447 sum2_0/x2_cb vdd 0.23749f
C448 a2 gnd 0.00274f
C449 carry_0/t3_2 carry_0/g3_0b 0.73625f
C450 pg3_0/t3b pg1_0/g1b 0.01817f
C451 carry_0/g3_2 gnd 0.00105f
C452 carry_0/c4g_xn1 c4 0.33845f
C453 pg2_0/oai2_xn1 pg2_0/p2b 0.7597f
C454 a2 pg2_0/t2b 0.05415f
C455 b2 pg2_0/g2b 0.28588f
C456 vdd sum0_0/x0_cb 0.11378f
C457 b0 pg0_0/p0b 0.02346f
C458 pg0_0/g0b pg0_0/p0 0.1561f
C459 a0 gnd 0.00307f
C460 sum1_0/x1_cb sum1_0/x1_s1xp1 0.01378f
C461 carry_0/t1_0b pg1_0/t1b 0.00701f
C462 carry_0/t1_0 pg1_0/p1 0.00113f
C463 carry_0/a_439_27# pg3_0/g3b 0.00215f
C464 carry_0/a_412_27# pg3_0/t3b 0.00215f
C465 carry_0/t2_0b pg1_0/g1b 0.04132f
C466 pg2_0/t2b carry_0/g3_2 0.53053f
C467 carry_0/c0b carry_0/g1_0 0.12311f
C468 vdd pg1_0/a_43_103# 0.00193f
C469 gnd sum3_0/a_34_25# 0
C470 pg2_0/a_70_19# gnd 0
C471 pg2_0/p2 vdd 0.31795f
C472 carry_0/a_376_148# carry_0/t3_2 0
C473 carry_0/g3_2 carry_0/g30_xp1 0.00758f
C474 carry_0/g3_0b vdd 0.03188f
C475 pg2_0/a_106_103# pg2_0/p2b 0
C476 pg2_0/oai2_xn1 pg2_0/g2b 0.16049f
C477 pg0_0/a_70_27# gnd 0
C478 vdd pg0_0/p0 0.20592f
C479 pg0_0/oai0_xn1 pg0_0/p0b 0.6277f
C480 a0 pg0_0/t0b 0.04862f
C481 b0 pg0_0/g0b 0.28673f
C482 pg1_0/p1 sum1_0/x1_s1xp1 0.00656f
C483 pg1_0/p1b sum1_0/x1_cb 0.26268f
C484 carry_0/g1_0 pg1_0/t1b 0.02712f
C485 sum2_0/c2 pg1_0/p1 0.07332f
C486 gnd sum3_0/x3_cb 0.08418f
C487 carry_0/c0b sum1_0/c1 0.09326f
C488 s2 sum2_0/c2 0.02396f
C489 b2 vdd 0.08104f
C490 carry_0/t3_0b carry_0/t3_2 0.02286f
C491 carry_0/t2_0b carry_0/a_277_10# 0
C492 carry_0/t1_0 carry_0/g32_xn1 0.25556f
C493 sum3_0/x3_s1xp1 s3 0.73156f
C494 carry_0/t2 gnd 0.33396f
C495 carry_0/a_376_148# vdd 0
C496 carry_0/g32_xn1 sum3_0/c3 0.29654f
C497 pg2_0/aoi2_xp1 pg2_0/t2b 0.36848f
C498 vdd b0 0.07975f
C499 pg0_0/a_106_103# pg0_0/p0b 0.00475f
C500 pg0_0/oai0_xn1 pg0_0/g0b 0.15985f
C501 pg1_0/p1 pg1_0/p1b 0.26666f
C502 carry_0/c0b pg1_0/t1b 0.01979f
C503 pg2_0/t2b carry_0/t2 0.04942f
C504 c0 pg1_0/p1 0.0054f
C505 gnd pg3_0/p3 0.08539f
C506 carry_0/t1_0b carry_0/c2_xn1 0.12525f
C507 carry_0/g1_0 carry_0/c3_xn1 0.23789f
C508 pg3_0/p3b s3 0.09188f
C509 pg2_0/p2 pg3_0/t3b 0.00504f
C510 pg2_0/p2b pg3_0/g3b 0
C511 carry_0/c4g_xn1 c0 0.27014f
C512 carry_0/t3_0b vdd 0.23912f
C513 carry_0/g1_0b gnd 0.08369f
C514 pg2_0/aoi2_xp1 a2 0.01312f
C515 c0 s0 0.02904f
C516 pg0_0/aoi0_xp1 pg0_0/t0b 0.23914f
C517 b1 pg1_0/p1b 0.02342f
C518 pg1_0/g1b pg1_0/p1 0.16138f
C519 carry_0/g3_0b pg3_0/t3b 0.01248f
C520 vdd sum3_0/x3_s1xp1 0.35344f
C521 gnd b3 0.00735f
C522 pg2_0/a_106_103# vdd 0
C523 carry_0/g1_0 carry_0/c2_xn1 0.23789f
C524 carry_0/c0b carry_0/c3_xn1 0.16883f
C525 pg2_0/g2b pg3_0/g3b 0.38194f
C526 carry_0/t1_0 gnd 0.27166f
C527 carry_0/g32_xn1 c0 0.0314f
C528 carry_0/g20_xp1 vdd 0.35503f
C529 pg0_0/a_106_103# vdd 0
C530 pg0_0/aoi0_xp1 a0 0.01183f
C531 sum3_0/c3 gnd 0.04966f
C532 pg1_0/oai1_xn1 pg1_0/p1b 0.62751f
C533 a1 pg1_0/t1b 0.05107f
C534 b1 pg1_0/g1b 0.28588f
C535 carry_0/t3_2 pg3_0/g3b 0.09785f
C536 pg2_0/p2b carry_0/g1_0 0
C537 pg2_0/t2b carry_0/t1_0 0.02718f
C538 sum2_0/a_34_19# s2 0
C539 vdd pg3_0/p3b 0.38422f
C540 gnd pg3_0/oai3_xn1 0.16529f
C541 pg2_0/t2b sum3_0/c3 0.01687f
C542 carry_0/g20_xp1 carry_0/g2_0b 1.17684f
C543 carry_0/c0b carry_0/c2_xn1 0.16915f
C544 vdd s1 0.01194f
C545 carry_0/g1_0 pg0_0/p0b 0.00114f
C546 carry_0/g30_xp1 sum3_0/c3 0.02176f
C547 carry_0/a_106_148# pg0_0/p0 0
C548 carry_0/a_169_148# vdd 0.00113f
C549 carry_0/t1_0 pg0_0/t0b 0.21833f
C550 sum2_0/c2 gnd 0.04635f
C551 pg1_0/a_106_103# pg1_0/p1b 0
C552 pg1_0/oai1_xn1 pg1_0/g1b 0.15985f
C553 pg2_0/p2b carry_0/c0b 0.00113f
C554 pg2_0/g2b carry_0/g1_0 0.02745f
C555 sum2_0/x2_cb s2 0.08563f
C556 sum0_0/a_34_10# s0 0
C557 vdd pg3_0/g3b 0.57751f
C558 carry_0/c2_xn1 pg1_0/t1b 0.01336f
C559 carry_0/t1_0 carry_0/g3_2 0.01797f
C560 carry_0/g2 carry_0/g20_xp1 0.00652f
C561 carry_0/g1_0 carry_0/t3_2 0.4181f
C562 gnd pg1_0/p1b 0.00307f
C563 pg3_0/p3 sum3_0/x3_cb 0.01812f
C564 carry_0/c0b pg0_0/p0b 0.00113f
C565 carry_0/g3_2 sum3_0/c3 0.00918f
C566 carry_0/c1_xn1 c0 0.25595f
C567 carry_0/t1_0b vdd 0.54765f
C568 carry_0/g1_0 pg0_0/g0b 0.01786f
C569 sum1_0/c1 pg0_0/p0b 0.00506f
C570 c0 gnd 0.00783f
C571 pg1_0/aoi1_xp1 pg1_0/t1b 0.23232f
C572 pg2_0/t2b pg1_0/p1b 0.00461f
C573 pg2_0/g2b carry_0/c0b 0.0276f
C574 pg2_0/p2 s2 0.15917f
C575 sum0_0/x0_cb s0 0.0858f
C576 pg2_0/t2b c0 0.0231f
C577 carry_0/c0b carry_0/t3_2 0.1748f
C578 carry_0/t2_0b carry_0/g20_xp1 0.3003f
C579 pg0_0/p0b pg1_0/t1b 0.00511f
C580 gnd pg1_0/g1b 0.05144f
C581 carry_0/a_304_148# sum3_0/c3 0.00142f
C582 carry_0/g1_0 vdd 0.48536f
C583 carry_0/c0b pg0_0/g0b 0.39994f
C584 sum1_0/c1 pg0_0/g0b 0.11073f
C585 c0 pg0_0/t0b 0.01806f
C586 carry_0/g3_0b carry_0/c4g_xn1 0.00464f
C587 pg1_0/aoi1_xp1 a1 0.01183f
C588 pg2_0/g2b pg1_0/t1b 0.27327f
C589 carry_0/a_412_27# gnd 0
C590 pg2_0/t2b pg1_0/g1b 1.94182f
C591 c4 pg3_0/p3 0.01995f
C592 sum3_0/c3 sum3_0/x3_cb 0.72334f
C593 pg0_0/p0 s0 0.15972f
C594 carry_0/g30_xp1 pg1_0/g1b 0.03248f
C595 carry_0/g1_0 carry_0/g2_0b 0.04581f
C596 carry_0/t1_0 carry_0/t2 0.41885f
C597 a3 pg3_0/p3b 0.00745f
C598 b3 pg3_0/p3 0.02799f
C599 pg3_0/g3b pg3_0/t3b 0.35361f
C600 pg0_0/t0b pg1_0/g1b 0.01852f
C601 pg0_0/g0b pg1_0/t1b 0.55393f
C602 carry_0/g3_2 c0 0.02449f
C603 carry_0/c0b vdd 0.2555f
C604 sum2_0/a_34_19# gnd 0
C605 sum1_0/c1 vdd 0.23795f
C606 pg2_0/g2b a1 0.00136f
C607 carry_0/a_277_10# gnd 0
C608 pg2_0/p2b sum2_0/x2_s1xp1 0.27763f
C609 sum3_0/c3 pg3_0/p3 0.59374f
C610 vdd pg3_0/a_43_103# 0.00113f
C611 gnd sum0_0/a_34_10# 0
C612 sum1_0/a_34_15# s1 0
C613 carry_0/g3_2 pg1_0/g1b 0.02578f
C614 carry_0/t1_0 carry_0/g1_0b 1.34505f
C615 pg2_0/g2b carry_0/c3_xn1 0.25633f
C616 carry_0/c0b carry_0/g2_0b 0.55533f
C617 carry_0/g1_0 carry_0/g2 0.01874f
C618 gnd pg1_0/a_16_10# 0
C619 pg3_0/oai3_xn1 pg3_0/p3 0.24705f
C620 a3 pg3_0/g3b 1.06186f
C621 vdd pg1_0/t1b 0.14103f
C622 carry_0/t2 sum2_0/c2 0.00114f
C623 sum2_0/x2_cb gnd 0.1012f
C624 carry_0/t3_0b carry_0/c4g_xn1 0.01188f
C625 carry_0/g1_0 pg3_0/t3b 0.44209f
C626 carry_0/g10_xn1 gnd 0.70201f
C627 gnd sum0_0/x0_cb 0.04512f
C628 pg0_0/p0b sum0_0/x0_s1xp1 0.27909f
C629 sum1_0/x1_cb s1 0.085f
C630 carry_0/t2 pg1_0/p1b 0
C631 carry_0/g20_xp1 pg1_0/p1 0.01383f
C632 carry_0/c0b carry_0/g2 0.08731f
C633 carry_0/g1_0 carry_0/t2_0b 0.02853f
C634 vdd a1 0.09017f
C635 pg3_0/oai3_xn1 b3 0.21964f
C636 carry_0/g1_0b sum2_0/c2 0.01968f
C637 carry_0/t2 c0 0.03455f
C638 carry_0/t1_0 sum3_0/c3 0.00941f
C639 pg2_0/p2 gnd 0.07523f
C640 s1 0 0.54449f
C641 sum1_0/x1_s1xp1 0 0.29934f ; **FLOATING
C642 sum1_0/x1_cb 0 1.17812f ; **FLOATING
C643 pg1_0/p1b 0 0.81104f
C644 pg1_0/p1 0 1.24433f
C645 pg1_0/t1b 0 2.51924f
C646 pg1_0/g1b 0 3.47847f
C647 b1 0 1.26267f
C648 a1 0 1.50261f
C649 pg1_0/oai1_xn1 0 0.26111f ; **FLOATING
C650 pg1_0/aoi1_xp1 0 0.12668f ; **FLOATING
C651 s3 0 0.52634f
C652 sum3_0/x3_s1xp1 0 0.29934f ; **FLOATING
C653 sum3_0/x3_cb 0 1.18305f ; **FLOATING
C654 pg3_0/p3b 0 0.97767f
C655 pg3_0/p3 0 1.24026f
C656 pg3_0/t3b 0 2.40373f
C657 pg3_0/g3b 0 3.08847f
C658 b3 0 1.26222f
C659 a3 0 1.50215f
C660 pg3_0/oai3_xn1 0 0.26725f ; **FLOATING
C661 pg3_0/aoi3_xp1 0 0.12668f ; **FLOATING
C662 s0 0 0.5462f
C663 sum0_0/x0_s1xp1 0 0.29158f ; **FLOATING
C664 sum0_0/x0_cb 0 1.17429f ; **FLOATING
C665 gnd 0 11.95407f
C666 pg0_0/p0b 0 0.94028f
C667 pg0_0/p0 0 1.22417f
C668 pg0_0/t0b 0 2.59657f
C669 pg0_0/g0b 0 3.02149f
C670 b0 0 1.26176f
C671 a0 0 1.50169f
C672 vdd 0 0.15017p
C673 pg0_0/oai0_xn1 0 0.26111f ; **FLOATING
C674 pg0_0/aoi0_xp1 0 0.12668f ; **FLOATING
C675 c4 0 1.24965f
C676 sum3_0/c3 0 1.79798f
C677 sum2_0/c2 0 1.54347f
C678 sum1_0/c1 0 1.967f
C679 c0 0 2.73752f
C680 carry_0/c4g_xn1 0 0.58741f ; **FLOATING
C681 carry_0/g32_xn1 0 0.2454f ; **FLOATING
C682 carry_0/c3_xn1 0 0.85963f ; **FLOATING
C683 carry_0/c2_xn1 0 1.01166f ; **FLOATING
C684 carry_0/g10_xn1 0 0.53635f ; **FLOATING
C685 carry_0/c1_xn1 0 0.35838f ; **FLOATING
C686 carry_0/g3_0b 0 1.26937f ; **FLOATING
C687 carry_0/g30_xp1 0 0.33358f ; **FLOATING
C688 carry_0/t3_2 0 2.33437f ; **FLOATING
C689 carry_0/g3_2 0 1.42885f ; **FLOATING
C690 carry_0/t3_0b 0 1.573f ; **FLOATING
C691 carry_0/g2_0b 0 2.19989f ; **FLOATING
C692 carry_0/g20_xp1 0 0.04344f ; **FLOATING
C693 carry_0/t2 0 2.03356f ; **FLOATING
C694 carry_0/g2 0 1.34429f ; **FLOATING
C695 carry_0/g1_0b 0 1.26245f ; **FLOATING
C696 carry_0/t2_0b 0 1.92421f ; **FLOATING
C697 carry_0/t1_0b 0 1.81245f ; **FLOATING
C698 carry_0/t1_0 0 3.16093f ; **FLOATING
C699 carry_0/g1_0 0 3.33299f ; **FLOATING
C700 carry_0/c0b 0 3.54657f ; **FLOATING
C701 s2 0 0.5389f
C702 sum2_0/x2_s1xp1 0 0.29934f ; **FLOATING
C703 sum2_0/x2_cb 0 1.19568f ; **FLOATING
C704 pg2_0/p2b 0 0.91722f
C705 pg2_0/p2 0 1.24063f
C706 pg2_0/t2b 0 2.79729f
C707 pg2_0/g2b 0 3.47619f
C708 b2 0 1.26313f
C709 a2 0 1.50306f
C710 pg2_0/oai2_xn1 0 0.2652f ; **FLOATING
C711 pg2_0/aoi2_xp1 0 0.12668f ; **FLOATING
.ends

.subckt final_post_post a0 a1 a2 a3 b0 b1 b2 b3 c0 s0 s1 s2 s3 c4 vdd gnd
X0 a0 a1 a2 a3 b0 b1 b2 b3 c0 c4 s0 s1 s2 s3 vdd gnd top_final_C4_aoi22_1
.ends
.subckt tb_inv a y vdd gnd
mp y a vdd vdd CMOSP W=1.8e-06 L=1.8e-07 AS=9.72e-13 PS=4.68e-06 AD=9.72e-13 PD=4.68e-06
mn y a gnd gnd CMOSN W=9.0e-07 L=1.8e-07 AS=4.86e-13 PS=2.88e-06 AD=4.86e-13 PD=2.88e-06
.ends
Va0 src_a0 gnd PWL(
+ 0.00000e+00 1.800 7.68000e-07 1.800 7.68050e-07 0.000 1.54200e-06 0.000 1.54205e-06 1.800 1.54500e-06 1.800
+ 1.54505e-06 0.000 1.54800e-06 0.000 1.54805e-06 1.800 1.55400e-06 1.800 1.55405e-06 0.000 1.56600e-06 0.000
+ 1.56605e-06 1.800 1.56900e-06 1.800 1.56905e-06 0.000 1.57200e-06 0.000 1.57205e-06 1.800 1.58100e-06 1.800
+ 1.58105e-06 0.000 1.58400e-06 0.000 1.58405e-06 1.800 1.59000e-06 1.800 1.59005e-06 0.000 1.59300e-06 0.000
+ 1.59305e-06 1.800 1.60800e-06 1.800 1.60805e-06 0.000 1.61100e-06 0.000 1.61105e-06 1.800 1.61700e-06 1.800
+ 1.61705e-06 0.000 1.62300e-06 0.000 1.62305e-06 1.800 1.62600e-06 1.800 1.62605e-06 0.000 1.63200e-06 0.000
+ 1.63205e-06 1.800 1.63500e-06 1.800 1.63505e-06 0.000 1.63800e-06 0.000 1.63805e-06 1.800 1.64100e-06 1.800
+ 1.64105e-06 0.000 1.64700e-06 0.000 1.64705e-06 1.800 1.65000e-06 1.800 1.65005e-06 0.000 1.65600e-06 0.000
+ 1.65605e-06 1.800 1.65900e-06 1.800 1.65905e-06 0.000 1.66200e-06 0.000 1.66205e-06 1.800 1.68600e-06 1.800
+ 1.68605e-06 0.000 1.68900e-06 0.000 1.68905e-06 1.800 1.69200e-06 1.800 1.69205e-06 0.000 1.69500e-06 0.000
+ 1.69505e-06 1.800 1.71000e-06 1.800 1.71005e-06 0.000 1.71300e-06 0.000 1.71305e-06 1.800 1.71600e-06 1.800
+ 1.71605e-06 0.000 1.72200e-06 0.000 1.72205e-06 1.800 1.72800e-06 1.800 1.72805e-06 0.000 1.73100e-06 0.000
+ 1.73105e-06 1.800 1.73700e-06 1.800 1.73705e-06 0.000 1.74000e-06 0.000 1.74005e-06 1.800 1.74300e-06 1.800
+ 1.74305e-06 0.000 1.74600e-06 0.000 1.74605e-06 1.800 1.74900e-06 1.800 1.74905e-06 0.000 1.75200e-06 0.000
+ 1.75205e-06 1.800 1.75500e-06 1.800 1.75505e-06 0.000 1.76700e-06 0.000 1.76705e-06 1.800 1.77000e-06 1.800
+ 1.77005e-06 0.000 1.77300e-06 0.000 1.77305e-06 1.800 1.77600e-06 1.800 1.77605e-06 0.000 1.78200e-06 0.000
+ 1.78205e-06 1.800 1.78500e-06 1.800 1.78505e-06 0.000 1.79100e-06 0.000 1.79105e-06 1.800 1.79400e-06 1.800
+ 1.79405e-06 0.000 1.79700e-06 0.000 1.79705e-06 1.800 1.80300e-06 1.800 1.80305e-06 0.000 1.80900e-06 0.000
+ 1.80905e-06 1.800 1.82100e-06 1.800 1.82105e-06 0.000 1.82400e-06 0.000 1.82405e-06 1.800 1.82700e-06 1.800
+ 1.82705e-06 0.000 1.83000e-06 0.000 1.83005e-06 1.800 1.83300e-06 1.800 1.83305e-06 0.000 1.83600e-06 0.000
+ 1.83605e-06 1.800 1.84800e-06 1.800 1.84805e-06 0.000 1.85400e-06 0.000 1.85405e-06 1.800 1.85700e-06 1.800
+ 1.85705e-06 0.000 1.86000e-06 0.000 1.86005e-06 1.800 1.86300e-06 1.800 1.86305e-06 0.000 1.87200e-06 0.000
+ 1.87205e-06 1.800 1.88100e-06 1.800 1.88105e-06 0.000 1.89900e-06 0.000 1.89905e-06 1.800 1.90200e-06 1.800
+ 1.90205e-06 0.000 1.90500e-06 0.000 1.90505e-06 1.800 1.90800e-06 1.800 1.90805e-06 0.000 1.91100e-06 0.000
+ 1.91105e-06 1.800 1.91400e-06 1.800 1.91405e-06 0.000 1.91700e-06 0.000 1.91705e-06 1.800 1.92000e-06 1.800
+ 1.92005e-06 0.000 1.93200e-06 0.000 1.93205e-06 1.800 1.93500e-06 1.800 1.93505e-06 0.000 1.93800e-06 0.000
+ 1.93805e-06 1.800 1.95000e-06 1.800 1.95005e-06 0.000 1.95300e-06 0.000 1.95305e-06 1.800 1.96200e-06 1.800
+ 1.96205e-06 0.000 1.96800e-06 0.000 1.96805e-06 1.800 1.98000e-06 1.800 1.98005e-06 0.000 1.98300e-06 0.000
+ 1.98305e-06 1.800 1.98600e-06 1.800 1.98605e-06 0.000 1.99200e-06 0.000 1.99205e-06 1.800 1.99800e-06 1.800
+ 1.99805e-06 0.000 2.00100e-06 0.000 2.00105e-06 1.800 2.00700e-06 1.800 2.00705e-06 0.000 2.01000e-06 0.000
+ 2.01005e-06 1.800 2.01300e-06 1.800 2.01305e-06 0.000 2.01900e-06 0.000 2.01905e-06 1.800 2.02200e-06 1.800
+ 2.02205e-06 0.000 2.02800e-06 0.000 2.02805e-06 1.800 2.03400e-06 1.800 2.03405e-06 0.000 2.03700e-06 0.000
+ 2.03705e-06 1.800 2.04900e-06 1.800 2.04905e-06 0.000 2.05200e-06 0.000 2.05205e-06 1.800 2.05500e-06 1.800
+ 2.05505e-06 0.000 2.06400e-06 0.000 2.06405e-06 1.800 2.06700e-06 1.800 2.06705e-06 0.000 2.07000e-06 0.000
+ 2.07005e-06 1.800 2.07300e-06 1.800 2.07305e-06 0.000 2.07600e-06 0.000 2.07605e-06 1.800 2.07900e-06 1.800
+ 2.07905e-06 0.000 2.09100e-06 0.000 2.09105e-06 1.800 2.09700e-06 1.800 2.09705e-06 0.000 2.10000e-06 0.000
+ 2.10005e-06 1.800 2.10300e-06 1.800 2.10305e-06 0.000 2.10900e-06 0.000 2.10905e-06 1.800 2.11200e-06 1.800
+ 2.11205e-06 0.000 2.12400e-06 0.000 2.12405e-06 1.800 2.12700e-06 1.800 2.12705e-06 0.000 2.13300e-06 0.000
+ 2.13305e-06 1.800 2.14500e-06 1.800 2.14505e-06 0.000 2.14800e-06 0.000 2.14805e-06 1.800 2.15700e-06 1.800
+ 2.15705e-06 0.000 2.16600e-06 0.000 2.16605e-06 1.800 2.16900e-06 1.800 2.16905e-06 0.000 2.17200e-06 0.000
+ 2.17205e-06 1.800 2.17500e-06 1.800 2.17505e-06 0.000 2.19300e-06 0.000 2.19305e-06 1.800 2.19900e-06 1.800
+ 2.19905e-06 0.000 2.20200e-06 0.000 2.20205e-06 1.800 2.21100e-06 1.800 2.21105e-06 0.000 2.21700e-06 0.000
+ 2.21705e-06 1.800 2.22300e-06 1.800 2.22305e-06 0.000 2.22600e-06 0.000 2.22605e-06 1.800 2.22900e-06 1.800
+ 2.22905e-06 0.000 2.25600e-06 0.000 2.25605e-06 1.800 2.25900e-06 1.800 2.25905e-06 0.000 2.26200e-06 0.000
+ 2.26205e-06 1.800 2.26500e-06 1.800 2.26505e-06 0.000 2.27700e-06 0.000 2.27705e-06 1.800 2.28000e-06 1.800
+ 2.28005e-06 0.000 2.28600e-06 0.000 2.28605e-06 1.800 2.28900e-06 1.800 2.28905e-06 0.000 2.29800e-06 0.000
+ 2.29805e-06 1.800 2.30100e-06 1.800 2.30105e-06 0.000 2.31300e-06 0.000 2.31305e-06 1.800 2.31900e-06 1.800
+ 2.31905e-06 0.000 2.32200e-06 0.000 2.32205e-06 1.800 2.34000e-06 1.800 2.34005e-06 0.000 2.34600e-06 0.000
+ 2.34605e-06 1.800 2.34900e-06 1.800 2.34905e-06 0.000 2.35500e-06 0.000 2.35505e-06 1.800 2.35800e-06 1.800
+ 2.35805e-06 0.000 2.37600e-06 0.000 2.37605e-06 1.800 2.39700e-06 1.800 2.39705e-06 0.000 2.40600e-06 0.000
+ 2.40605e-06 1.800 2.40900e-06 1.800 2.40905e-06 0.000 2.41200e-06 0.000 2.41205e-06 1.800 2.45400e-06 1.800
+ 2.45405e-06 0.000 2.46300e-06 0.000 2.46305e-06 1.800 2.47200e-06 1.800 2.47205e-06 0.000 2.47800e-06 0.000
+ 2.47805e-06 1.800 2.48400e-06 1.800 2.48405e-06 0.000 2.48700e-06 0.000 2.48705e-06 1.800 2.51100e-06 1.800
+ 2.51105e-06 0.000 2.51700e-06 0.000 2.51705e-06 1.800 2.52300e-06 1.800 2.52305e-06 0.000 2.52900e-06 0.000
+ 2.52905e-06 1.800 2.53200e-06 1.800 2.53205e-06 0.000 2.54400e-06 0.000 2.54405e-06 1.800 2.55000e-06 1.800
+ 2.55005e-06 0.000 2.56200e-06 0.000 2.56205e-06 1.800 2.56800e-06 1.800 2.56805e-06 0.000 2.57100e-06 0.000
+ 2.57105e-06 1.800 2.58000e-06 1.800 2.58005e-06 0.000 2.59200e-06 0.000 2.59205e-06 1.800 2.60700e-06 1.800
+ 2.60705e-06 0.000 2.61300e-06 0.000 2.61305e-06 1.800 2.61600e-06 1.800 2.61605e-06 0.000 2.61900e-06 0.000
+ 2.61905e-06 1.800 2.62500e-06 1.800 2.62505e-06 0.000 2.64000e-06 0.000 2.64005e-06 1.800 2.64300e-06 1.800
+ 2.64305e-06 0.000 2.65200e-06 0.000 2.65205e-06 1.800 2.65500e-06 1.800 2.65505e-06 0.000 2.66400e-06 0.000
+ 2.66405e-06 1.800 2.67300e-06 1.800 2.67305e-06 0.000 2.67600e-06 0.000 2.67605e-06 1.800 2.68200e-06 1.800
+ 2.68205e-06 0.000 2.70000e-06 0.000 2.70005e-06 1.800 2.70900e-06 1.800 2.70905e-06 0.000 2.71500e-06 0.000
+ 2.71505e-06 1.800 2.72100e-06 1.800 2.72105e-06 0.000 2.72700e-06 0.000 2.72705e-06 1.800 2.73000e-06 1.800
+ 2.73005e-06 0.000 2.73300e-06 0.000 2.73305e-06 1.800 2.73600e-06 1.800 2.73605e-06 0.000 2.74500e-06 0.000
+ 2.74505e-06 1.800 2.75100e-06 1.800 2.75105e-06 0.000 2.76600e-06 0.000 2.76605e-06 1.800 2.77200e-06 1.800
+ 2.77205e-06 0.000 2.77500e-06 0.000 2.77505e-06 1.800 2.78100e-06 1.800 2.78105e-06 0.000 2.78700e-06 0.000
+ 2.78705e-06 1.800 2.79600e-06 1.800 2.79605e-06 0.000 2.79900e-06 0.000 2.79905e-06 1.800 2.80200e-06 1.800
+ 2.80205e-06 0.000 2.80500e-06 0.000 2.80505e-06 1.800 2.80800e-06 1.800 2.80805e-06 0.000 2.81100e-06 0.000
+ 2.81105e-06 1.800 2.82000e-06 1.800 2.82005e-06 0.000 2.84100e-06 0.000 2.84105e-06 1.800 2.84400e-06 1.800
+ 2.84405e-06 0.000 2.84700e-06 0.000 2.84705e-06 1.800 2.85300e-06 1.800 2.85305e-06 0.000 2.85900e-06 0.000
+ 2.85905e-06 1.800 2.86500e-06 1.800 2.86505e-06 0.000 2.87400e-06 0.000 2.87405e-06 1.800 2.87700e-06 1.800
+ 2.87705e-06 0.000 2.88000e-06 0.000 2.88005e-06 1.800 2.88600e-06 1.800 2.88605e-06 0.000 2.88900e-06 0.000
+ 2.88905e-06 1.800 2.89200e-06 1.800 2.89205e-06 0.000 2.89500e-06 0.000 2.89505e-06 1.800 2.90400e-06 1.800
+ 2.90405e-06 0.000 2.91000e-06 0.000 2.91005e-06 1.800 2.91300e-06 1.800 2.91305e-06 0.000 2.91600e-06 0.000
+ 2.91605e-06 1.800 2.91900e-06 1.800 2.91905e-06 0.000 2.92800e-06 0.000 2.92805e-06 1.800 2.93400e-06 1.800
+ 2.93405e-06 0.000 2.93700e-06 0.000 2.93705e-06 1.800 2.94000e-06 1.800 2.94005e-06 0.000 2.94300e-06 0.000
+ 2.94305e-06 1.800 2.94600e-06 1.800 2.94605e-06 0.000 2.95200e-06 0.000 2.95205e-06 1.800 2.96400e-06 1.800
+ 2.96405e-06 0.000 2.96700e-06 0.000 2.96705e-06 1.800 2.97000e-06 1.800 2.97005e-06 0.000 2.97300e-06 0.000
+ 2.97305e-06 1.800 2.97600e-06 1.800 2.97605e-06 0.000 2.98200e-06 0.000 2.98205e-06 1.800 2.98800e-06 1.800
+ 2.98805e-06 0.000 2.99100e-06 0.000 2.99105e-06 1.800 2.99400e-06 1.800 2.99405e-06 0.000 3.00300e-06 0.000
+ 3.00305e-06 1.800 3.00900e-06 1.800 3.00905e-06 0.000 3.01500e-06 0.000 3.01505e-06 1.800 3.02700e-06 1.800
+ 3.02705e-06 0.000 3.03000e-06 0.000 3.03005e-06 1.800 3.03300e-06 1.800 3.03305e-06 0.000 3.03600e-06 0.000
+ 3.03605e-06 1.800 3.04200e-06 1.800 3.04205e-06 0.000 3.04500e-06 0.000 3.04505e-06 1.800 3.05700e-06 1.800
+ 3.05705e-06 0.000 3.06900e-06 0.000 3.06905e-06 1.800 3.07200e-06 1.800
+ )
Xd_a0 src_a0 a0 vdd gnd tb_inv
Va1 src_a1 gnd PWL(
+ 0.00000e+00 1.800 3.84000e-07 1.800 3.84050e-07 0.000 7.68000e-07 0.000 7.68050e-07 1.800 1.15200e-06 1.800
+ 1.15205e-06 0.000 1.53600e-06 0.000 1.53605e-06 1.800 1.54200e-06 1.800 1.54205e-06 0.000 1.54800e-06 0.000
+ 1.54805e-06 1.800 1.55400e-06 1.800 1.55405e-06 0.000 1.55700e-06 0.000 1.55705e-06 1.800 1.56000e-06 1.800
+ 1.56005e-06 0.000 1.56300e-06 0.000 1.56305e-06 1.800 1.57500e-06 1.800 1.57505e-06 0.000 1.57800e-06 0.000
+ 1.57805e-06 1.800 1.59000e-06 1.800 1.59005e-06 0.000 1.59300e-06 0.000 1.59305e-06 1.800 1.59600e-06 1.800
+ 1.59605e-06 0.000 1.60200e-06 0.000 1.60205e-06 1.800 1.60500e-06 1.800 1.60505e-06 0.000 1.61100e-06 0.000
+ 1.61105e-06 1.800 1.62600e-06 1.800 1.62605e-06 0.000 1.63500e-06 0.000 1.63505e-06 1.800 1.63800e-06 1.800
+ 1.63805e-06 0.000 1.64100e-06 0.000 1.64105e-06 1.800 1.65000e-06 1.800 1.65005e-06 0.000 1.65600e-06 0.000
+ 1.65605e-06 1.800 1.65900e-06 1.800 1.65905e-06 0.000 1.67100e-06 0.000 1.67105e-06 1.800 1.67700e-06 1.800
+ 1.67705e-06 0.000 1.69200e-06 0.000 1.69205e-06 1.800 1.70100e-06 1.800 1.70105e-06 0.000 1.70700e-06 0.000
+ 1.70705e-06 1.800 1.71000e-06 1.800 1.71005e-06 0.000 1.71300e-06 0.000 1.71305e-06 1.800 1.71600e-06 1.800
+ 1.71605e-06 0.000 1.71900e-06 0.000 1.71905e-06 1.800 1.72200e-06 1.800 1.72205e-06 0.000 1.72800e-06 0.000
+ 1.72805e-06 1.800 1.73100e-06 1.800 1.73105e-06 0.000 1.74300e-06 0.000 1.74305e-06 1.800 1.74600e-06 1.800
+ 1.74605e-06 0.000 1.74900e-06 0.000 1.74905e-06 1.800 1.75500e-06 1.800 1.75505e-06 0.000 1.76400e-06 0.000
+ 1.76405e-06 1.800 1.76700e-06 1.800 1.76705e-06 0.000 1.77300e-06 0.000 1.77305e-06 1.800 1.77900e-06 1.800
+ 1.77905e-06 0.000 1.78200e-06 0.000 1.78205e-06 1.800 1.79100e-06 1.800 1.79105e-06 0.000 1.79400e-06 0.000
+ 1.79405e-06 1.800 1.79700e-06 1.800 1.79705e-06 0.000 1.80300e-06 0.000 1.80305e-06 1.800 1.80900e-06 1.800
+ 1.80905e-06 0.000 1.81200e-06 0.000 1.81205e-06 1.800 1.81800e-06 1.800 1.81805e-06 0.000 1.82400e-06 0.000
+ 1.82405e-06 1.800 1.82700e-06 1.800 1.82705e-06 0.000 1.83000e-06 0.000 1.83005e-06 1.800 1.83300e-06 1.800
+ 1.83305e-06 0.000 1.83900e-06 0.000 1.83905e-06 1.800 1.84500e-06 1.800 1.84505e-06 0.000 1.84800e-06 0.000
+ 1.84805e-06 1.800 1.85400e-06 1.800 1.85405e-06 0.000 1.86000e-06 0.000 1.86005e-06 1.800 1.86300e-06 1.800
+ 1.86305e-06 0.000 1.86600e-06 0.000 1.86605e-06 1.800 1.87200e-06 1.800 1.87205e-06 0.000 1.87500e-06 0.000
+ 1.87505e-06 1.800 1.89000e-06 1.800 1.89005e-06 0.000 1.89300e-06 0.000 1.89305e-06 1.800 1.89600e-06 1.800
+ 1.89605e-06 0.000 1.90200e-06 0.000 1.90205e-06 1.800 1.90500e-06 1.800 1.90505e-06 0.000 1.90800e-06 0.000
+ 1.90805e-06 1.800 1.91100e-06 1.800 1.91105e-06 0.000 1.91400e-06 0.000 1.91405e-06 1.800 1.92300e-06 1.800
+ 1.92305e-06 0.000 1.93800e-06 0.000 1.93805e-06 1.800 1.94100e-06 1.800 1.94105e-06 0.000 1.94400e-06 0.000
+ 1.94405e-06 1.800 1.94700e-06 1.800 1.94705e-06 0.000 1.95300e-06 0.000 1.95305e-06 1.800 1.95900e-06 1.800
+ 1.95905e-06 0.000 1.97100e-06 0.000 1.97105e-06 1.800 1.97400e-06 1.800 1.97405e-06 0.000 1.97700e-06 0.000
+ 1.97705e-06 1.800 1.98000e-06 1.800 1.98005e-06 0.000 1.98300e-06 0.000 1.98305e-06 1.800 1.99500e-06 1.800
+ 1.99505e-06 0.000 1.99800e-06 0.000 1.99805e-06 1.800 2.00100e-06 1.800 2.00105e-06 0.000 2.01000e-06 0.000
+ 2.01005e-06 1.800 2.01300e-06 1.800 2.01305e-06 0.000 2.01600e-06 0.000 2.01605e-06 1.800 2.02200e-06 1.800
+ 2.02205e-06 0.000 2.03400e-06 0.000 2.03405e-06 1.800 2.03700e-06 1.800 2.03705e-06 0.000 2.04000e-06 0.000
+ 2.04005e-06 1.800 2.04300e-06 1.800 2.04305e-06 0.000 2.04900e-06 0.000 2.04905e-06 1.800 2.06100e-06 1.800
+ 2.06105e-06 0.000 2.06400e-06 0.000 2.06405e-06 1.800 2.07000e-06 1.800 2.07005e-06 0.000 2.07300e-06 0.000
+ 2.07305e-06 1.800 2.07600e-06 1.800 2.07605e-06 0.000 2.07900e-06 0.000 2.07905e-06 1.800 2.08500e-06 1.800
+ 2.08505e-06 0.000 2.09400e-06 0.000 2.09405e-06 1.800 2.10000e-06 1.800 2.10005e-06 0.000 2.10300e-06 0.000
+ 2.10305e-06 1.800 2.10600e-06 1.800 2.10605e-06 0.000 2.12100e-06 0.000 2.12105e-06 1.800 2.12400e-06 1.800
+ 2.12405e-06 0.000 2.13600e-06 0.000 2.13605e-06 1.800 2.15100e-06 1.800 2.15105e-06 0.000 2.15700e-06 0.000
+ 2.15705e-06 1.800 2.16300e-06 1.800 2.16305e-06 0.000 2.16600e-06 0.000 2.16605e-06 1.800 2.16900e-06 1.800
+ 2.16905e-06 0.000 2.17200e-06 0.000 2.17205e-06 1.800 2.17800e-06 1.800 2.17805e-06 0.000 2.18700e-06 0.000
+ 2.18705e-06 1.800 2.19000e-06 1.800 2.19005e-06 0.000 2.19300e-06 0.000 2.19305e-06 1.800 2.19900e-06 1.800
+ 2.19905e-06 0.000 2.20200e-06 0.000 2.20205e-06 1.800 2.21100e-06 1.800 2.21105e-06 0.000 2.22600e-06 0.000
+ 2.22605e-06 1.800 2.22900e-06 1.800 2.22905e-06 0.000 2.23500e-06 0.000 2.23505e-06 1.800 2.23800e-06 1.800
+ 2.23805e-06 0.000 2.24100e-06 0.000 2.24105e-06 1.800 2.25000e-06 1.800 2.25005e-06 0.000 2.25900e-06 0.000
+ 2.25905e-06 1.800 2.26500e-06 1.800 2.26505e-06 0.000 2.27100e-06 0.000 2.27105e-06 1.800 2.27400e-06 1.800
+ 2.27405e-06 0.000 2.29200e-06 0.000 2.29205e-06 1.800 2.30400e-06 1.800 2.30405e-06 0.000 2.30700e-06 0.000
+ 2.30705e-06 1.800 2.31000e-06 1.800 2.31005e-06 0.000 2.31600e-06 0.000 2.31605e-06 1.800 2.32200e-06 1.800
+ 2.32205e-06 0.000 2.32500e-06 0.000 2.32505e-06 1.800 2.33400e-06 1.800 2.33405e-06 0.000 2.33700e-06 0.000
+ 2.33705e-06 1.800 2.34000e-06 1.800 2.34005e-06 0.000 2.35200e-06 0.000 2.35205e-06 1.800 2.35800e-06 1.800
+ 2.35805e-06 0.000 2.36100e-06 0.000 2.36105e-06 1.800 2.36400e-06 1.800 2.36405e-06 0.000 2.36700e-06 0.000
+ 2.36705e-06 1.800 2.37000e-06 1.800 2.37005e-06 0.000 2.37600e-06 0.000 2.37605e-06 1.800 2.38500e-06 1.800
+ 2.38505e-06 0.000 2.38800e-06 0.000 2.38805e-06 1.800 2.39700e-06 1.800 2.39705e-06 0.000 2.40300e-06 0.000
+ 2.40305e-06 1.800 2.40600e-06 1.800 2.40605e-06 0.000 2.41500e-06 0.000 2.41505e-06 1.800 2.41800e-06 1.800
+ 2.41805e-06 0.000 2.43000e-06 0.000 2.43005e-06 1.800 2.43600e-06 1.800 2.43605e-06 0.000 2.46300e-06 0.000
+ 2.46305e-06 1.800 2.47200e-06 1.800 2.47205e-06 0.000 2.47800e-06 0.000 2.47805e-06 1.800 2.49000e-06 1.800
+ 2.49005e-06 0.000 2.49300e-06 0.000 2.49305e-06 1.800 2.49600e-06 1.800 2.49605e-06 0.000 2.49900e-06 0.000
+ 2.49905e-06 1.800 2.51100e-06 1.800 2.51105e-06 0.000 2.51400e-06 0.000 2.51405e-06 1.800 2.53500e-06 1.800
+ 2.53505e-06 0.000 2.54100e-06 0.000 2.54105e-06 1.800 2.54400e-06 1.800 2.54405e-06 0.000 2.55000e-06 0.000
+ 2.55005e-06 1.800 2.55600e-06 1.800 2.55605e-06 0.000 2.55900e-06 0.000 2.55905e-06 1.800 2.56500e-06 1.800
+ 2.56505e-06 0.000 2.58300e-06 0.000 2.58305e-06 1.800 2.58600e-06 1.800 2.58605e-06 0.000 2.59800e-06 0.000
+ 2.59805e-06 1.800 2.60100e-06 1.800 2.60105e-06 0.000 2.60400e-06 0.000 2.60405e-06 1.800 2.61900e-06 1.800
+ 2.61905e-06 0.000 2.62200e-06 0.000 2.62205e-06 1.800 2.62500e-06 1.800 2.62505e-06 0.000 2.62800e-06 0.000
+ 2.62805e-06 1.800 2.63400e-06 1.800 2.63405e-06 0.000 2.64300e-06 0.000 2.64305e-06 1.800 2.64600e-06 1.800
+ 2.64605e-06 0.000 2.64900e-06 0.000 2.64905e-06 1.800 2.65200e-06 1.800 2.65205e-06 0.000 2.66100e-06 0.000
+ 2.66105e-06 1.800 2.68500e-06 1.800 2.68505e-06 0.000 2.68800e-06 0.000 2.68805e-06 1.800 2.70000e-06 1.800
+ 2.70005e-06 0.000 2.70300e-06 0.000 2.70305e-06 1.800 2.70600e-06 1.800 2.70605e-06 0.000 2.71200e-06 0.000
+ 2.71205e-06 1.800 2.71500e-06 1.800 2.71505e-06 0.000 2.72400e-06 0.000 2.72405e-06 1.800 2.73000e-06 1.800
+ 2.73005e-06 0.000 2.73300e-06 0.000 2.73305e-06 1.800 2.74200e-06 1.800 2.74205e-06 0.000 2.74500e-06 0.000
+ 2.74505e-06 1.800 2.74800e-06 1.800 2.74805e-06 0.000 2.75100e-06 0.000 2.75105e-06 1.800 2.75700e-06 1.800
+ 2.75705e-06 0.000 2.76000e-06 0.000 2.76005e-06 1.800 2.76600e-06 1.800 2.76605e-06 0.000 2.76900e-06 0.000
+ 2.76905e-06 1.800 2.77500e-06 1.800 2.77505e-06 0.000 2.78700e-06 0.000 2.78705e-06 1.800 2.79000e-06 1.800
+ 2.79005e-06 0.000 2.79300e-06 0.000 2.79305e-06 1.800 2.79900e-06 1.800 2.79905e-06 0.000 2.80200e-06 0.000
+ 2.80205e-06 1.800 2.80500e-06 1.800 2.80505e-06 0.000 2.80800e-06 0.000 2.80805e-06 1.800 2.81100e-06 1.800
+ 2.81105e-06 0.000 2.81700e-06 0.000 2.81705e-06 1.800 2.82300e-06 1.800 2.82305e-06 0.000 2.82600e-06 0.000
+ 2.82605e-06 1.800 2.82900e-06 1.800 2.82905e-06 0.000 2.83200e-06 0.000 2.83205e-06 1.800 2.83800e-06 1.800
+ 2.83805e-06 0.000 2.84400e-06 0.000 2.84405e-06 1.800 2.85000e-06 1.800 2.85005e-06 0.000 2.85300e-06 0.000
+ 2.85305e-06 1.800 2.87100e-06 1.800 2.87105e-06 0.000 2.88900e-06 0.000 2.88905e-06 1.800 2.89800e-06 1.800
+ 2.89805e-06 0.000 2.90100e-06 0.000 2.90105e-06 1.800 2.90700e-06 1.800 2.90705e-06 0.000 2.91600e-06 0.000
+ 2.91605e-06 1.800 2.92200e-06 1.800 2.92205e-06 0.000 2.92500e-06 0.000 2.92505e-06 1.800 2.92800e-06 1.800
+ 2.92805e-06 0.000 2.93100e-06 0.000 2.93105e-06 1.800 2.93700e-06 1.800 2.93705e-06 0.000 2.94300e-06 0.000
+ 2.94305e-06 1.800 2.96100e-06 1.800 2.96105e-06 0.000 2.96700e-06 0.000 2.96705e-06 1.800 2.97600e-06 1.800
+ 2.97605e-06 0.000 2.97900e-06 0.000 2.97905e-06 1.800 2.98200e-06 1.800 2.98205e-06 0.000 2.98800e-06 0.000
+ 2.98805e-06 1.800 2.99400e-06 1.800 2.99405e-06 0.000 3.00000e-06 0.000 3.00005e-06 1.800 3.00300e-06 1.800
+ 3.00305e-06 0.000 3.01500e-06 0.000 3.01505e-06 1.800 3.01800e-06 1.800 3.01805e-06 0.000 3.02100e-06 0.000
+ 3.02105e-06 1.800 3.02700e-06 1.800 3.02705e-06 0.000 3.03300e-06 0.000 3.03305e-06 1.800 3.03600e-06 1.800
+ 3.03605e-06 0.000 3.04800e-06 0.000 3.04805e-06 1.800 3.05100e-06 1.800 3.05105e-06 0.000 3.05400e-06 0.000
+ 3.05405e-06 1.800 3.05700e-06 1.800 3.05705e-06 0.000 3.06600e-06 0.000 3.06605e-06 1.800 3.06900e-06 1.800
+ 3.06905e-06 0.000 3.07200e-06 0.000
+ )
Xd_a1 src_a1 a1 vdd gnd tb_inv
Va2 src_a2 gnd PWL(
+ 0.00000e+00 1.800 1.92000e-07 1.800 1.92050e-07 0.000 3.84000e-07 0.000 3.84050e-07 1.800 5.76000e-07 1.800
+ 5.76050e-07 0.000 7.68000e-07 0.000 7.68050e-07 1.800 9.60000e-07 1.800 9.60050e-07 0.000 1.15200e-06 0.000
+ 1.15205e-06 1.800 1.34400e-06 1.800 1.34405e-06 0.000 1.53900e-06 0.000 1.53905e-06 1.800 1.54800e-06 1.800
+ 1.54805e-06 0.000 1.55100e-06 0.000 1.55105e-06 1.800 1.55400e-06 1.800 1.55405e-06 0.000 1.57500e-06 0.000
+ 1.57505e-06 1.800 1.58100e-06 1.800 1.58105e-06 0.000 1.59000e-06 0.000 1.59005e-06 1.800 1.59300e-06 1.800
+ 1.59305e-06 0.000 1.59600e-06 0.000 1.59605e-06 1.800 1.59900e-06 1.800 1.59905e-06 0.000 1.60800e-06 0.000
+ 1.60805e-06 1.800 1.61100e-06 1.800 1.61105e-06 0.000 1.61400e-06 0.000 1.61405e-06 1.800 1.61700e-06 1.800
+ 1.61705e-06 0.000 1.62000e-06 0.000 1.62005e-06 1.800 1.62300e-06 1.800 1.62305e-06 0.000 1.62600e-06 0.000
+ 1.62605e-06 1.800 1.62900e-06 1.800 1.62905e-06 0.000 1.63200e-06 0.000 1.63205e-06 1.800 1.63500e-06 1.800
+ 1.63505e-06 0.000 1.63800e-06 0.000 1.63805e-06 1.800 1.64700e-06 1.800 1.64705e-06 0.000 1.65000e-06 0.000
+ 1.65005e-06 1.800 1.65300e-06 1.800 1.65305e-06 0.000 1.66500e-06 0.000 1.66505e-06 1.800 1.66800e-06 1.800
+ 1.66805e-06 0.000 1.67400e-06 0.000 1.67405e-06 1.800 1.68900e-06 1.800 1.68905e-06 0.000 1.69200e-06 0.000
+ 1.69205e-06 1.800 1.69800e-06 1.800 1.69805e-06 0.000 1.70100e-06 0.000 1.70105e-06 1.800 1.70400e-06 1.800
+ 1.70405e-06 0.000 1.70700e-06 0.000 1.70705e-06 1.800 1.71300e-06 1.800 1.71305e-06 0.000 1.72200e-06 0.000
+ 1.72205e-06 1.800 1.72500e-06 1.800 1.72505e-06 0.000 1.72800e-06 0.000 1.72805e-06 1.800 1.73400e-06 1.800
+ 1.73405e-06 0.000 1.74000e-06 0.000 1.74005e-06 1.800 1.74300e-06 1.800 1.74305e-06 0.000 1.74600e-06 0.000
+ 1.74605e-06 1.800 1.74900e-06 1.800 1.74905e-06 0.000 1.75200e-06 0.000 1.75205e-06 1.800 1.76400e-06 1.800
+ 1.76405e-06 0.000 1.76700e-06 0.000 1.76705e-06 1.800 1.77600e-06 1.800 1.77605e-06 0.000 1.78500e-06 0.000
+ 1.78505e-06 1.800 1.78800e-06 1.800 1.78805e-06 0.000 1.79700e-06 0.000 1.79705e-06 1.800 1.80000e-06 1.800
+ 1.80005e-06 0.000 1.81500e-06 0.000 1.81505e-06 1.800 1.82400e-06 1.800 1.82405e-06 0.000 1.82700e-06 0.000
+ 1.82705e-06 1.800 1.83000e-06 1.800 1.83005e-06 0.000 1.83600e-06 0.000 1.83605e-06 1.800 1.84200e-06 1.800
+ 1.84205e-06 0.000 1.84800e-06 0.000 1.84805e-06 1.800 1.85400e-06 1.800 1.85405e-06 0.000 1.85700e-06 0.000
+ 1.85705e-06 1.800 1.86000e-06 1.800 1.86005e-06 0.000 1.86300e-06 0.000 1.86305e-06 1.800 1.86600e-06 1.800
+ 1.86605e-06 0.000 1.86900e-06 0.000 1.86905e-06 1.800 1.87500e-06 1.800 1.87505e-06 0.000 1.89600e-06 0.000
+ 1.89605e-06 1.800 1.90500e-06 1.800 1.90505e-06 0.000 1.91100e-06 0.000 1.91105e-06 1.800 1.91400e-06 1.800
+ 1.91405e-06 0.000 1.91700e-06 0.000 1.91705e-06 1.800 1.92600e-06 1.800 1.92605e-06 0.000 1.93200e-06 0.000
+ 1.93205e-06 1.800 1.93500e-06 1.800 1.93505e-06 0.000 1.93800e-06 0.000 1.93805e-06 1.800 1.94100e-06 1.800
+ 1.94105e-06 0.000 1.94400e-06 0.000 1.94405e-06 1.800 1.95600e-06 1.800 1.95605e-06 0.000 1.96200e-06 0.000
+ 1.96205e-06 1.800 1.96800e-06 1.800 1.96805e-06 0.000 1.97700e-06 0.000 1.97705e-06 1.800 1.98600e-06 1.800
+ 1.98605e-06 0.000 1.98900e-06 0.000 1.98905e-06 1.800 1.99500e-06 1.800 1.99505e-06 0.000 1.99800e-06 0.000
+ 1.99805e-06 1.800 2.00100e-06 1.800 2.00105e-06 0.000 2.00400e-06 0.000 2.00405e-06 1.800 2.00700e-06 1.800
+ 2.00705e-06 0.000 2.01000e-06 0.000 2.01005e-06 1.800 2.01600e-06 1.800 2.01605e-06 0.000 2.03100e-06 0.000
+ 2.03105e-06 1.800 2.04000e-06 1.800 2.04005e-06 0.000 2.04300e-06 0.000 2.04305e-06 1.800 2.04900e-06 1.800
+ 2.04905e-06 0.000 2.05200e-06 0.000 2.05205e-06 1.800 2.05500e-06 1.800 2.05505e-06 0.000 2.06100e-06 0.000
+ 2.06105e-06 1.800 2.06400e-06 1.800 2.06405e-06 0.000 2.06700e-06 0.000 2.06705e-06 1.800 2.07600e-06 1.800
+ 2.07605e-06 0.000 2.08200e-06 0.000 2.08205e-06 1.800 2.09100e-06 1.800 2.09105e-06 0.000 2.09400e-06 0.000
+ 2.09405e-06 1.800 2.10300e-06 1.800 2.10305e-06 0.000 2.11200e-06 0.000 2.11205e-06 1.800 2.11500e-06 1.800
+ 2.11505e-06 0.000 2.11800e-06 0.000 2.11805e-06 1.800 2.12100e-06 1.800 2.12105e-06 0.000 2.12400e-06 0.000
+ 2.12405e-06 1.800 2.12700e-06 1.800 2.12705e-06 0.000 2.13900e-06 0.000 2.13905e-06 1.800 2.14200e-06 1.800
+ 2.14205e-06 0.000 2.14500e-06 0.000 2.14505e-06 1.800 2.15100e-06 1.800 2.15105e-06 0.000 2.15400e-06 0.000
+ 2.15405e-06 1.800 2.15700e-06 1.800 2.15705e-06 0.000 2.16000e-06 0.000 2.16005e-06 1.800 2.17200e-06 1.800
+ 2.17205e-06 0.000 2.17800e-06 0.000 2.17805e-06 1.800 2.18400e-06 1.800 2.18405e-06 0.000 2.18700e-06 0.000
+ 2.18705e-06 1.800 2.19300e-06 1.800 2.19305e-06 0.000 2.19900e-06 0.000 2.19905e-06 1.800 2.20500e-06 1.800
+ 2.20505e-06 0.000 2.20800e-06 0.000 2.20805e-06 1.800 2.21100e-06 1.800 2.21105e-06 0.000 2.21700e-06 0.000
+ 2.21705e-06 1.800 2.22300e-06 1.800 2.22305e-06 0.000 2.22600e-06 0.000 2.22605e-06 1.800 2.23800e-06 1.800
+ 2.23805e-06 0.000 2.24100e-06 0.000 2.24105e-06 1.800 2.24700e-06 1.800 2.24705e-06 0.000 2.26200e-06 0.000
+ 2.26205e-06 1.800 2.26500e-06 1.800 2.26505e-06 0.000 2.26800e-06 0.000 2.26805e-06 1.800 2.27400e-06 1.800
+ 2.27405e-06 0.000 2.28000e-06 0.000 2.28005e-06 1.800 2.28600e-06 1.800 2.28605e-06 0.000 2.28900e-06 0.000
+ 2.28905e-06 1.800 2.29500e-06 1.800 2.29505e-06 0.000 2.29800e-06 0.000 2.29805e-06 1.800 2.31900e-06 1.800
+ 2.31905e-06 0.000 2.32200e-06 0.000 2.32205e-06 1.800 2.32800e-06 1.800 2.32805e-06 0.000 2.33400e-06 0.000
+ 2.33405e-06 1.800 2.34000e-06 1.800 2.34005e-06 0.000 2.35200e-06 0.000 2.35205e-06 1.800 2.35500e-06 1.800
+ 2.35505e-06 0.000 2.36100e-06 0.000 2.36105e-06 1.800 2.36400e-06 1.800 2.36405e-06 0.000 2.37000e-06 0.000
+ 2.37005e-06 1.800 2.37300e-06 1.800 2.37305e-06 0.000 2.37900e-06 0.000 2.37905e-06 1.800 2.38200e-06 1.800
+ 2.38205e-06 0.000 2.38800e-06 0.000 2.38805e-06 1.800 2.39100e-06 1.800 2.39105e-06 0.000 2.39400e-06 0.000
+ 2.39405e-06 1.800 2.39700e-06 1.800 2.39705e-06 0.000 2.40300e-06 0.000 2.40305e-06 1.800 2.41500e-06 1.800
+ 2.41505e-06 0.000 2.42100e-06 0.000 2.42105e-06 1.800 2.42400e-06 1.800 2.42405e-06 0.000 2.42700e-06 0.000
+ 2.42705e-06 1.800 2.43600e-06 1.800 2.43605e-06 0.000 2.44200e-06 0.000 2.44205e-06 1.800 2.44500e-06 1.800
+ 2.44505e-06 0.000 2.44800e-06 0.000 2.44805e-06 1.800 2.45700e-06 1.800 2.45705e-06 0.000 2.46900e-06 0.000
+ 2.46905e-06 1.800 2.47200e-06 1.800 2.47205e-06 0.000 2.47500e-06 0.000 2.47505e-06 1.800 2.47800e-06 1.800
+ 2.47805e-06 0.000 2.48100e-06 0.000 2.48105e-06 1.800 2.48400e-06 1.800 2.48405e-06 0.000 2.49000e-06 0.000
+ 2.49005e-06 1.800 2.49600e-06 1.800 2.49605e-06 0.000 2.49900e-06 0.000 2.49905e-06 1.800 2.51100e-06 1.800
+ 2.51105e-06 0.000 2.51400e-06 0.000 2.51405e-06 1.800 2.52000e-06 1.800 2.52005e-06 0.000 2.52300e-06 0.000
+ 2.52305e-06 1.800 2.52900e-06 1.800 2.52905e-06 0.000 2.54100e-06 0.000 2.54105e-06 1.800 2.54400e-06 1.800
+ 2.54405e-06 0.000 2.54700e-06 0.000 2.54705e-06 1.800 2.55600e-06 1.800 2.55605e-06 0.000 2.55900e-06 0.000
+ 2.55905e-06 1.800 2.57400e-06 1.800 2.57405e-06 0.000 2.58000e-06 0.000 2.58005e-06 1.800 2.58300e-06 1.800
+ 2.58305e-06 0.000 2.59200e-06 0.000 2.59205e-06 1.800 2.59500e-06 1.800 2.59505e-06 0.000 2.59800e-06 0.000
+ 2.59805e-06 1.800 2.60100e-06 1.800 2.60105e-06 0.000 2.60700e-06 0.000 2.60705e-06 1.800 2.61300e-06 1.800
+ 2.61305e-06 0.000 2.61600e-06 0.000 2.61605e-06 1.800 2.61900e-06 1.800 2.61905e-06 0.000 2.62200e-06 0.000
+ 2.62205e-06 1.800 2.62500e-06 1.800 2.62505e-06 0.000 2.64000e-06 0.000 2.64005e-06 1.800 2.64600e-06 1.800
+ 2.64605e-06 0.000 2.64900e-06 0.000 2.64905e-06 1.800 2.65200e-06 1.800 2.65205e-06 0.000 2.65800e-06 0.000
+ 2.65805e-06 1.800 2.66400e-06 1.800 2.66405e-06 0.000 2.66700e-06 0.000 2.66705e-06 1.800 2.67000e-06 1.800
+ 2.67005e-06 0.000 2.67300e-06 0.000 2.67305e-06 1.800 2.67600e-06 1.800 2.67605e-06 0.000 2.68500e-06 0.000
+ 2.68505e-06 1.800 2.69700e-06 1.800 2.69705e-06 0.000 2.70000e-06 0.000 2.70005e-06 1.800 2.70600e-06 1.800
+ 2.70605e-06 0.000 2.71800e-06 0.000 2.71805e-06 1.800 2.72700e-06 1.800 2.72705e-06 0.000 2.73000e-06 0.000
+ 2.73005e-06 1.800 2.73900e-06 1.800 2.73905e-06 0.000 2.74500e-06 0.000 2.74505e-06 1.800 2.75100e-06 1.800
+ 2.75105e-06 0.000 2.75700e-06 0.000 2.75705e-06 1.800 2.76000e-06 1.800 2.76005e-06 0.000 2.76300e-06 0.000
+ 2.76305e-06 1.800 2.76900e-06 1.800 2.76905e-06 0.000 2.78100e-06 0.000 2.78105e-06 1.800 2.78700e-06 1.800
+ 2.78705e-06 0.000 2.79300e-06 0.000 2.79305e-06 1.800 2.79900e-06 1.800 2.79905e-06 0.000 2.80200e-06 0.000
+ 2.80205e-06 1.800 2.80500e-06 1.800 2.80505e-06 0.000 2.80800e-06 0.000 2.80805e-06 1.800 2.81700e-06 1.800
+ 2.81705e-06 0.000 2.82300e-06 0.000 2.82305e-06 1.800 2.82900e-06 1.800 2.82905e-06 0.000 2.83200e-06 0.000
+ 2.83205e-06 1.800 2.83500e-06 1.800 2.83505e-06 0.000 2.84100e-06 0.000 2.84105e-06 1.800 2.84400e-06 1.800
+ 2.84405e-06 0.000 2.84700e-06 0.000 2.84705e-06 1.800 2.85300e-06 1.800 2.85305e-06 0.000 2.86200e-06 0.000
+ 2.86205e-06 1.800 2.86500e-06 1.800 2.86505e-06 0.000 2.86800e-06 0.000 2.86805e-06 1.800 2.87400e-06 1.800
+ 2.87405e-06 0.000 2.88000e-06 0.000 2.88005e-06 1.800 2.88300e-06 1.800 2.88305e-06 0.000 2.89800e-06 0.000
+ 2.89805e-06 1.800 2.90100e-06 1.800 2.90105e-06 0.000 2.90400e-06 0.000 2.90405e-06 1.800 2.90700e-06 1.800
+ 2.90705e-06 0.000 2.91900e-06 0.000 2.91905e-06 1.800 2.92200e-06 1.800 2.92205e-06 0.000 2.94300e-06 0.000
+ 2.94305e-06 1.800 2.94900e-06 1.800 2.94905e-06 0.000 2.95200e-06 0.000 2.95205e-06 1.800 2.96400e-06 1.800
+ 2.96405e-06 0.000 2.96700e-06 0.000 2.96705e-06 1.800 2.97300e-06 1.800 2.97305e-06 0.000 2.98200e-06 0.000
+ 2.98205e-06 1.800 2.98500e-06 1.800 2.98505e-06 0.000 2.99100e-06 0.000 2.99105e-06 1.800 3.00300e-06 1.800
+ 3.00305e-06 0.000 3.00900e-06 0.000 3.00905e-06 1.800 3.01200e-06 1.800 3.01205e-06 0.000 3.01500e-06 0.000
+ 3.01505e-06 1.800 3.01800e-06 1.800 3.01805e-06 0.000 3.02100e-06 0.000 3.02105e-06 1.800 3.02400e-06 1.800
+ 3.02405e-06 0.000 3.02700e-06 0.000 3.02705e-06 1.800 3.03000e-06 1.800 3.03005e-06 0.000 3.04200e-06 0.000
+ 3.04205e-06 1.800 3.04500e-06 1.800 3.04505e-06 0.000 3.04800e-06 0.000 3.04805e-06 1.800 3.07200e-06 1.800
+ )
Xd_a2 src_a2 a2 vdd gnd tb_inv
Va3 src_a3 gnd PWL(
+ 0.00000e+00 1.800 9.60000e-08 1.800 9.60500e-08 0.000 1.92000e-07 0.000 1.92050e-07 1.800 2.88000e-07 1.800
+ 2.88050e-07 0.000 3.84000e-07 0.000 3.84050e-07 1.800 4.80000e-07 1.800 4.80050e-07 0.000 5.76000e-07 0.000
+ 5.76050e-07 1.800 6.72000e-07 1.800 6.72050e-07 0.000 7.68000e-07 0.000 7.68050e-07 1.800 8.64000e-07 1.800
+ 8.64050e-07 0.000 9.60000e-07 0.000 9.60050e-07 1.800 1.05600e-06 1.800 1.05605e-06 0.000 1.15200e-06 0.000
+ 1.15205e-06 1.800 1.24800e-06 1.800 1.24805e-06 0.000 1.34400e-06 0.000 1.34405e-06 1.800 1.44000e-06 1.800
+ 1.44005e-06 0.000 1.53600e-06 0.000 1.53605e-06 1.800 1.53900e-06 1.800 1.53905e-06 0.000 1.54200e-06 0.000
+ 1.54205e-06 1.800 1.55100e-06 1.800 1.55105e-06 0.000 1.55400e-06 0.000 1.55405e-06 1.800 1.55700e-06 1.800
+ 1.55705e-06 0.000 1.56000e-06 0.000 1.56005e-06 1.800 1.56900e-06 1.800 1.56905e-06 0.000 1.57200e-06 0.000
+ 1.57205e-06 1.800 1.57500e-06 1.800 1.57505e-06 0.000 1.58100e-06 0.000 1.58105e-06 1.800 1.59600e-06 1.800
+ 1.59605e-06 0.000 1.59900e-06 0.000 1.59905e-06 1.800 1.60500e-06 1.800 1.60505e-06 0.000 1.60800e-06 0.000
+ 1.60805e-06 1.800 1.61100e-06 1.800 1.61105e-06 0.000 1.62000e-06 0.000 1.62005e-06 1.800 1.62300e-06 1.800
+ 1.62305e-06 0.000 1.62600e-06 0.000 1.62605e-06 1.800 1.63200e-06 1.800 1.63205e-06 0.000 1.63500e-06 0.000
+ 1.63505e-06 1.800 1.63800e-06 1.800 1.63805e-06 0.000 1.64400e-06 0.000 1.64405e-06 1.800 1.64700e-06 1.800
+ 1.64705e-06 0.000 1.65600e-06 0.000 1.65605e-06 1.800 1.65900e-06 1.800 1.65905e-06 0.000 1.66200e-06 0.000
+ 1.66205e-06 1.800 1.66500e-06 1.800 1.66505e-06 0.000 1.68600e-06 0.000 1.68605e-06 1.800 1.69500e-06 1.800
+ 1.69505e-06 0.000 1.71000e-06 0.000 1.71005e-06 1.800 1.71300e-06 1.800 1.71305e-06 0.000 1.71900e-06 0.000
+ 1.71905e-06 1.800 1.72500e-06 1.800 1.72505e-06 0.000 1.74000e-06 0.000 1.74005e-06 1.800 1.74300e-06 1.800
+ 1.74305e-06 0.000 1.74600e-06 0.000 1.74605e-06 1.800 1.75500e-06 1.800 1.75505e-06 0.000 1.75800e-06 0.000
+ 1.75805e-06 1.800 1.76400e-06 1.800 1.76405e-06 0.000 1.76700e-06 0.000 1.76705e-06 1.800 1.77000e-06 1.800
+ 1.77005e-06 0.000 1.77900e-06 0.000 1.77905e-06 1.800 1.78500e-06 1.800 1.78505e-06 0.000 1.78800e-06 0.000
+ 1.78805e-06 1.800 1.79700e-06 1.800 1.79705e-06 0.000 1.80600e-06 0.000 1.80605e-06 1.800 1.80900e-06 1.800
+ 1.80905e-06 0.000 1.82400e-06 0.000 1.82405e-06 1.800 1.82700e-06 1.800 1.82705e-06 0.000 1.83600e-06 0.000
+ 1.83605e-06 1.800 1.84200e-06 1.800 1.84205e-06 0.000 1.84500e-06 0.000 1.84505e-06 1.800 1.85100e-06 1.800
+ 1.85105e-06 0.000 1.85400e-06 0.000 1.85405e-06 1.800 1.85700e-06 1.800 1.85705e-06 0.000 1.86000e-06 0.000
+ 1.86005e-06 1.800 1.86600e-06 1.800 1.86605e-06 0.000 1.86900e-06 0.000 1.86905e-06 1.800 1.87200e-06 1.800
+ 1.87205e-06 0.000 1.87500e-06 0.000 1.87505e-06 1.800 1.87800e-06 1.800 1.87805e-06 0.000 1.89000e-06 0.000
+ 1.89005e-06 1.800 1.89600e-06 1.800 1.89605e-06 0.000 1.89900e-06 0.000 1.89905e-06 1.800 1.90800e-06 1.800
+ 1.90805e-06 0.000 1.91100e-06 0.000 1.91105e-06 1.800 1.91700e-06 1.800 1.91705e-06 0.000 1.92900e-06 0.000
+ 1.92905e-06 1.800 1.93500e-06 1.800 1.93505e-06 0.000 1.93800e-06 0.000 1.93805e-06 1.800 1.94100e-06 1.800
+ 1.94105e-06 0.000 1.94400e-06 0.000 1.94405e-06 1.800 1.94700e-06 1.800 1.94705e-06 0.000 1.95300e-06 0.000
+ 1.95305e-06 1.800 1.95900e-06 1.800 1.95905e-06 0.000 1.96500e-06 0.000 1.96505e-06 1.800 1.97400e-06 1.800
+ 1.97405e-06 0.000 1.97700e-06 0.000 1.97705e-06 1.800 1.98300e-06 1.800 1.98305e-06 0.000 1.98900e-06 0.000
+ 1.98905e-06 1.800 1.99500e-06 1.800 1.99505e-06 0.000 2.01300e-06 0.000 2.01305e-06 1.800 2.01900e-06 1.800
+ 2.01905e-06 0.000 2.03100e-06 0.000 2.03105e-06 1.800 2.03400e-06 1.800 2.03405e-06 0.000 2.04300e-06 0.000
+ 2.04305e-06 1.800 2.04600e-06 1.800 2.04605e-06 0.000 2.04900e-06 0.000 2.04905e-06 1.800 2.05500e-06 1.800
+ 2.05505e-06 0.000 2.05800e-06 0.000 2.05805e-06 1.800 2.07300e-06 1.800 2.07305e-06 0.000 2.07600e-06 0.000
+ 2.07605e-06 1.800 2.07900e-06 1.800 2.07905e-06 0.000 2.09100e-06 0.000 2.09105e-06 1.800 2.10000e-06 1.800
+ 2.10005e-06 0.000 2.10300e-06 0.000 2.10305e-06 1.800 2.10600e-06 1.800 2.10605e-06 0.000 2.10900e-06 0.000
+ 2.10905e-06 1.800 2.11200e-06 1.800 2.11205e-06 0.000 2.12100e-06 0.000 2.12105e-06 1.800 2.12700e-06 1.800
+ 2.12705e-06 0.000 2.13000e-06 0.000 2.13005e-06 1.800 2.13300e-06 1.800 2.13305e-06 0.000 2.13600e-06 0.000
+ 2.13605e-06 1.800 2.13900e-06 1.800 2.13905e-06 0.000 2.15100e-06 0.000 2.15105e-06 1.800 2.15700e-06 1.800
+ 2.15705e-06 0.000 2.16300e-06 0.000 2.16305e-06 1.800 2.16600e-06 1.800 2.16605e-06 0.000 2.17200e-06 0.000
+ 2.17205e-06 1.800 2.18700e-06 1.800 2.18705e-06 0.000 2.19300e-06 0.000 2.19305e-06 1.800 2.19600e-06 1.800
+ 2.19605e-06 0.000 2.20200e-06 0.000 2.20205e-06 1.800 2.20500e-06 1.800 2.20505e-06 0.000 2.21100e-06 0.000
+ 2.21105e-06 1.800 2.21700e-06 1.800 2.21705e-06 0.000 2.22000e-06 0.000 2.22005e-06 1.800 2.23200e-06 1.800
+ 2.23205e-06 0.000 2.25600e-06 0.000 2.25605e-06 1.800 2.26200e-06 1.800 2.26205e-06 0.000 2.27100e-06 0.000
+ 2.27105e-06 1.800 2.28000e-06 1.800 2.28005e-06 0.000 2.28600e-06 0.000 2.28605e-06 1.800 2.29200e-06 1.800
+ 2.29205e-06 0.000 2.31000e-06 0.000 2.31005e-06 1.800 2.31600e-06 1.800 2.31605e-06 0.000 2.31900e-06 0.000
+ 2.31905e-06 1.800 2.32800e-06 1.800 2.32805e-06 0.000 2.33100e-06 0.000 2.33105e-06 1.800 2.35500e-06 1.800
+ 2.35505e-06 0.000 2.36100e-06 0.000 2.36105e-06 1.800 2.36700e-06 1.800 2.36705e-06 0.000 2.37600e-06 0.000
+ 2.37605e-06 1.800 2.39100e-06 1.800 2.39105e-06 0.000 2.39400e-06 0.000 2.39405e-06 1.800 2.39700e-06 1.800
+ 2.39705e-06 0.000 2.40300e-06 0.000 2.40305e-06 1.800 2.41500e-06 1.800 2.41505e-06 0.000 2.41800e-06 0.000
+ 2.41805e-06 1.800 2.42100e-06 1.800 2.42105e-06 0.000 2.42400e-06 0.000 2.42405e-06 1.800 2.43300e-06 1.800
+ 2.43305e-06 0.000 2.44800e-06 0.000 2.44805e-06 1.800 2.45400e-06 1.800 2.45405e-06 0.000 2.45700e-06 0.000
+ 2.45705e-06 1.800 2.46900e-06 1.800 2.46905e-06 0.000 2.47200e-06 0.000 2.47205e-06 1.800 2.47500e-06 1.800
+ 2.47505e-06 0.000 2.47800e-06 0.000 2.47805e-06 1.800 2.48100e-06 1.800 2.48105e-06 0.000 2.49000e-06 0.000
+ 2.49005e-06 1.800 2.49600e-06 1.800 2.49605e-06 0.000 2.49900e-06 0.000 2.49905e-06 1.800 2.50200e-06 1.800
+ 2.50205e-06 0.000 2.50800e-06 0.000 2.50805e-06 1.800 2.51100e-06 1.800 2.51105e-06 0.000 2.51400e-06 0.000
+ 2.51405e-06 1.800 2.51700e-06 1.800 2.51705e-06 0.000 2.52000e-06 0.000 2.52005e-06 1.800 2.52300e-06 1.800
+ 2.52305e-06 0.000 2.52600e-06 0.000 2.52605e-06 1.800 2.54100e-06 1.800 2.54105e-06 0.000 2.55900e-06 0.000
+ 2.55905e-06 1.800 2.56500e-06 1.800 2.56505e-06 0.000 2.56800e-06 0.000 2.56805e-06 1.800 2.57100e-06 1.800
+ 2.57105e-06 0.000 2.57700e-06 0.000 2.57705e-06 1.800 2.58000e-06 1.800 2.58005e-06 0.000 2.58600e-06 0.000
+ 2.58605e-06 1.800 2.58900e-06 1.800 2.58905e-06 0.000 2.59800e-06 0.000 2.59805e-06 1.800 2.60400e-06 1.800
+ 2.60405e-06 0.000 2.60700e-06 0.000 2.60705e-06 1.800 2.62500e-06 1.800 2.62505e-06 0.000 2.63100e-06 0.000
+ 2.63105e-06 1.800 2.63400e-06 1.800 2.63405e-06 0.000 2.63700e-06 0.000 2.63705e-06 1.800 2.64000e-06 1.800
+ 2.64005e-06 0.000 2.64600e-06 0.000 2.64605e-06 1.800 2.66400e-06 1.800 2.66405e-06 0.000 2.66700e-06 0.000
+ 2.66705e-06 1.800 2.67000e-06 1.800 2.67005e-06 0.000 2.67300e-06 0.000 2.67305e-06 1.800 2.68800e-06 1.800
+ 2.68805e-06 0.000 2.70000e-06 0.000 2.70005e-06 1.800 2.70600e-06 1.800 2.70605e-06 0.000 2.70900e-06 0.000
+ 2.70905e-06 1.800 2.71200e-06 1.800 2.71205e-06 0.000 2.72400e-06 0.000 2.72405e-06 1.800 2.73300e-06 1.800
+ 2.73305e-06 0.000 2.73600e-06 0.000 2.73605e-06 1.800 2.74500e-06 1.800 2.74505e-06 0.000 2.75400e-06 0.000
+ 2.75405e-06 1.800 2.76000e-06 1.800 2.76005e-06 0.000 2.76300e-06 0.000 2.76305e-06 1.800 2.76600e-06 1.800
+ 2.76605e-06 0.000 2.76900e-06 0.000 2.76905e-06 1.800 2.78400e-06 1.800 2.78405e-06 0.000 2.79300e-06 0.000
+ 2.79305e-06 1.800 2.79600e-06 1.800 2.79605e-06 0.000 2.79900e-06 0.000 2.79905e-06 1.800 2.80500e-06 1.800
+ 2.80505e-06 0.000 2.81100e-06 0.000 2.81105e-06 1.800 2.81700e-06 1.800 2.81705e-06 0.000 2.82000e-06 0.000
+ 2.82005e-06 1.800 2.82300e-06 1.800 2.82305e-06 0.000 2.82600e-06 0.000 2.82605e-06 1.800 2.83500e-06 1.800
+ 2.83505e-06 0.000 2.85000e-06 0.000 2.85005e-06 1.800 2.85300e-06 1.800 2.85305e-06 0.000 2.85600e-06 0.000
+ 2.85605e-06 1.800 2.86200e-06 1.800 2.86205e-06 0.000 2.86500e-06 0.000 2.86505e-06 1.800 2.87100e-06 1.800
+ 2.87105e-06 0.000 2.87400e-06 0.000 2.87405e-06 1.800 2.88300e-06 1.800 2.88305e-06 0.000 2.89200e-06 0.000
+ 2.89205e-06 1.800 2.89500e-06 1.800 2.89505e-06 0.000 2.90400e-06 0.000 2.90405e-06 1.800 2.90700e-06 1.800
+ 2.90705e-06 0.000 2.91900e-06 0.000 2.91905e-06 1.800 2.92200e-06 1.800 2.92205e-06 0.000 2.92800e-06 0.000
+ 2.92805e-06 1.800 2.93100e-06 1.800 2.93105e-06 0.000 2.93400e-06 0.000 2.93405e-06 1.800 2.96100e-06 1.800
+ 2.96105e-06 0.000 2.96400e-06 0.000 2.96405e-06 1.800 2.96700e-06 1.800 2.96705e-06 0.000 2.98200e-06 0.000
+ 2.98205e-06 1.800 2.98500e-06 1.800 2.98505e-06 0.000 2.99100e-06 0.000 2.99105e-06 1.800 3.00000e-06 1.800
+ 3.00005e-06 0.000 3.00300e-06 0.000 3.00305e-06 1.800 3.00900e-06 1.800 3.00905e-06 0.000 3.01200e-06 0.000
+ 3.01205e-06 1.800 3.01800e-06 1.800 3.01805e-06 0.000 3.02700e-06 0.000 3.02705e-06 1.800 3.03600e-06 1.800
+ 3.03605e-06 0.000 3.04200e-06 0.000 3.04205e-06 1.800 3.04500e-06 1.800 3.04505e-06 0.000 3.05100e-06 0.000
+ 3.05105e-06 1.800 3.05400e-06 1.800 3.05405e-06 0.000 3.05700e-06 0.000 3.05705e-06 1.800 3.06300e-06 1.800
+ 3.06305e-06 0.000 3.06900e-06 0.000 3.06905e-06 1.800 3.07200e-06 1.800
+ )
Xd_a3 src_a3 a3 vdd gnd tb_inv
Vb0 src_b0 gnd PWL(
+ 0.00000e+00 1.800 4.80000e-08 1.800 4.80500e-08 0.000 9.60000e-08 0.000 9.60500e-08 1.800 1.44000e-07 1.800
+ 1.44050e-07 0.000 1.92000e-07 0.000 1.92050e-07 1.800 2.40000e-07 1.800 2.40050e-07 0.000 2.88000e-07 0.000
+ 2.88050e-07 1.800 3.36000e-07 1.800 3.36050e-07 0.000 3.84000e-07 0.000 3.84050e-07 1.800 4.32000e-07 1.800
+ 4.32050e-07 0.000 4.80000e-07 0.000 4.80050e-07 1.800 5.28000e-07 1.800 5.28050e-07 0.000 5.76000e-07 0.000
+ 5.76050e-07 1.800 6.24000e-07 1.800 6.24050e-07 0.000 6.72000e-07 0.000 6.72050e-07 1.800 7.20000e-07 1.800
+ 7.20050e-07 0.000 7.68000e-07 0.000 7.68050e-07 1.800 8.16000e-07 1.800 8.16050e-07 0.000 8.64000e-07 0.000
+ 8.64050e-07 1.800 9.12000e-07 1.800 9.12050e-07 0.000 9.60000e-07 0.000 9.60050e-07 1.800 1.00800e-06 1.800
+ 1.00805e-06 0.000 1.05600e-06 0.000 1.05605e-06 1.800 1.10400e-06 1.800 1.10405e-06 0.000 1.15200e-06 0.000
+ 1.15205e-06 1.800 1.20000e-06 1.800 1.20005e-06 0.000 1.24800e-06 0.000 1.24805e-06 1.800 1.29600e-06 1.800
+ 1.29605e-06 0.000 1.34400e-06 0.000 1.34405e-06 1.800 1.39200e-06 1.800 1.39205e-06 0.000 1.44000e-06 0.000
+ 1.44005e-06 1.800 1.48800e-06 1.800 1.48805e-06 0.000 1.54200e-06 0.000 1.54205e-06 1.800 1.54500e-06 1.800
+ 1.54505e-06 0.000 1.54800e-06 0.000 1.54805e-06 1.800 1.55100e-06 1.800 1.55105e-06 0.000 1.55400e-06 0.000
+ 1.55405e-06 1.800 1.55700e-06 1.800 1.55705e-06 0.000 1.56600e-06 0.000 1.56605e-06 1.800 1.57200e-06 1.800
+ 1.57205e-06 0.000 1.57500e-06 0.000 1.57505e-06 1.800 1.57800e-06 1.800 1.57805e-06 0.000 1.58400e-06 0.000
+ 1.58405e-06 1.800 1.58700e-06 1.800 1.58705e-06 0.000 1.59300e-06 0.000 1.59305e-06 1.800 1.60200e-06 1.800
+ 1.60205e-06 0.000 1.60500e-06 0.000 1.60505e-06 1.800 1.62000e-06 1.800 1.62005e-06 0.000 1.62600e-06 0.000
+ 1.62605e-06 1.800 1.63500e-06 1.800 1.63505e-06 0.000 1.64100e-06 0.000 1.64105e-06 1.800 1.64400e-06 1.800
+ 1.64405e-06 0.000 1.65000e-06 0.000 1.65005e-06 1.800 1.65300e-06 1.800 1.65305e-06 0.000 1.65600e-06 0.000
+ 1.65605e-06 1.800 1.65900e-06 1.800 1.65905e-06 0.000 1.66800e-06 0.000 1.66805e-06 1.800 1.68600e-06 1.800
+ 1.68605e-06 0.000 1.68900e-06 0.000 1.68905e-06 1.800 1.69500e-06 1.800 1.69505e-06 0.000 1.69800e-06 0.000
+ 1.69805e-06 1.800 1.70100e-06 1.800 1.70105e-06 0.000 1.71600e-06 0.000 1.71605e-06 1.800 1.71900e-06 1.800
+ 1.71905e-06 0.000 1.72200e-06 0.000 1.72205e-06 1.800 1.72500e-06 1.800 1.72505e-06 0.000 1.72800e-06 0.000
+ 1.72805e-06 1.800 1.73100e-06 1.800 1.73105e-06 0.000 1.73400e-06 0.000 1.73405e-06 1.800 1.73700e-06 1.800
+ 1.73705e-06 0.000 1.74000e-06 0.000 1.74005e-06 1.800 1.75200e-06 1.800 1.75205e-06 0.000 1.75500e-06 0.000
+ 1.75505e-06 1.800 1.75800e-06 1.800 1.75805e-06 0.000 1.76700e-06 0.000 1.76705e-06 1.800 1.78500e-06 1.800
+ 1.78505e-06 0.000 1.78800e-06 0.000 1.78805e-06 1.800 1.79100e-06 1.800 1.79105e-06 0.000 1.79400e-06 0.000
+ 1.79405e-06 1.800 1.79700e-06 1.800 1.79705e-06 0.000 1.80000e-06 0.000 1.80005e-06 1.800 1.80300e-06 1.800
+ 1.80305e-06 0.000 1.80600e-06 0.000 1.80605e-06 1.800 1.80900e-06 1.800 1.80905e-06 0.000 1.81800e-06 0.000
+ 1.81805e-06 1.800 1.82100e-06 1.800 1.82105e-06 0.000 1.82400e-06 0.000 1.82405e-06 1.800 1.82700e-06 1.800
+ 1.82705e-06 0.000 1.83000e-06 0.000 1.83005e-06 1.800 1.84500e-06 1.800 1.84505e-06 0.000 1.84800e-06 0.000
+ 1.84805e-06 1.800 1.85400e-06 1.800 1.85405e-06 0.000 1.86300e-06 0.000 1.86305e-06 1.800 1.86900e-06 1.800
+ 1.86905e-06 0.000 1.87200e-06 0.000 1.87205e-06 1.800 1.88400e-06 1.800 1.88405e-06 0.000 1.88700e-06 0.000
+ 1.88705e-06 1.800 1.89000e-06 1.800 1.89005e-06 0.000 1.90200e-06 0.000 1.90205e-06 1.800 1.90500e-06 1.800
+ 1.90505e-06 0.000 1.90800e-06 0.000 1.90805e-06 1.800 1.91100e-06 1.800 1.91105e-06 0.000 1.91400e-06 0.000
+ 1.91405e-06 1.800 1.92300e-06 1.800 1.92305e-06 0.000 1.92600e-06 0.000 1.92605e-06 1.800 1.92900e-06 1.800
+ 1.92905e-06 0.000 1.93200e-06 0.000 1.93205e-06 1.800 1.93800e-06 1.800 1.93805e-06 0.000 1.94400e-06 0.000
+ 1.94405e-06 1.800 1.95000e-06 1.800 1.95005e-06 0.000 1.95600e-06 0.000 1.95605e-06 1.800 1.95900e-06 1.800
+ 1.95905e-06 0.000 1.96200e-06 0.000 1.96205e-06 1.800 1.96500e-06 1.800 1.96505e-06 0.000 1.97400e-06 0.000
+ 1.97405e-06 1.800 1.97700e-06 1.800 1.97705e-06 0.000 1.98600e-06 0.000 1.98605e-06 1.800 1.98900e-06 1.800
+ 1.98905e-06 0.000 1.99500e-06 0.000 1.99505e-06 1.800 1.99800e-06 1.800 1.99805e-06 0.000 2.00100e-06 0.000
+ 2.00105e-06 1.800 2.00700e-06 1.800 2.00705e-06 0.000 2.01000e-06 0.000 2.01005e-06 1.800 2.02500e-06 1.800
+ 2.02505e-06 0.000 2.02800e-06 0.000 2.02805e-06 1.800 2.03400e-06 1.800 2.03405e-06 0.000 2.04900e-06 0.000
+ 2.04905e-06 1.800 2.05200e-06 1.800 2.05205e-06 0.000 2.06100e-06 0.000 2.06105e-06 1.800 2.06700e-06 1.800
+ 2.06705e-06 0.000 2.07600e-06 0.000 2.07605e-06 1.800 2.07900e-06 1.800 2.07905e-06 0.000 2.08800e-06 0.000
+ 2.08805e-06 1.800 2.09400e-06 1.800 2.09405e-06 0.000 2.10300e-06 0.000 2.10305e-06 1.800 2.10600e-06 1.800
+ 2.10605e-06 0.000 2.10900e-06 0.000 2.10905e-06 1.800 2.11800e-06 1.800 2.11805e-06 0.000 2.12100e-06 0.000
+ 2.12105e-06 1.800 2.13900e-06 1.800 2.13905e-06 0.000 2.14200e-06 0.000 2.14205e-06 1.800 2.14500e-06 1.800
+ 2.14505e-06 0.000 2.14800e-06 0.000 2.14805e-06 1.800 2.15400e-06 1.800 2.15405e-06 0.000 2.16000e-06 0.000
+ 2.16005e-06 1.800 2.17500e-06 1.800 2.17505e-06 0.000 2.17800e-06 0.000 2.17805e-06 1.800 2.18100e-06 1.800
+ 2.18105e-06 0.000 2.19000e-06 0.000 2.19005e-06 1.800 2.19900e-06 1.800 2.19905e-06 0.000 2.21100e-06 0.000
+ 2.21105e-06 1.800 2.21400e-06 1.800 2.21405e-06 0.000 2.21700e-06 0.000 2.21705e-06 1.800 2.22000e-06 1.800
+ 2.22005e-06 0.000 2.23500e-06 0.000 2.23505e-06 1.800 2.24100e-06 1.800 2.24105e-06 0.000 2.24400e-06 0.000
+ 2.24405e-06 1.800 2.24700e-06 1.800 2.24705e-06 0.000 2.25000e-06 0.000 2.25005e-06 1.800 2.25600e-06 1.800
+ 2.25605e-06 0.000 2.26200e-06 0.000 2.26205e-06 1.800 2.26500e-06 1.800 2.26505e-06 0.000 2.26800e-06 0.000
+ 2.26805e-06 1.800 2.27100e-06 1.800 2.27105e-06 0.000 2.29500e-06 0.000 2.29505e-06 1.800 2.30400e-06 1.800
+ 2.30405e-06 0.000 2.31000e-06 0.000 2.31005e-06 1.800 2.31300e-06 1.800 2.31305e-06 0.000 2.31600e-06 0.000
+ 2.31605e-06 1.800 2.32200e-06 1.800 2.32205e-06 0.000 2.32800e-06 0.000 2.32805e-06 1.800 2.33400e-06 1.800
+ 2.33405e-06 0.000 2.34600e-06 0.000 2.34605e-06 1.800 2.35500e-06 1.800 2.35505e-06 0.000 2.36100e-06 0.000
+ 2.36105e-06 1.800 2.36400e-06 1.800 2.36405e-06 0.000 2.36700e-06 0.000 2.36705e-06 1.800 2.37600e-06 1.800
+ 2.37605e-06 0.000 2.38200e-06 0.000 2.38205e-06 1.800 2.39100e-06 1.800 2.39105e-06 0.000 2.39400e-06 0.000
+ 2.39405e-06 1.800 2.40000e-06 1.800 2.40005e-06 0.000 2.40300e-06 0.000 2.40305e-06 1.800 2.41800e-06 1.800
+ 2.41805e-06 0.000 2.42100e-06 0.000 2.42105e-06 1.800 2.42700e-06 1.800 2.42705e-06 0.000 2.43000e-06 0.000
+ 2.43005e-06 1.800 2.43300e-06 1.800 2.43305e-06 0.000 2.44200e-06 0.000 2.44205e-06 1.800 2.44800e-06 1.800
+ 2.44805e-06 0.000 2.45100e-06 0.000 2.45105e-06 1.800 2.45700e-06 1.800 2.45705e-06 0.000 2.46900e-06 0.000
+ 2.46905e-06 1.800 2.47500e-06 1.800 2.47505e-06 0.000 2.48400e-06 0.000 2.48405e-06 1.800 2.48700e-06 1.800
+ 2.48705e-06 0.000 2.49000e-06 0.000 2.49005e-06 1.800 2.50800e-06 1.800 2.50805e-06 0.000 2.51700e-06 0.000
+ 2.51705e-06 1.800 2.52000e-06 1.800 2.52005e-06 0.000 2.52300e-06 0.000 2.52305e-06 1.800 2.52600e-06 1.800
+ 2.52605e-06 0.000 2.53200e-06 0.000 2.53205e-06 1.800 2.53500e-06 1.800 2.53505e-06 0.000 2.53800e-06 0.000
+ 2.53805e-06 1.800 2.54100e-06 1.800 2.54105e-06 0.000 2.54400e-06 0.000 2.54405e-06 1.800 2.55000e-06 1.800
+ 2.55005e-06 0.000 2.55600e-06 0.000 2.55605e-06 1.800 2.55900e-06 1.800 2.55905e-06 0.000 2.56200e-06 0.000
+ 2.56205e-06 1.800 2.56500e-06 1.800 2.56505e-06 0.000 2.58000e-06 0.000 2.58005e-06 1.800 2.58300e-06 1.800
+ 2.58305e-06 0.000 2.58600e-06 0.000 2.58605e-06 1.800 2.58900e-06 1.800 2.58905e-06 0.000 2.60400e-06 0.000
+ 2.60405e-06 1.800 2.60700e-06 1.800 2.60705e-06 0.000 2.61000e-06 0.000 2.61005e-06 1.800 2.62800e-06 1.800
+ 2.62805e-06 0.000 2.63700e-06 0.000 2.63705e-06 1.800 2.64000e-06 1.800 2.64005e-06 0.000 2.64300e-06 0.000
+ 2.64305e-06 1.800 2.65800e-06 1.800 2.65805e-06 0.000 2.66400e-06 0.000 2.66405e-06 1.800 2.67000e-06 1.800
+ 2.67005e-06 0.000 2.67300e-06 0.000 2.67305e-06 1.800 2.67600e-06 1.800 2.67605e-06 0.000 2.68200e-06 0.000
+ 2.68205e-06 1.800 2.69400e-06 1.800 2.69405e-06 0.000 2.69700e-06 0.000 2.69705e-06 1.800 2.70000e-06 1.800
+ 2.70005e-06 0.000 2.72100e-06 0.000 2.72105e-06 1.800 2.72700e-06 1.800 2.72705e-06 0.000 2.73000e-06 0.000
+ 2.73005e-06 1.800 2.73300e-06 1.800 2.73305e-06 0.000 2.73600e-06 0.000 2.73605e-06 1.800 2.73900e-06 1.800
+ 2.73905e-06 0.000 2.74200e-06 0.000 2.74205e-06 1.800 2.74800e-06 1.800 2.74805e-06 0.000 2.75700e-06 0.000
+ 2.75705e-06 1.800 2.76300e-06 1.800 2.76305e-06 0.000 2.77800e-06 0.000 2.77805e-06 1.800 2.78100e-06 1.800
+ 2.78105e-06 0.000 2.79600e-06 0.000 2.79605e-06 1.800 2.80500e-06 1.800 2.80505e-06 0.000 2.80800e-06 0.000
+ 2.80805e-06 1.800 2.81100e-06 1.800 2.81105e-06 0.000 2.81700e-06 0.000 2.81705e-06 1.800 2.82000e-06 1.800
+ 2.82005e-06 0.000 2.82300e-06 0.000 2.82305e-06 1.800 2.82900e-06 1.800 2.82905e-06 0.000 2.83200e-06 0.000
+ 2.83205e-06 1.800 2.84400e-06 1.800 2.84405e-06 0.000 2.85600e-06 0.000 2.85605e-06 1.800 2.85900e-06 1.800
+ 2.85905e-06 0.000 2.86500e-06 0.000 2.86505e-06 1.800 2.86800e-06 1.800 2.86805e-06 0.000 2.87100e-06 0.000
+ 2.87105e-06 1.800 2.87400e-06 1.800 2.87405e-06 0.000 2.88300e-06 0.000 2.88305e-06 1.800 2.88600e-06 1.800
+ 2.88605e-06 0.000 2.91000e-06 0.000 2.91005e-06 1.800 2.91300e-06 1.800 2.91305e-06 0.000 2.91900e-06 0.000
+ 2.91905e-06 1.800 2.92500e-06 1.800 2.92505e-06 0.000 2.93100e-06 0.000 2.93105e-06 1.800 2.93400e-06 1.800
+ 2.93405e-06 0.000 2.93700e-06 0.000 2.93705e-06 1.800 2.94600e-06 1.800 2.94605e-06 0.000 2.94900e-06 0.000
+ 2.94905e-06 1.800 2.96700e-06 1.800 2.96705e-06 0.000 2.97000e-06 0.000 2.97005e-06 1.800 2.97300e-06 1.800
+ 2.97305e-06 0.000 2.98200e-06 0.000 2.98205e-06 1.800 3.00000e-06 1.800 3.00005e-06 0.000 3.00600e-06 0.000
+ 3.00605e-06 1.800 3.01800e-06 1.800 3.01805e-06 0.000 3.02400e-06 0.000 3.02405e-06 1.800 3.02700e-06 1.800
+ 3.02705e-06 0.000 3.03000e-06 0.000 3.03005e-06 1.800 3.03600e-06 1.800 3.03605e-06 0.000 3.03900e-06 0.000
+ 3.03905e-06 1.800 3.04500e-06 1.800 3.04505e-06 0.000 3.05100e-06 0.000 3.05105e-06 1.800 3.06000e-06 1.800
+ 3.06005e-06 0.000 3.06600e-06 0.000 3.06605e-06 1.800 3.07200e-06 1.800
+ )
Xd_b0 src_b0 b0 vdd gnd tb_inv
Vb1 src_b1 gnd PWL(
+ 0.00000e+00 1.800 2.40000e-08 1.800 2.40500e-08 0.000 4.80000e-08 0.000 4.80500e-08 1.800 7.20000e-08 1.800
+ 7.20500e-08 0.000 9.60000e-08 0.000 9.60500e-08 1.800 1.20000e-07 1.800 1.20050e-07 0.000 1.44000e-07 0.000
+ 1.44050e-07 1.800 1.68000e-07 1.800 1.68050e-07 0.000 1.92000e-07 0.000 1.92050e-07 1.800 2.16000e-07 1.800
+ 2.16050e-07 0.000 2.40000e-07 0.000 2.40050e-07 1.800 2.64000e-07 1.800 2.64050e-07 0.000 2.88000e-07 0.000
+ 2.88050e-07 1.800 3.12000e-07 1.800 3.12050e-07 0.000 3.36000e-07 0.000 3.36050e-07 1.800 3.60000e-07 1.800
+ 3.60050e-07 0.000 3.84000e-07 0.000 3.84050e-07 1.800 4.08000e-07 1.800 4.08050e-07 0.000 4.32000e-07 0.000
+ 4.32050e-07 1.800 4.56000e-07 1.800 4.56050e-07 0.000 4.80000e-07 0.000 4.80050e-07 1.800 5.04000e-07 1.800
+ 5.04050e-07 0.000 5.28000e-07 0.000 5.28050e-07 1.800 5.52000e-07 1.800 5.52050e-07 0.000 5.76000e-07 0.000
+ 5.76050e-07 1.800 6.00000e-07 1.800 6.00050e-07 0.000 6.24000e-07 0.000 6.24050e-07 1.800 6.48000e-07 1.800
+ 6.48050e-07 0.000 6.72000e-07 0.000 6.72050e-07 1.800 6.96000e-07 1.800 6.96050e-07 0.000 7.20000e-07 0.000
+ 7.20050e-07 1.800 7.44000e-07 1.800 7.44050e-07 0.000 7.68000e-07 0.000 7.68050e-07 1.800 7.92000e-07 1.800
+ 7.92050e-07 0.000 8.16000e-07 0.000 8.16050e-07 1.800 8.40000e-07 1.800 8.40050e-07 0.000 8.64000e-07 0.000
+ 8.64050e-07 1.800 8.88000e-07 1.800 8.88050e-07 0.000 9.12000e-07 0.000 9.12050e-07 1.800 9.36000e-07 1.800
+ 9.36050e-07 0.000 9.60000e-07 0.000 9.60050e-07 1.800 9.84000e-07 1.800 9.84050e-07 0.000 1.00800e-06 0.000
+ 1.00805e-06 1.800 1.03200e-06 1.800 1.03205e-06 0.000 1.05600e-06 0.000 1.05605e-06 1.800 1.08000e-06 1.800
+ 1.08005e-06 0.000 1.10400e-06 0.000 1.10405e-06 1.800 1.12800e-06 1.800 1.12805e-06 0.000 1.15200e-06 0.000
+ 1.15205e-06 1.800 1.17600e-06 1.800 1.17605e-06 0.000 1.20000e-06 0.000 1.20005e-06 1.800 1.22400e-06 1.800
+ 1.22405e-06 0.000 1.24800e-06 0.000 1.24805e-06 1.800 1.27200e-06 1.800 1.27205e-06 0.000 1.29600e-06 0.000
+ 1.29605e-06 1.800 1.32000e-06 1.800 1.32005e-06 0.000 1.34400e-06 0.000 1.34405e-06 1.800 1.36800e-06 1.800
+ 1.36805e-06 0.000 1.39200e-06 0.000 1.39205e-06 1.800 1.41600e-06 1.800 1.41605e-06 0.000 1.44000e-06 0.000
+ 1.44005e-06 1.800 1.46400e-06 1.800 1.46405e-06 0.000 1.48800e-06 0.000 1.48805e-06 1.800 1.51200e-06 1.800
+ 1.51205e-06 0.000 1.53600e-06 0.000 1.53605e-06 1.800 1.53900e-06 1.800 1.53905e-06 0.000 1.54200e-06 0.000
+ 1.54205e-06 1.800 1.54800e-06 1.800 1.54805e-06 0.000 1.55100e-06 0.000 1.55105e-06 1.800 1.56300e-06 1.800
+ 1.56305e-06 0.000 1.56600e-06 0.000 1.56605e-06 1.800 1.57200e-06 1.800 1.57205e-06 0.000 1.58100e-06 0.000
+ 1.58105e-06 1.800 1.58400e-06 1.800 1.58405e-06 0.000 1.58700e-06 0.000 1.58705e-06 1.800 1.60800e-06 1.800
+ 1.60805e-06 0.000 1.61100e-06 0.000 1.61105e-06 1.800 1.61400e-06 1.800 1.61405e-06 0.000 1.61700e-06 0.000
+ 1.61705e-06 1.800 1.62300e-06 1.800 1.62305e-06 0.000 1.62900e-06 0.000 1.62905e-06 1.800 1.64400e-06 1.800
+ 1.64405e-06 0.000 1.65000e-06 0.000 1.65005e-06 1.800 1.65600e-06 1.800 1.65605e-06 0.000 1.65900e-06 0.000
+ 1.65905e-06 1.800 1.66200e-06 1.800 1.66205e-06 0.000 1.66500e-06 0.000 1.66505e-06 1.800 1.68000e-06 1.800
+ 1.68005e-06 0.000 1.68300e-06 0.000 1.68305e-06 1.800 1.69200e-06 1.800 1.69205e-06 0.000 1.69800e-06 0.000
+ 1.69805e-06 1.800 1.70700e-06 1.800 1.70705e-06 0.000 1.72200e-06 0.000 1.72205e-06 1.800 1.72500e-06 1.800
+ 1.72505e-06 0.000 1.72800e-06 0.000 1.72805e-06 1.800 1.73100e-06 1.800 1.73105e-06 0.000 1.73400e-06 0.000
+ 1.73405e-06 1.800 1.74000e-06 1.800 1.74005e-06 0.000 1.74600e-06 0.000 1.74605e-06 1.800 1.75200e-06 1.800
+ 1.75205e-06 0.000 1.75500e-06 0.000 1.75505e-06 1.800 1.76100e-06 1.800 1.76105e-06 0.000 1.76700e-06 0.000
+ 1.76705e-06 1.800 1.77300e-06 1.800 1.77305e-06 0.000 1.77600e-06 0.000 1.77605e-06 1.800 1.77900e-06 1.800
+ 1.77905e-06 0.000 1.78500e-06 0.000 1.78505e-06 1.800 1.78800e-06 1.800 1.78805e-06 0.000 1.79700e-06 0.000
+ 1.79705e-06 1.800 1.80000e-06 1.800 1.80005e-06 0.000 1.80600e-06 0.000 1.80605e-06 1.800 1.81200e-06 1.800
+ 1.81205e-06 0.000 1.81500e-06 0.000 1.81505e-06 1.800 1.81800e-06 1.800 1.81805e-06 0.000 1.82100e-06 0.000
+ 1.82105e-06 1.800 1.82400e-06 1.800 1.82405e-06 0.000 1.83300e-06 0.000 1.83305e-06 1.800 1.84200e-06 1.800
+ 1.84205e-06 0.000 1.84500e-06 0.000 1.84505e-06 1.800 1.84800e-06 1.800 1.84805e-06 0.000 1.85400e-06 0.000
+ 1.85405e-06 1.800 1.85700e-06 1.800 1.85705e-06 0.000 1.86300e-06 0.000 1.86305e-06 1.800 1.86600e-06 1.800
+ 1.86605e-06 0.000 1.86900e-06 0.000 1.86905e-06 1.800 1.88100e-06 1.800 1.88105e-06 0.000 1.88700e-06 0.000
+ 1.88705e-06 1.800 1.89000e-06 1.800 1.89005e-06 0.000 1.89300e-06 0.000 1.89305e-06 1.800 1.89600e-06 1.800
+ 1.89605e-06 0.000 1.89900e-06 0.000 1.89905e-06 1.800 1.90200e-06 1.800 1.90205e-06 0.000 1.90500e-06 0.000
+ 1.90505e-06 1.800 1.91400e-06 1.800 1.91405e-06 0.000 1.92000e-06 0.000 1.92005e-06 1.800 1.92600e-06 1.800
+ 1.92605e-06 0.000 1.93500e-06 0.000 1.93505e-06 1.800 1.94100e-06 1.800 1.94105e-06 0.000 1.94400e-06 0.000
+ 1.94405e-06 1.800 1.95000e-06 1.800 1.95005e-06 0.000 1.95600e-06 0.000 1.95605e-06 1.800 1.96200e-06 1.800
+ 1.96205e-06 0.000 1.96500e-06 0.000 1.96505e-06 1.800 1.96800e-06 1.800 1.96805e-06 0.000 1.97700e-06 0.000
+ 1.97705e-06 1.800 1.98000e-06 1.800 1.98005e-06 0.000 1.98900e-06 0.000 1.98905e-06 1.800 1.99500e-06 1.800
+ 1.99505e-06 0.000 1.99800e-06 0.000 1.99805e-06 1.800 2.00100e-06 1.800 2.00105e-06 0.000 2.01000e-06 0.000
+ 2.01005e-06 1.800 2.01600e-06 1.800 2.01605e-06 0.000 2.02200e-06 0.000 2.02205e-06 1.800 2.02500e-06 1.800
+ 2.02505e-06 0.000 2.04900e-06 0.000 2.04905e-06 1.800 2.05200e-06 1.800 2.05205e-06 0.000 2.06100e-06 0.000
+ 2.06105e-06 1.800 2.07000e-06 1.800 2.07005e-06 0.000 2.07300e-06 0.000 2.07305e-06 1.800 2.07600e-06 1.800
+ 2.07605e-06 0.000 2.09400e-06 0.000 2.09405e-06 1.800 2.09700e-06 1.800 2.09705e-06 0.000 2.10300e-06 0.000
+ 2.10305e-06 1.800 2.10600e-06 1.800 2.10605e-06 0.000 2.10900e-06 0.000 2.10905e-06 1.800 2.12400e-06 1.800
+ 2.12405e-06 0.000 2.13300e-06 0.000 2.13305e-06 1.800 2.14200e-06 1.800 2.14205e-06 0.000 2.14500e-06 0.000
+ 2.14505e-06 1.800 2.15100e-06 1.800 2.15105e-06 0.000 2.15400e-06 0.000 2.15405e-06 1.800 2.16600e-06 1.800
+ 2.16605e-06 0.000 2.17800e-06 0.000 2.17805e-06 1.800 2.18700e-06 1.800 2.18705e-06 0.000 2.19000e-06 0.000
+ 2.19005e-06 1.800 2.19300e-06 1.800 2.19305e-06 0.000 2.19600e-06 0.000 2.19605e-06 1.800 2.20200e-06 1.800
+ 2.20205e-06 0.000 2.20800e-06 0.000 2.20805e-06 1.800 2.21700e-06 1.800 2.21705e-06 0.000 2.22000e-06 0.000
+ 2.22005e-06 1.800 2.22300e-06 1.800 2.22305e-06 0.000 2.23500e-06 0.000 2.23505e-06 1.800 2.23800e-06 1.800
+ 2.23805e-06 0.000 2.24100e-06 0.000 2.24105e-06 1.800 2.24400e-06 1.800 2.24405e-06 0.000 2.24700e-06 0.000
+ 2.24705e-06 1.800 2.25000e-06 1.800 2.25005e-06 0.000 2.25300e-06 0.000 2.25305e-06 1.800 2.25600e-06 1.800
+ 2.25605e-06 0.000 2.26500e-06 0.000 2.26505e-06 1.800 2.26800e-06 1.800 2.26805e-06 0.000 2.27100e-06 0.000
+ 2.27105e-06 1.800 2.28300e-06 1.800 2.28305e-06 0.000 2.28900e-06 0.000 2.28905e-06 1.800 2.29200e-06 1.800
+ 2.29205e-06 0.000 2.29800e-06 0.000 2.29805e-06 1.800 2.30400e-06 1.800 2.30405e-06 0.000 2.30700e-06 0.000
+ 2.30705e-06 1.800 2.31000e-06 1.800 2.31005e-06 0.000 2.31600e-06 0.000 2.31605e-06 1.800 2.32200e-06 1.800
+ 2.32205e-06 0.000 2.33100e-06 0.000 2.33105e-06 1.800 2.33400e-06 1.800 2.33405e-06 0.000 2.34000e-06 0.000
+ 2.34005e-06 1.800 2.34300e-06 1.800 2.34305e-06 0.000 2.35500e-06 0.000 2.35505e-06 1.800 2.36100e-06 1.800
+ 2.36105e-06 0.000 2.36400e-06 0.000 2.36405e-06 1.800 2.37000e-06 1.800 2.37005e-06 0.000 2.37300e-06 0.000
+ 2.37305e-06 1.800 2.38200e-06 1.800 2.38205e-06 0.000 2.39100e-06 0.000 2.39105e-06 1.800 2.39400e-06 1.800
+ 2.39405e-06 0.000 2.40000e-06 0.000 2.40005e-06 1.800 2.40900e-06 1.800 2.40905e-06 0.000 2.41200e-06 0.000
+ 2.41205e-06 1.800 2.42100e-06 1.800 2.42105e-06 0.000 2.42400e-06 0.000 2.42405e-06 1.800 2.42700e-06 1.800
+ 2.42705e-06 0.000 2.43600e-06 0.000 2.43605e-06 1.800 2.43900e-06 1.800 2.43905e-06 0.000 2.44200e-06 0.000
+ 2.44205e-06 1.800 2.44500e-06 1.800 2.44505e-06 0.000 2.44800e-06 0.000 2.44805e-06 1.800 2.45100e-06 1.800
+ 2.45105e-06 0.000 2.45400e-06 0.000 2.45405e-06 1.800 2.45700e-06 1.800 2.45705e-06 0.000 2.46000e-06 0.000
+ 2.46005e-06 1.800 2.47800e-06 1.800 2.47805e-06 0.000 2.49300e-06 0.000 2.49305e-06 1.800 2.49900e-06 1.800
+ 2.49905e-06 0.000 2.50500e-06 0.000 2.50505e-06 1.800 2.51100e-06 1.800 2.51105e-06 0.000 2.53200e-06 0.000
+ 2.53205e-06 1.800 2.53500e-06 1.800 2.53505e-06 0.000 2.54100e-06 0.000 2.54105e-06 1.800 2.54400e-06 1.800
+ 2.54405e-06 0.000 2.55600e-06 0.000 2.55605e-06 1.800 2.56800e-06 1.800 2.56805e-06 0.000 2.57100e-06 0.000
+ 2.57105e-06 1.800 2.57400e-06 1.800 2.57405e-06 0.000 2.57700e-06 0.000 2.57705e-06 1.800 2.58300e-06 1.800
+ 2.58305e-06 0.000 2.59500e-06 0.000 2.59505e-06 1.800 2.59800e-06 1.800 2.59805e-06 0.000 2.61300e-06 0.000
+ 2.61305e-06 1.800 2.62500e-06 1.800 2.62505e-06 0.000 2.62800e-06 0.000 2.62805e-06 1.800 2.63400e-06 1.800
+ 2.63405e-06 0.000 2.63700e-06 0.000 2.63705e-06 1.800 2.65200e-06 1.800 2.65205e-06 0.000 2.65500e-06 0.000
+ 2.65505e-06 1.800 2.65800e-06 1.800 2.65805e-06 0.000 2.66100e-06 0.000 2.66105e-06 1.800 2.68200e-06 1.800
+ 2.68205e-06 0.000 2.70300e-06 0.000 2.70305e-06 1.800 2.70900e-06 1.800 2.70905e-06 0.000 2.71200e-06 0.000
+ 2.71205e-06 1.800 2.71500e-06 1.800 2.71505e-06 0.000 2.72100e-06 0.000 2.72105e-06 1.800 2.72400e-06 1.800
+ 2.72405e-06 0.000 2.72700e-06 0.000 2.72705e-06 1.800 2.73000e-06 1.800 2.73005e-06 0.000 2.73300e-06 0.000
+ 2.73305e-06 1.800 2.74200e-06 1.800 2.74205e-06 0.000 2.76000e-06 0.000 2.76005e-06 1.800 2.76300e-06 1.800
+ 2.76305e-06 0.000 2.77200e-06 0.000 2.77205e-06 1.800 2.77800e-06 1.800 2.77805e-06 0.000 2.78400e-06 0.000
+ 2.78405e-06 1.800 2.78700e-06 1.800 2.78705e-06 0.000 2.79000e-06 0.000 2.79005e-06 1.800 2.79600e-06 1.800
+ 2.79605e-06 0.000 2.80200e-06 0.000 2.80205e-06 1.800 2.80500e-06 1.800 2.80505e-06 0.000 2.81100e-06 0.000
+ 2.81105e-06 1.800 2.81400e-06 1.800 2.81405e-06 0.000 2.81700e-06 0.000 2.81705e-06 1.800 2.82300e-06 1.800
+ 2.82305e-06 0.000 2.82600e-06 0.000 2.82605e-06 1.800 2.83500e-06 1.800 2.83505e-06 0.000 2.83800e-06 0.000
+ 2.83805e-06 1.800 2.84100e-06 1.800 2.84105e-06 0.000 2.85000e-06 0.000 2.85005e-06 1.800 2.85900e-06 1.800
+ 2.85905e-06 0.000 2.86200e-06 0.000 2.86205e-06 1.800 2.86500e-06 1.800 2.86505e-06 0.000 2.87400e-06 0.000
+ 2.87405e-06 1.800 2.87700e-06 1.800 2.87705e-06 0.000 2.88000e-06 0.000 2.88005e-06 1.800 2.88300e-06 1.800
+ 2.88305e-06 0.000 2.88600e-06 0.000 2.88605e-06 1.800 2.89200e-06 1.800 2.89205e-06 0.000 2.89500e-06 0.000
+ 2.89505e-06 1.800 2.90400e-06 1.800 2.90405e-06 0.000 2.90700e-06 0.000 2.90705e-06 1.800 2.91300e-06 1.800
+ 2.91305e-06 0.000 2.91600e-06 0.000 2.91605e-06 1.800 2.91900e-06 1.800 2.91905e-06 0.000 2.92500e-06 0.000
+ 2.92505e-06 1.800 2.92800e-06 1.800 2.92805e-06 0.000 2.93700e-06 0.000 2.93705e-06 1.800 2.94900e-06 1.800
+ 2.94905e-06 0.000 2.96100e-06 0.000 2.96105e-06 1.800 2.96400e-06 1.800 2.96405e-06 0.000 2.96700e-06 0.000
+ 2.96705e-06 1.800 2.97000e-06 1.800 2.97005e-06 0.000 2.97300e-06 0.000 2.97305e-06 1.800 2.97600e-06 1.800
+ 2.97605e-06 0.000 2.97900e-06 0.000 2.97905e-06 1.800 2.98200e-06 1.800 2.98205e-06 0.000 2.98500e-06 0.000
+ 2.98505e-06 1.800 2.99400e-06 1.800 2.99405e-06 0.000 2.99700e-06 0.000 2.99705e-06 1.800 3.00300e-06 1.800
+ 3.00305e-06 0.000 3.00600e-06 0.000 3.00605e-06 1.800 3.00900e-06 1.800 3.00905e-06 0.000 3.02100e-06 0.000
+ 3.02105e-06 1.800 3.02400e-06 1.800 3.02405e-06 0.000 3.02700e-06 0.000 3.02705e-06 1.800 3.03300e-06 1.800
+ 3.03305e-06 0.000 3.03600e-06 0.000 3.03605e-06 1.800 3.04500e-06 1.800 3.04505e-06 0.000 3.05100e-06 0.000
+ 3.05105e-06 1.800 3.06000e-06 1.800 3.06005e-06 0.000 3.06300e-06 0.000 3.06305e-06 1.800 3.06900e-06 1.800
+ 3.06905e-06 0.000 3.07200e-06 0.000
+ )
Xd_b1 src_b1 b1 vdd gnd tb_inv
Vb2 src_b2 gnd PWL(
+ 0.00000e+00 1.800 1.20000e-08 1.800 1.20500e-08 0.000 2.40000e-08 0.000 2.40500e-08 1.800 3.60000e-08 1.800
+ 3.60500e-08 0.000 4.80000e-08 0.000 4.80500e-08 1.800 6.00000e-08 1.800 6.00500e-08 0.000 7.20000e-08 0.000
+ 7.20500e-08 1.800 8.40000e-08 1.800 8.40500e-08 0.000 9.60000e-08 0.000 9.60500e-08 1.800 1.08000e-07 1.800
+ 1.08050e-07 0.000 1.20000e-07 0.000 1.20050e-07 1.800 1.32000e-07 1.800 1.32050e-07 0.000 1.44000e-07 0.000
+ 1.44050e-07 1.800 1.56000e-07 1.800 1.56050e-07 0.000 1.68000e-07 0.000 1.68050e-07 1.800 1.80000e-07 1.800
+ 1.80050e-07 0.000 1.92000e-07 0.000 1.92050e-07 1.800 2.04000e-07 1.800 2.04050e-07 0.000 2.16000e-07 0.000
+ 2.16050e-07 1.800 2.28000e-07 1.800 2.28050e-07 0.000 2.40000e-07 0.000 2.40050e-07 1.800 2.52000e-07 1.800
+ 2.52050e-07 0.000 2.64000e-07 0.000 2.64050e-07 1.800 2.76000e-07 1.800 2.76050e-07 0.000 2.88000e-07 0.000
+ 2.88050e-07 1.800 3.00000e-07 1.800 3.00050e-07 0.000 3.12000e-07 0.000 3.12050e-07 1.800 3.24000e-07 1.800
+ 3.24050e-07 0.000 3.36000e-07 0.000 3.36050e-07 1.800 3.48000e-07 1.800 3.48050e-07 0.000 3.60000e-07 0.000
+ 3.60050e-07 1.800 3.72000e-07 1.800 3.72050e-07 0.000 3.84000e-07 0.000 3.84050e-07 1.800 3.96000e-07 1.800
+ 3.96050e-07 0.000 4.08000e-07 0.000 4.08050e-07 1.800 4.20000e-07 1.800 4.20050e-07 0.000 4.32000e-07 0.000
+ 4.32050e-07 1.800 4.44000e-07 1.800 4.44050e-07 0.000 4.56000e-07 0.000 4.56050e-07 1.800 4.68000e-07 1.800
+ 4.68050e-07 0.000 4.80000e-07 0.000 4.80050e-07 1.800 4.92000e-07 1.800 4.92050e-07 0.000 5.04000e-07 0.000
+ 5.04050e-07 1.800 5.16000e-07 1.800 5.16050e-07 0.000 5.28000e-07 0.000 5.28050e-07 1.800 5.40000e-07 1.800
+ 5.40050e-07 0.000 5.52000e-07 0.000 5.52050e-07 1.800 5.64000e-07 1.800 5.64050e-07 0.000 5.76000e-07 0.000
+ 5.76050e-07 1.800 5.88000e-07 1.800 5.88050e-07 0.000 6.00000e-07 0.000 6.00050e-07 1.800 6.12000e-07 1.800
+ 6.12050e-07 0.000 6.24000e-07 0.000 6.24050e-07 1.800 6.36000e-07 1.800 6.36050e-07 0.000 6.48000e-07 0.000
+ 6.48050e-07 1.800 6.60000e-07 1.800 6.60050e-07 0.000 6.72000e-07 0.000 6.72050e-07 1.800 6.84000e-07 1.800
+ 6.84050e-07 0.000 6.96000e-07 0.000 6.96050e-07 1.800 7.08000e-07 1.800 7.08050e-07 0.000 7.20000e-07 0.000
+ 7.20050e-07 1.800 7.32000e-07 1.800 7.32050e-07 0.000 7.44000e-07 0.000 7.44050e-07 1.800 7.56000e-07 1.800
+ 7.56050e-07 0.000 7.68000e-07 0.000 7.68050e-07 1.800 7.80000e-07 1.800 7.80050e-07 0.000 7.92000e-07 0.000
+ 7.92050e-07 1.800 8.04000e-07 1.800 8.04050e-07 0.000 8.16000e-07 0.000 8.16050e-07 1.800 8.28000e-07 1.800
+ 8.28050e-07 0.000 8.40000e-07 0.000 8.40050e-07 1.800 8.52000e-07 1.800 8.52050e-07 0.000 8.64000e-07 0.000
+ 8.64050e-07 1.800 8.76000e-07 1.800 8.76050e-07 0.000 8.88000e-07 0.000 8.88050e-07 1.800 9.00000e-07 1.800
+ 9.00050e-07 0.000 9.12000e-07 0.000 9.12050e-07 1.800 9.24000e-07 1.800 9.24050e-07 0.000 9.36000e-07 0.000
+ 9.36050e-07 1.800 9.48000e-07 1.800 9.48050e-07 0.000 9.60000e-07 0.000 9.60050e-07 1.800 9.72000e-07 1.800
+ 9.72050e-07 0.000 9.84000e-07 0.000 9.84050e-07 1.800 9.96000e-07 1.800 9.96050e-07 0.000 1.00800e-06 0.000
+ 1.00805e-06 1.800 1.02000e-06 1.800 1.02005e-06 0.000 1.03200e-06 0.000 1.03205e-06 1.800 1.04400e-06 1.800
+ 1.04405e-06 0.000 1.05600e-06 0.000 1.05605e-06 1.800 1.06800e-06 1.800 1.06805e-06 0.000 1.08000e-06 0.000
+ 1.08005e-06 1.800 1.09200e-06 1.800 1.09205e-06 0.000 1.10400e-06 0.000 1.10405e-06 1.800 1.11600e-06 1.800
+ 1.11605e-06 0.000 1.12800e-06 0.000 1.12805e-06 1.800 1.14000e-06 1.800 1.14005e-06 0.000 1.15200e-06 0.000
+ 1.15205e-06 1.800 1.16400e-06 1.800 1.16405e-06 0.000 1.17600e-06 0.000 1.17605e-06 1.800 1.18800e-06 1.800
+ 1.18805e-06 0.000 1.20000e-06 0.000 1.20005e-06 1.800 1.21200e-06 1.800 1.21205e-06 0.000 1.22400e-06 0.000
+ 1.22405e-06 1.800 1.23600e-06 1.800 1.23605e-06 0.000 1.24800e-06 0.000 1.24805e-06 1.800 1.26000e-06 1.800
+ 1.26005e-06 0.000 1.27200e-06 0.000 1.27205e-06 1.800 1.28400e-06 1.800 1.28405e-06 0.000 1.29600e-06 0.000
+ 1.29605e-06 1.800 1.30800e-06 1.800 1.30805e-06 0.000 1.32000e-06 0.000 1.32005e-06 1.800 1.33200e-06 1.800
+ 1.33205e-06 0.000 1.34400e-06 0.000 1.34405e-06 1.800 1.35600e-06 1.800 1.35605e-06 0.000 1.36800e-06 0.000
+ 1.36805e-06 1.800 1.38000e-06 1.800 1.38005e-06 0.000 1.39200e-06 0.000 1.39205e-06 1.800 1.40400e-06 1.800
+ 1.40405e-06 0.000 1.41600e-06 0.000 1.41605e-06 1.800 1.42800e-06 1.800 1.42805e-06 0.000 1.44000e-06 0.000
+ 1.44005e-06 1.800 1.45200e-06 1.800 1.45205e-06 0.000 1.46400e-06 0.000 1.46405e-06 1.800 1.47600e-06 1.800
+ 1.47605e-06 0.000 1.48800e-06 0.000 1.48805e-06 1.800 1.50000e-06 1.800 1.50005e-06 0.000 1.51200e-06 0.000
+ 1.51205e-06 1.800 1.52400e-06 1.800 1.52405e-06 0.000 1.53600e-06 0.000 1.53605e-06 1.800 1.54200e-06 1.800
+ 1.54205e-06 0.000 1.54500e-06 0.000 1.54505e-06 1.800 1.54800e-06 1.800 1.54805e-06 0.000 1.56000e-06 0.000
+ 1.56005e-06 1.800 1.56600e-06 1.800 1.56605e-06 0.000 1.57200e-06 0.000 1.57205e-06 1.800 1.57500e-06 1.800
+ 1.57505e-06 0.000 1.58100e-06 0.000 1.58105e-06 1.800 1.58400e-06 1.800 1.58405e-06 0.000 1.59300e-06 0.000
+ 1.59305e-06 1.800 1.59900e-06 1.800 1.59905e-06 0.000 1.60200e-06 0.000 1.60205e-06 1.800 1.61100e-06 1.800
+ 1.61105e-06 0.000 1.61700e-06 0.000 1.61705e-06 1.800 1.63500e-06 1.800 1.63505e-06 0.000 1.64100e-06 0.000
+ 1.64105e-06 1.800 1.64400e-06 1.800 1.64405e-06 0.000 1.64700e-06 0.000 1.64705e-06 1.800 1.65300e-06 1.800
+ 1.65305e-06 0.000 1.65600e-06 0.000 1.65605e-06 1.800 1.66200e-06 1.800 1.66205e-06 0.000 1.66500e-06 0.000
+ 1.66505e-06 1.800 1.66800e-06 1.800 1.66805e-06 0.000 1.68000e-06 0.000 1.68005e-06 1.800 1.68300e-06 1.800
+ 1.68305e-06 0.000 1.68900e-06 0.000 1.68905e-06 1.800 1.69200e-06 1.800 1.69205e-06 0.000 1.69800e-06 0.000
+ 1.69805e-06 1.800 1.70100e-06 1.800 1.70105e-06 0.000 1.70700e-06 0.000 1.70705e-06 1.800 1.71000e-06 1.800
+ 1.71005e-06 0.000 1.71300e-06 0.000 1.71305e-06 1.800 1.71600e-06 1.800 1.71605e-06 0.000 1.72200e-06 0.000
+ 1.72205e-06 1.800 1.72800e-06 1.800 1.72805e-06 0.000 1.73100e-06 0.000 1.73105e-06 1.800 1.74900e-06 1.800
+ 1.74905e-06 0.000 1.75500e-06 0.000 1.75505e-06 1.800 1.76100e-06 1.800 1.76105e-06 0.000 1.76400e-06 0.000
+ 1.76405e-06 1.800 1.76700e-06 1.800 1.76705e-06 0.000 1.78500e-06 0.000 1.78505e-06 1.800 1.78800e-06 1.800
+ 1.78805e-06 0.000 1.79400e-06 0.000 1.79405e-06 1.800 1.80000e-06 1.800 1.80005e-06 0.000 1.80600e-06 0.000
+ 1.80605e-06 1.800 1.80900e-06 1.800 1.80905e-06 0.000 1.81200e-06 0.000 1.81205e-06 1.800 1.82400e-06 1.800
+ 1.82405e-06 0.000 1.82700e-06 0.000 1.82705e-06 1.800 1.83000e-06 1.800 1.83005e-06 0.000 1.84200e-06 0.000
+ 1.84205e-06 1.800 1.84800e-06 1.800 1.84805e-06 0.000 1.85100e-06 0.000 1.85105e-06 1.800 1.85700e-06 1.800
+ 1.85705e-06 0.000 1.86000e-06 0.000 1.86005e-06 1.800 1.86300e-06 1.800 1.86305e-06 0.000 1.87200e-06 0.000
+ 1.87205e-06 1.800 1.87500e-06 1.800 1.87505e-06 0.000 1.88400e-06 0.000 1.88405e-06 1.800 1.89300e-06 1.800
+ 1.89305e-06 0.000 1.89600e-06 0.000 1.89605e-06 1.800 1.90500e-06 1.800 1.90505e-06 0.000 1.90800e-06 0.000
+ 1.90805e-06 1.800 1.91100e-06 1.800 1.91105e-06 0.000 1.91700e-06 0.000 1.91705e-06 1.800 1.92300e-06 1.800
+ 1.92305e-06 0.000 1.92900e-06 0.000 1.92905e-06 1.800 1.93200e-06 1.800 1.93205e-06 0.000 1.94400e-06 0.000
+ 1.94405e-06 1.800 1.94700e-06 1.800 1.94705e-06 0.000 1.95300e-06 0.000 1.95305e-06 1.800 1.95600e-06 1.800
+ 1.95605e-06 0.000 1.95900e-06 0.000 1.95905e-06 1.800 1.96500e-06 1.800 1.96505e-06 0.000 1.96800e-06 0.000
+ 1.96805e-06 1.800 1.97100e-06 1.800 1.97105e-06 0.000 1.98300e-06 0.000 1.98305e-06 1.800 1.98900e-06 1.800
+ 1.98905e-06 0.000 1.99200e-06 0.000 1.99205e-06 1.800 2.00100e-06 1.800 2.00105e-06 0.000 2.00700e-06 0.000
+ 2.00705e-06 1.800 2.01000e-06 1.800 2.01005e-06 0.000 2.01300e-06 0.000 2.01305e-06 1.800 2.02500e-06 1.800
+ 2.02505e-06 0.000 2.03400e-06 0.000 2.03405e-06 1.800 2.03700e-06 1.800 2.03705e-06 0.000 2.04300e-06 0.000
+ 2.04305e-06 1.800 2.04600e-06 1.800 2.04605e-06 0.000 2.06100e-06 0.000 2.06105e-06 1.800 2.07300e-06 1.800
+ 2.07305e-06 0.000 2.08500e-06 0.000 2.08505e-06 1.800 2.08800e-06 1.800 2.08805e-06 0.000 2.10000e-06 0.000
+ 2.10005e-06 1.800 2.10300e-06 1.800 2.10305e-06 0.000 2.10600e-06 0.000 2.10605e-06 1.800 2.12400e-06 1.800
+ 2.12405e-06 0.000 2.12700e-06 0.000 2.12705e-06 1.800 2.13000e-06 1.800 2.13005e-06 0.000 2.13300e-06 0.000
+ 2.13305e-06 1.800 2.13600e-06 1.800 2.13605e-06 0.000 2.14500e-06 0.000 2.14505e-06 1.800 2.15700e-06 1.800
+ 2.15705e-06 0.000 2.16300e-06 0.000 2.16305e-06 1.800 2.16900e-06 1.800 2.16905e-06 0.000 2.17200e-06 0.000
+ 2.17205e-06 1.800 2.17500e-06 1.800 2.17505e-06 0.000 2.17800e-06 0.000 2.17805e-06 1.800 2.18100e-06 1.800
+ 2.18105e-06 0.000 2.19300e-06 0.000 2.19305e-06 1.800 2.20500e-06 1.800 2.20505e-06 0.000 2.20800e-06 0.000
+ 2.20805e-06 1.800 2.21100e-06 1.800 2.21105e-06 0.000 2.21400e-06 0.000 2.21405e-06 1.800 2.21700e-06 1.800
+ 2.21705e-06 0.000 2.22000e-06 0.000 2.22005e-06 1.800 2.22300e-06 1.800 2.22305e-06 0.000 2.22600e-06 0.000
+ 2.22605e-06 1.800 2.23500e-06 1.800 2.23505e-06 0.000 2.24400e-06 0.000 2.24405e-06 1.800 2.25300e-06 1.800
+ 2.25305e-06 0.000 2.25900e-06 0.000 2.25905e-06 1.800 2.28000e-06 1.800 2.28005e-06 0.000 2.28600e-06 0.000
+ 2.28605e-06 1.800 2.29200e-06 1.800 2.29205e-06 0.000 2.29500e-06 0.000 2.29505e-06 1.800 2.30400e-06 1.800
+ 2.30405e-06 0.000 2.31900e-06 0.000 2.31905e-06 1.800 2.32200e-06 1.800 2.32205e-06 0.000 2.32500e-06 0.000
+ 2.32505e-06 1.800 2.32800e-06 1.800 2.32805e-06 0.000 2.33100e-06 0.000 2.33105e-06 1.800 2.33700e-06 1.800
+ 2.33705e-06 0.000 2.34600e-06 0.000 2.34605e-06 1.800 2.35200e-06 1.800 2.35205e-06 0.000 2.35500e-06 0.000
+ 2.35505e-06 1.800 2.35800e-06 1.800 2.35805e-06 0.000 2.36100e-06 0.000 2.36105e-06 1.800 2.36400e-06 1.800
+ 2.36405e-06 0.000 2.36700e-06 0.000 2.36705e-06 1.800 2.37000e-06 1.800 2.37005e-06 0.000 2.37300e-06 0.000
+ 2.37305e-06 1.800 2.40300e-06 1.800 2.40305e-06 0.000 2.40600e-06 0.000 2.40605e-06 1.800 2.40900e-06 1.800
+ 2.40905e-06 0.000 2.41500e-06 0.000 2.41505e-06 1.800 2.41800e-06 1.800 2.41805e-06 0.000 2.43300e-06 0.000
+ 2.43305e-06 1.800 2.43900e-06 1.800 2.43905e-06 0.000 2.44500e-06 0.000 2.44505e-06 1.800 2.44800e-06 1.800
+ 2.44805e-06 0.000 2.45100e-06 0.000 2.45105e-06 1.800 2.45700e-06 1.800 2.45705e-06 0.000 2.46300e-06 0.000
+ 2.46305e-06 1.800 2.46600e-06 1.800 2.46605e-06 0.000 2.46900e-06 0.000 2.46905e-06 1.800 2.47500e-06 1.800
+ 2.47505e-06 0.000 2.48100e-06 0.000 2.48105e-06 1.800 2.48400e-06 1.800 2.48405e-06 0.000 2.49900e-06 0.000
+ 2.49905e-06 1.800 2.50500e-06 1.800 2.50505e-06 0.000 2.50800e-06 0.000 2.50805e-06 1.800 2.51700e-06 1.800
+ 2.51705e-06 0.000 2.52300e-06 0.000 2.52305e-06 1.800 2.53200e-06 1.800 2.53205e-06 0.000 2.54100e-06 0.000
+ 2.54105e-06 1.800 2.55300e-06 1.800 2.55305e-06 0.000 2.55900e-06 0.000 2.55905e-06 1.800 2.56800e-06 1.800
+ 2.56805e-06 0.000 2.57400e-06 0.000 2.57405e-06 1.800 2.58000e-06 1.800 2.58005e-06 0.000 2.58300e-06 0.000
+ 2.58305e-06 1.800 2.58900e-06 1.800 2.58905e-06 0.000 2.59200e-06 0.000 2.59205e-06 1.800 2.59500e-06 1.800
+ 2.59505e-06 0.000 2.60100e-06 0.000 2.60105e-06 1.800 2.60700e-06 1.800 2.60705e-06 0.000 2.61000e-06 0.000
+ 2.61005e-06 1.800 2.61600e-06 1.800 2.61605e-06 0.000 2.62200e-06 0.000 2.62205e-06 1.800 2.62800e-06 1.800
+ 2.62805e-06 0.000 2.63100e-06 0.000 2.63105e-06 1.800 2.63400e-06 1.800 2.63405e-06 0.000 2.63700e-06 0.000
+ 2.63705e-06 1.800 2.64000e-06 1.800 2.64005e-06 0.000 2.65800e-06 0.000 2.65805e-06 1.800 2.66100e-06 1.800
+ 2.66105e-06 0.000 2.67300e-06 0.000 2.67305e-06 1.800 2.67600e-06 1.800 2.67605e-06 0.000 2.68200e-06 0.000
+ 2.68205e-06 1.800 2.69100e-06 1.800 2.69105e-06 0.000 2.69400e-06 0.000 2.69405e-06 1.800 2.70000e-06 1.800
+ 2.70005e-06 0.000 2.70600e-06 0.000 2.70605e-06 1.800 2.71200e-06 1.800 2.71205e-06 0.000 2.71500e-06 0.000
+ 2.71505e-06 1.800 2.71800e-06 1.800 2.71805e-06 0.000 2.72400e-06 0.000 2.72405e-06 1.800 2.73000e-06 1.800
+ 2.73005e-06 0.000 2.73900e-06 0.000 2.73905e-06 1.800 2.74500e-06 1.800 2.74505e-06 0.000 2.75100e-06 0.000
+ 2.75105e-06 1.800 2.75700e-06 1.800 2.75705e-06 0.000 2.76300e-06 0.000 2.76305e-06 1.800 2.77200e-06 1.800
+ 2.77205e-06 0.000 2.78100e-06 0.000 2.78105e-06 1.800 2.78400e-06 1.800 2.78405e-06 0.000 2.79300e-06 0.000
+ 2.79305e-06 1.800 2.79600e-06 1.800 2.79605e-06 0.000 2.79900e-06 0.000 2.79905e-06 1.800 2.80500e-06 1.800
+ 2.80505e-06 0.000 2.81100e-06 0.000 2.81105e-06 1.800 2.82000e-06 1.800 2.82005e-06 0.000 2.82300e-06 0.000
+ 2.82305e-06 1.800 2.83500e-06 1.800 2.83505e-06 0.000 2.83800e-06 0.000 2.83805e-06 1.800 2.84400e-06 1.800
+ 2.84405e-06 0.000 2.85300e-06 0.000 2.85305e-06 1.800 2.85900e-06 1.800 2.85905e-06 0.000 2.86200e-06 0.000
+ 2.86205e-06 1.800 2.86800e-06 1.800 2.86805e-06 0.000 2.87700e-06 0.000 2.87705e-06 1.800 2.88000e-06 1.800
+ 2.88005e-06 0.000 2.88300e-06 0.000 2.88305e-06 1.800 2.88600e-06 1.800 2.88605e-06 0.000 2.88900e-06 0.000
+ 2.88905e-06 1.800 2.89500e-06 1.800 2.89505e-06 0.000 2.89800e-06 0.000 2.89805e-06 1.800 2.90100e-06 1.800
+ 2.90105e-06 0.000 2.90400e-06 0.000 2.90405e-06 1.800 2.90700e-06 1.800 2.90705e-06 0.000 2.91000e-06 0.000
+ 2.91005e-06 1.800 2.91900e-06 1.800 2.91905e-06 0.000 2.92500e-06 0.000 2.92505e-06 1.800 2.93100e-06 1.800
+ 2.93105e-06 0.000 2.93700e-06 0.000 2.93705e-06 1.800 2.94300e-06 1.800 2.94305e-06 0.000 2.95500e-06 0.000
+ 2.95505e-06 1.800 2.95800e-06 1.800 2.95805e-06 0.000 2.96100e-06 0.000 2.96105e-06 1.800 2.96400e-06 1.800
+ 2.96405e-06 0.000 2.97900e-06 0.000 2.97905e-06 1.800 2.98500e-06 1.800 2.98505e-06 0.000 2.99100e-06 0.000
+ 2.99105e-06 1.800 2.99700e-06 1.800 2.99705e-06 0.000 3.00900e-06 0.000 3.00905e-06 1.800 3.01500e-06 1.800
+ 3.01505e-06 0.000 3.01800e-06 0.000 3.01805e-06 1.800 3.03300e-06 1.800 3.03305e-06 0.000 3.03600e-06 0.000
+ 3.03605e-06 1.800 3.03900e-06 1.800 3.03905e-06 0.000 3.05100e-06 0.000 3.05105e-06 1.800 3.05700e-06 1.800
+ 3.05705e-06 0.000 3.06000e-06 0.000 3.06005e-06 1.800 3.07200e-06 1.800
+ )
Xd_b2 src_b2 b2 vdd gnd tb_inv
Vb3 src_b3 gnd PWL(
+ 0.00000e+00 1.800 6.00000e-09 1.800 6.05000e-09 0.000 1.20000e-08 0.000 1.20500e-08 1.800 1.80000e-08 1.800
+ 1.80500e-08 0.000 2.40000e-08 0.000 2.40500e-08 1.800 3.00000e-08 1.800 3.00500e-08 0.000 3.60000e-08 0.000
+ 3.60500e-08 1.800 4.20000e-08 1.800 4.20500e-08 0.000 4.80000e-08 0.000 4.80500e-08 1.800 5.40000e-08 1.800
+ 5.40500e-08 0.000 6.00000e-08 0.000 6.00500e-08 1.800 6.60000e-08 1.800 6.60500e-08 0.000 7.20000e-08 0.000
+ 7.20500e-08 1.800 7.80000e-08 1.800 7.80500e-08 0.000 8.40000e-08 0.000 8.40500e-08 1.800 9.00000e-08 1.800
+ 9.00500e-08 0.000 9.60000e-08 0.000 9.60500e-08 1.800 1.02000e-07 1.800 1.02050e-07 0.000 1.08000e-07 0.000
+ 1.08050e-07 1.800 1.14000e-07 1.800 1.14050e-07 0.000 1.20000e-07 0.000 1.20050e-07 1.800 1.26000e-07 1.800
+ 1.26050e-07 0.000 1.32000e-07 0.000 1.32050e-07 1.800 1.38000e-07 1.800 1.38050e-07 0.000 1.44000e-07 0.000
+ 1.44050e-07 1.800 1.50000e-07 1.800 1.50050e-07 0.000 1.56000e-07 0.000 1.56050e-07 1.800 1.62000e-07 1.800
+ 1.62050e-07 0.000 1.68000e-07 0.000 1.68050e-07 1.800 1.74000e-07 1.800 1.74050e-07 0.000 1.80000e-07 0.000
+ 1.80050e-07 1.800 1.86000e-07 1.800 1.86050e-07 0.000 1.92000e-07 0.000 1.92050e-07 1.800 1.98000e-07 1.800
+ 1.98050e-07 0.000 2.04000e-07 0.000 2.04050e-07 1.800 2.10000e-07 1.800 2.10050e-07 0.000 2.16000e-07 0.000
+ 2.16050e-07 1.800 2.22000e-07 1.800 2.22050e-07 0.000 2.28000e-07 0.000 2.28050e-07 1.800 2.34000e-07 1.800
+ 2.34050e-07 0.000 2.40000e-07 0.000 2.40050e-07 1.800 2.46000e-07 1.800 2.46050e-07 0.000 2.52000e-07 0.000
+ 2.52050e-07 1.800 2.58000e-07 1.800 2.58050e-07 0.000 2.64000e-07 0.000 2.64050e-07 1.800 2.70000e-07 1.800
+ 2.70050e-07 0.000 2.76000e-07 0.000 2.76050e-07 1.800 2.82000e-07 1.800 2.82050e-07 0.000 2.88000e-07 0.000
+ 2.88050e-07 1.800 2.94000e-07 1.800 2.94050e-07 0.000 3.00000e-07 0.000 3.00050e-07 1.800 3.06000e-07 1.800
+ 3.06050e-07 0.000 3.12000e-07 0.000 3.12050e-07 1.800 3.18000e-07 1.800 3.18050e-07 0.000 3.24000e-07 0.000
+ 3.24050e-07 1.800 3.30000e-07 1.800 3.30050e-07 0.000 3.36000e-07 0.000 3.36050e-07 1.800 3.42000e-07 1.800
+ 3.42050e-07 0.000 3.48000e-07 0.000 3.48050e-07 1.800 3.54000e-07 1.800 3.54050e-07 0.000 3.60000e-07 0.000
+ 3.60050e-07 1.800 3.66000e-07 1.800 3.66050e-07 0.000 3.72000e-07 0.000 3.72050e-07 1.800 3.78000e-07 1.800
+ 3.78050e-07 0.000 3.84000e-07 0.000 3.84050e-07 1.800 3.90000e-07 1.800 3.90050e-07 0.000 3.96000e-07 0.000
+ 3.96050e-07 1.800 4.02000e-07 1.800 4.02050e-07 0.000 4.08000e-07 0.000 4.08050e-07 1.800 4.14000e-07 1.800
+ 4.14050e-07 0.000 4.20000e-07 0.000 4.20050e-07 1.800 4.26000e-07 1.800 4.26050e-07 0.000 4.32000e-07 0.000
+ 4.32050e-07 1.800 4.38000e-07 1.800 4.38050e-07 0.000 4.44000e-07 0.000 4.44050e-07 1.800 4.50000e-07 1.800
+ 4.50050e-07 0.000 4.56000e-07 0.000 4.56050e-07 1.800 4.62000e-07 1.800 4.62050e-07 0.000 4.68000e-07 0.000
+ 4.68050e-07 1.800 4.74000e-07 1.800 4.74050e-07 0.000 4.80000e-07 0.000 4.80050e-07 1.800 4.86000e-07 1.800
+ 4.86050e-07 0.000 4.92000e-07 0.000 4.92050e-07 1.800 4.98000e-07 1.800 4.98050e-07 0.000 5.04000e-07 0.000
+ 5.04050e-07 1.800 5.10000e-07 1.800 5.10050e-07 0.000 5.16000e-07 0.000 5.16050e-07 1.800 5.22000e-07 1.800
+ 5.22050e-07 0.000 5.28000e-07 0.000 5.28050e-07 1.800 5.34000e-07 1.800 5.34050e-07 0.000 5.40000e-07 0.000
+ 5.40050e-07 1.800 5.46000e-07 1.800 5.46050e-07 0.000 5.52000e-07 0.000 5.52050e-07 1.800 5.58000e-07 1.800
+ 5.58050e-07 0.000 5.64000e-07 0.000 5.64050e-07 1.800 5.70000e-07 1.800 5.70050e-07 0.000 5.76000e-07 0.000
+ 5.76050e-07 1.800 5.82000e-07 1.800 5.82050e-07 0.000 5.88000e-07 0.000 5.88050e-07 1.800 5.94000e-07 1.800
+ 5.94050e-07 0.000 6.00000e-07 0.000 6.00050e-07 1.800 6.06000e-07 1.800 6.06050e-07 0.000 6.12000e-07 0.000
+ 6.12050e-07 1.800 6.18000e-07 1.800 6.18050e-07 0.000 6.24000e-07 0.000 6.24050e-07 1.800 6.30000e-07 1.800
+ 6.30050e-07 0.000 6.36000e-07 0.000 6.36050e-07 1.800 6.42000e-07 1.800 6.42050e-07 0.000 6.48000e-07 0.000
+ 6.48050e-07 1.800 6.54000e-07 1.800 6.54050e-07 0.000 6.60000e-07 0.000 6.60050e-07 1.800 6.66000e-07 1.800
+ 6.66050e-07 0.000 6.72000e-07 0.000 6.72050e-07 1.800 6.78000e-07 1.800 6.78050e-07 0.000 6.84000e-07 0.000
+ 6.84050e-07 1.800 6.90000e-07 1.800 6.90050e-07 0.000 6.96000e-07 0.000 6.96050e-07 1.800 7.02000e-07 1.800
+ 7.02050e-07 0.000 7.08000e-07 0.000 7.08050e-07 1.800 7.14000e-07 1.800 7.14050e-07 0.000 7.20000e-07 0.000
+ 7.20050e-07 1.800 7.26000e-07 1.800 7.26050e-07 0.000 7.32000e-07 0.000 7.32050e-07 1.800 7.38000e-07 1.800
+ 7.38050e-07 0.000 7.44000e-07 0.000 7.44050e-07 1.800 7.50000e-07 1.800 7.50050e-07 0.000 7.56000e-07 0.000
+ 7.56050e-07 1.800 7.62000e-07 1.800 7.62050e-07 0.000 7.68000e-07 0.000 7.68050e-07 1.800 7.74000e-07 1.800
+ 7.74050e-07 0.000 7.80000e-07 0.000 7.80050e-07 1.800 7.86000e-07 1.800 7.86050e-07 0.000 7.92000e-07 0.000
+ 7.92050e-07 1.800 7.98000e-07 1.800 7.98050e-07 0.000 8.04000e-07 0.000 8.04050e-07 1.800 8.10000e-07 1.800
+ 8.10050e-07 0.000 8.16000e-07 0.000 8.16050e-07 1.800 8.22000e-07 1.800 8.22050e-07 0.000 8.28000e-07 0.000
+ 8.28050e-07 1.800 8.34000e-07 1.800 8.34050e-07 0.000 8.40000e-07 0.000 8.40050e-07 1.800 8.46000e-07 1.800
+ 8.46050e-07 0.000 8.52000e-07 0.000 8.52050e-07 1.800 8.58000e-07 1.800 8.58050e-07 0.000 8.64000e-07 0.000
+ 8.64050e-07 1.800 8.70000e-07 1.800 8.70050e-07 0.000 8.76000e-07 0.000 8.76050e-07 1.800 8.82000e-07 1.800
+ 8.82050e-07 0.000 8.88000e-07 0.000 8.88050e-07 1.800 8.94000e-07 1.800 8.94050e-07 0.000 9.00000e-07 0.000
+ 9.00050e-07 1.800 9.06000e-07 1.800 9.06050e-07 0.000 9.12000e-07 0.000 9.12050e-07 1.800 9.18000e-07 1.800
+ 9.18050e-07 0.000 9.24000e-07 0.000 9.24050e-07 1.800 9.30000e-07 1.800 9.30050e-07 0.000 9.36000e-07 0.000
+ 9.36050e-07 1.800 9.42000e-07 1.800 9.42050e-07 0.000 9.48000e-07 0.000 9.48050e-07 1.800 9.54000e-07 1.800
+ 9.54050e-07 0.000 9.60000e-07 0.000 9.60050e-07 1.800 9.66000e-07 1.800 9.66050e-07 0.000 9.72000e-07 0.000
+ 9.72050e-07 1.800 9.78000e-07 1.800 9.78050e-07 0.000 9.84000e-07 0.000 9.84050e-07 1.800 9.90000e-07 1.800
+ 9.90050e-07 0.000 9.96000e-07 0.000 9.96050e-07 1.800 1.00200e-06 1.800 1.00205e-06 0.000 1.00800e-06 0.000
+ 1.00805e-06 1.800 1.01400e-06 1.800 1.01405e-06 0.000 1.02000e-06 0.000 1.02005e-06 1.800 1.02600e-06 1.800
+ 1.02605e-06 0.000 1.03200e-06 0.000 1.03205e-06 1.800 1.03800e-06 1.800 1.03805e-06 0.000 1.04400e-06 0.000
+ 1.04405e-06 1.800 1.05000e-06 1.800 1.05005e-06 0.000 1.05600e-06 0.000 1.05605e-06 1.800 1.06200e-06 1.800
+ 1.06205e-06 0.000 1.06800e-06 0.000 1.06805e-06 1.800 1.07400e-06 1.800 1.07405e-06 0.000 1.08000e-06 0.000
+ 1.08005e-06 1.800 1.08600e-06 1.800 1.08605e-06 0.000 1.09200e-06 0.000 1.09205e-06 1.800 1.09800e-06 1.800
+ 1.09805e-06 0.000 1.10400e-06 0.000 1.10405e-06 1.800 1.11000e-06 1.800 1.11005e-06 0.000 1.11600e-06 0.000
+ 1.11605e-06 1.800 1.12200e-06 1.800 1.12205e-06 0.000 1.12800e-06 0.000 1.12805e-06 1.800 1.13400e-06 1.800
+ 1.13405e-06 0.000 1.14000e-06 0.000 1.14005e-06 1.800 1.14600e-06 1.800 1.14605e-06 0.000 1.15200e-06 0.000
+ 1.15205e-06 1.800 1.15800e-06 1.800 1.15805e-06 0.000 1.16400e-06 0.000 1.16405e-06 1.800 1.17000e-06 1.800
+ 1.17005e-06 0.000 1.17600e-06 0.000 1.17605e-06 1.800 1.18200e-06 1.800 1.18205e-06 0.000 1.18800e-06 0.000
+ 1.18805e-06 1.800 1.19400e-06 1.800 1.19405e-06 0.000 1.20000e-06 0.000 1.20005e-06 1.800 1.20600e-06 1.800
+ 1.20605e-06 0.000 1.21200e-06 0.000 1.21205e-06 1.800 1.21800e-06 1.800 1.21805e-06 0.000 1.22400e-06 0.000
+ 1.22405e-06 1.800 1.23000e-06 1.800 1.23005e-06 0.000 1.23600e-06 0.000 1.23605e-06 1.800 1.24200e-06 1.800
+ 1.24205e-06 0.000 1.24800e-06 0.000 1.24805e-06 1.800 1.25400e-06 1.800 1.25405e-06 0.000 1.26000e-06 0.000
+ 1.26005e-06 1.800 1.26600e-06 1.800 1.26605e-06 0.000 1.27200e-06 0.000 1.27205e-06 1.800 1.27800e-06 1.800
+ 1.27805e-06 0.000 1.28400e-06 0.000 1.28405e-06 1.800 1.29000e-06 1.800 1.29005e-06 0.000 1.29600e-06 0.000
+ 1.29605e-06 1.800 1.30200e-06 1.800 1.30205e-06 0.000 1.30800e-06 0.000 1.30805e-06 1.800 1.31400e-06 1.800
+ 1.31405e-06 0.000 1.32000e-06 0.000 1.32005e-06 1.800 1.32600e-06 1.800 1.32605e-06 0.000 1.33200e-06 0.000
+ 1.33205e-06 1.800 1.33800e-06 1.800 1.33805e-06 0.000 1.34400e-06 0.000 1.34405e-06 1.800 1.35000e-06 1.800
+ 1.35005e-06 0.000 1.35600e-06 0.000 1.35605e-06 1.800 1.36200e-06 1.800 1.36205e-06 0.000 1.36800e-06 0.000
+ 1.36805e-06 1.800 1.37400e-06 1.800 1.37405e-06 0.000 1.38000e-06 0.000 1.38005e-06 1.800 1.38600e-06 1.800
+ 1.38605e-06 0.000 1.39200e-06 0.000 1.39205e-06 1.800 1.39800e-06 1.800 1.39805e-06 0.000 1.40400e-06 0.000
+ 1.40405e-06 1.800 1.41000e-06 1.800 1.41005e-06 0.000 1.41600e-06 0.000 1.41605e-06 1.800 1.42200e-06 1.800
+ 1.42205e-06 0.000 1.42800e-06 0.000 1.42805e-06 1.800 1.43400e-06 1.800 1.43405e-06 0.000 1.44000e-06 0.000
+ 1.44005e-06 1.800 1.44600e-06 1.800 1.44605e-06 0.000 1.45200e-06 0.000 1.45205e-06 1.800 1.45800e-06 1.800
+ 1.45805e-06 0.000 1.46400e-06 0.000 1.46405e-06 1.800 1.47000e-06 1.800 1.47005e-06 0.000 1.47600e-06 0.000
+ 1.47605e-06 1.800 1.48200e-06 1.800 1.48205e-06 0.000 1.48800e-06 0.000 1.48805e-06 1.800 1.49400e-06 1.800
+ 1.49405e-06 0.000 1.50000e-06 0.000 1.50005e-06 1.800 1.50600e-06 1.800 1.50605e-06 0.000 1.51200e-06 0.000
+ 1.51205e-06 1.800 1.51800e-06 1.800 1.51805e-06 0.000 1.52400e-06 0.000 1.52405e-06 1.800 1.53000e-06 1.800
+ 1.53005e-06 0.000 1.54200e-06 0.000 1.54205e-06 1.800 1.54800e-06 1.800 1.54805e-06 0.000 1.55100e-06 0.000
+ 1.55105e-06 1.800 1.55400e-06 1.800 1.55405e-06 0.000 1.55700e-06 0.000 1.55705e-06 1.800 1.56000e-06 1.800
+ 1.56005e-06 0.000 1.56300e-06 0.000 1.56305e-06 1.800 1.56600e-06 1.800 1.56605e-06 0.000 1.57200e-06 0.000
+ 1.57205e-06 1.800 1.57500e-06 1.800 1.57505e-06 0.000 1.58100e-06 0.000 1.58105e-06 1.800 1.59000e-06 1.800
+ 1.59005e-06 0.000 1.60200e-06 0.000 1.60205e-06 1.800 1.60500e-06 1.800 1.60505e-06 0.000 1.61100e-06 0.000
+ 1.61105e-06 1.800 1.61400e-06 1.800 1.61405e-06 0.000 1.62000e-06 0.000 1.62005e-06 1.800 1.62300e-06 1.800
+ 1.62305e-06 0.000 1.62600e-06 0.000 1.62605e-06 1.800 1.62900e-06 1.800 1.62905e-06 0.000 1.63200e-06 0.000
+ 1.63205e-06 1.800 1.63500e-06 1.800 1.63505e-06 0.000 1.64100e-06 0.000 1.64105e-06 1.800 1.64700e-06 1.800
+ 1.64705e-06 0.000 1.65300e-06 0.000 1.65305e-06 1.800 1.66500e-06 1.800 1.66505e-06 0.000 1.66800e-06 0.000
+ 1.66805e-06 1.800 1.67400e-06 1.800 1.67405e-06 0.000 1.67700e-06 0.000 1.67705e-06 1.800 1.68000e-06 1.800
+ 1.68005e-06 0.000 1.68600e-06 0.000 1.68605e-06 1.800 1.69200e-06 1.800 1.69205e-06 0.000 1.70100e-06 0.000
+ 1.70105e-06 1.800 1.70700e-06 1.800 1.70705e-06 0.000 1.71300e-06 0.000 1.71305e-06 1.800 1.72500e-06 1.800
+ 1.72505e-06 0.000 1.72800e-06 0.000 1.72805e-06 1.800 1.73700e-06 1.800 1.73705e-06 0.000 1.75800e-06 0.000
+ 1.75805e-06 1.800 1.76400e-06 1.800 1.76405e-06 0.000 1.77000e-06 0.000 1.77005e-06 1.800 1.78200e-06 1.800
+ 1.78205e-06 0.000 1.78500e-06 0.000 1.78505e-06 1.800 1.78800e-06 1.800 1.78805e-06 0.000 1.79400e-06 0.000
+ 1.79405e-06 1.800 1.79700e-06 1.800 1.79705e-06 0.000 1.80000e-06 0.000 1.80005e-06 1.800 1.80300e-06 1.800
+ 1.80305e-06 0.000 1.80600e-06 0.000 1.80605e-06 1.800 1.80900e-06 1.800 1.80905e-06 0.000 1.81200e-06 0.000
+ 1.81205e-06 1.800 1.81500e-06 1.800 1.81505e-06 0.000 1.81800e-06 0.000 1.81805e-06 1.800 1.82700e-06 1.800
+ 1.82705e-06 0.000 1.83300e-06 0.000 1.83305e-06 1.800 1.83600e-06 1.800 1.83605e-06 0.000 1.83900e-06 0.000
+ 1.83905e-06 1.800 1.84200e-06 1.800 1.84205e-06 0.000 1.84500e-06 0.000 1.84505e-06 1.800 1.85100e-06 1.800
+ 1.85105e-06 0.000 1.85700e-06 0.000 1.85705e-06 1.800 1.86000e-06 1.800 1.86005e-06 0.000 1.86300e-06 0.000
+ 1.86305e-06 1.800 1.86900e-06 1.800 1.86905e-06 0.000 1.87200e-06 0.000 1.87205e-06 1.800 1.87800e-06 1.800
+ 1.87805e-06 0.000 1.88700e-06 0.000 1.88705e-06 1.800 1.89900e-06 1.800 1.89905e-06 0.000 1.90800e-06 0.000
+ 1.90805e-06 1.800 1.91400e-06 1.800 1.91405e-06 0.000 1.91700e-06 0.000 1.91705e-06 1.800 1.92600e-06 1.800
+ 1.92605e-06 0.000 1.93500e-06 0.000 1.93505e-06 1.800 1.93800e-06 1.800 1.93805e-06 0.000 1.94100e-06 0.000
+ 1.94105e-06 1.800 1.94400e-06 1.800 1.94405e-06 0.000 1.96500e-06 0.000 1.96505e-06 1.800 1.96800e-06 1.800
+ 1.96805e-06 0.000 1.97100e-06 0.000 1.97105e-06 1.800 1.98000e-06 1.800 1.98005e-06 0.000 1.98300e-06 0.000
+ 1.98305e-06 1.800 1.98900e-06 1.800 1.98905e-06 0.000 1.99500e-06 0.000 1.99505e-06 1.800 2.00100e-06 1.800
+ 2.00105e-06 0.000 2.00400e-06 0.000 2.00405e-06 1.800 2.00700e-06 1.800 2.00705e-06 0.000 2.01000e-06 0.000
+ 2.01005e-06 1.800 2.01600e-06 1.800 2.01605e-06 0.000 2.01900e-06 0.000 2.01905e-06 1.800 2.02800e-06 1.800
+ 2.02805e-06 0.000 2.03100e-06 0.000 2.03105e-06 1.800 2.04300e-06 1.800 2.04305e-06 0.000 2.05200e-06 0.000
+ 2.05205e-06 1.800 2.05800e-06 1.800 2.05805e-06 0.000 2.06400e-06 0.000 2.06405e-06 1.800 2.07300e-06 1.800
+ 2.07305e-06 0.000 2.07600e-06 0.000 2.07605e-06 1.800 2.07900e-06 1.800 2.07905e-06 0.000 2.08200e-06 0.000
+ 2.08205e-06 1.800 2.09700e-06 1.800 2.09705e-06 0.000 2.10000e-06 0.000 2.10005e-06 1.800 2.11500e-06 1.800
+ 2.11505e-06 0.000 2.12100e-06 0.000 2.12105e-06 1.800 2.12700e-06 1.800 2.12705e-06 0.000 2.13600e-06 0.000
+ 2.13605e-06 1.800 2.13900e-06 1.800 2.13905e-06 0.000 2.14200e-06 0.000 2.14205e-06 1.800 2.14500e-06 1.800
+ 2.14505e-06 0.000 2.15100e-06 0.000 2.15105e-06 1.800 2.16000e-06 1.800 2.16005e-06 0.000 2.16300e-06 0.000
+ 2.16305e-06 1.800 2.16900e-06 1.800 2.16905e-06 0.000 2.17200e-06 0.000 2.17205e-06 1.800 2.17800e-06 1.800
+ 2.17805e-06 0.000 2.18400e-06 0.000 2.18405e-06 1.800 2.19000e-06 1.800 2.19005e-06 0.000 2.20800e-06 0.000
+ 2.20805e-06 1.800 2.22000e-06 1.800 2.22005e-06 0.000 2.22300e-06 0.000 2.22305e-06 1.800 2.22900e-06 1.800
+ 2.22905e-06 0.000 2.23500e-06 0.000 2.23505e-06 1.800 2.23800e-06 1.800 2.23805e-06 0.000 2.24100e-06 0.000
+ 2.24105e-06 1.800 2.25000e-06 1.800 2.25005e-06 0.000 2.26800e-06 0.000 2.26805e-06 1.800 2.27100e-06 1.800
+ 2.27105e-06 0.000 2.27700e-06 0.000 2.27705e-06 1.800 2.28000e-06 1.800 2.28005e-06 0.000 2.28300e-06 0.000
+ 2.28305e-06 1.800 2.28900e-06 1.800 2.28905e-06 0.000 2.29800e-06 0.000 2.29805e-06 1.800 2.30100e-06 1.800
+ 2.30105e-06 0.000 2.30700e-06 0.000 2.30705e-06 1.800 2.31300e-06 1.800 2.31305e-06 0.000 2.32200e-06 0.000
+ 2.32205e-06 1.800 2.33700e-06 1.800 2.33705e-06 0.000 2.35200e-06 0.000 2.35205e-06 1.800 2.35500e-06 1.800
+ 2.35505e-06 0.000 2.35800e-06 0.000 2.35805e-06 1.800 2.36700e-06 1.800 2.36705e-06 0.000 2.38800e-06 0.000
+ 2.38805e-06 1.800 2.39100e-06 1.800 2.39105e-06 0.000 2.39700e-06 0.000 2.39705e-06 1.800 2.40900e-06 1.800
+ 2.40905e-06 0.000 2.41200e-06 0.000 2.41205e-06 1.800 2.41800e-06 1.800 2.41805e-06 0.000 2.42400e-06 0.000
+ 2.42405e-06 1.800 2.42700e-06 1.800 2.42705e-06 0.000 2.43000e-06 0.000 2.43005e-06 1.800 2.43300e-06 1.800
+ 2.43305e-06 0.000 2.44200e-06 0.000 2.44205e-06 1.800 2.44800e-06 1.800 2.44805e-06 0.000 2.45400e-06 0.000
+ 2.45405e-06 1.800 2.46000e-06 1.800 2.46005e-06 0.000 2.46300e-06 0.000 2.46305e-06 1.800 2.46900e-06 1.800
+ 2.46905e-06 0.000 2.47200e-06 0.000 2.47205e-06 1.800 2.47500e-06 1.800 2.47505e-06 0.000 2.48100e-06 0.000
+ 2.48105e-06 1.800 2.48400e-06 1.800 2.48405e-06 0.000 2.49900e-06 0.000 2.49905e-06 1.800 2.50200e-06 1.800
+ 2.50205e-06 0.000 2.50500e-06 0.000 2.50505e-06 1.800 2.51400e-06 1.800 2.51405e-06 0.000 2.52000e-06 0.000
+ 2.52005e-06 1.800 2.52300e-06 1.800 2.52305e-06 0.000 2.52600e-06 0.000 2.52605e-06 1.800 2.52900e-06 1.800
+ 2.52905e-06 0.000 2.53200e-06 0.000 2.53205e-06 1.800 2.53500e-06 1.800 2.53505e-06 0.000 2.54700e-06 0.000
+ 2.54705e-06 1.800 2.55300e-06 1.800 2.55305e-06 0.000 2.56200e-06 0.000 2.56205e-06 1.800 2.57100e-06 1.800
+ 2.57105e-06 0.000 2.57400e-06 0.000 2.57405e-06 1.800 2.57700e-06 1.800 2.57705e-06 0.000 2.58300e-06 0.000
+ 2.58305e-06 1.800 2.58900e-06 1.800 2.58905e-06 0.000 2.59800e-06 0.000 2.59805e-06 1.800 2.60100e-06 1.800
+ 2.60105e-06 0.000 2.60400e-06 0.000 2.60405e-06 1.800 2.60700e-06 1.800 2.60705e-06 0.000 2.61000e-06 0.000
+ 2.61005e-06 1.800 2.61300e-06 1.800 2.61305e-06 0.000 2.61900e-06 0.000 2.61905e-06 1.800 2.62200e-06 1.800
+ 2.62205e-06 0.000 2.62500e-06 0.000 2.62505e-06 1.800 2.62800e-06 1.800 2.62805e-06 0.000 2.63100e-06 0.000
+ 2.63105e-06 1.800 2.63400e-06 1.800 2.63405e-06 0.000 2.63700e-06 0.000 2.63705e-06 1.800 2.64300e-06 1.800
+ 2.64305e-06 0.000 2.65500e-06 0.000 2.65505e-06 1.800 2.66400e-06 1.800 2.66405e-06 0.000 2.67000e-06 0.000
+ 2.67005e-06 1.800 2.67600e-06 1.800 2.67605e-06 0.000 2.68800e-06 0.000 2.68805e-06 1.800 2.69100e-06 1.800
+ 2.69105e-06 0.000 2.69700e-06 0.000 2.69705e-06 1.800 2.70300e-06 1.800 2.70305e-06 0.000 2.70600e-06 0.000
+ 2.70605e-06 1.800 2.70900e-06 1.800 2.70905e-06 0.000 2.71800e-06 0.000 2.71805e-06 1.800 2.72400e-06 1.800
+ 2.72405e-06 0.000 2.73600e-06 0.000 2.73605e-06 1.800 2.73900e-06 1.800 2.73905e-06 0.000 2.74500e-06 0.000
+ 2.74505e-06 1.800 2.74800e-06 1.800 2.74805e-06 0.000 2.75100e-06 0.000 2.75105e-06 1.800 2.76000e-06 1.800
+ 2.76005e-06 0.000 2.76300e-06 0.000 2.76305e-06 1.800 2.76600e-06 1.800 2.76605e-06 0.000 2.76900e-06 0.000
+ 2.76905e-06 1.800 2.77800e-06 1.800 2.77805e-06 0.000 2.78100e-06 0.000 2.78105e-06 1.800 2.80200e-06 1.800
+ 2.80205e-06 0.000 2.80800e-06 0.000 2.80805e-06 1.800 2.81400e-06 1.800 2.81405e-06 0.000 2.81700e-06 0.000
+ 2.81705e-06 1.800 2.82000e-06 1.800 2.82005e-06 0.000 2.82300e-06 0.000 2.82305e-06 1.800 2.82600e-06 1.800
+ 2.82605e-06 0.000 2.82900e-06 0.000 2.82905e-06 1.800 2.84100e-06 1.800 2.84105e-06 0.000 2.84400e-06 0.000
+ 2.84405e-06 1.800 2.85000e-06 1.800 2.85005e-06 0.000 2.86500e-06 0.000 2.86505e-06 1.800 2.88300e-06 1.800
+ 2.88305e-06 0.000 2.88900e-06 0.000 2.88905e-06 1.800 2.89200e-06 1.800 2.89205e-06 0.000 2.89800e-06 0.000
+ 2.89805e-06 1.800 2.90100e-06 1.800 2.90105e-06 0.000 2.91000e-06 0.000 2.91005e-06 1.800 2.91300e-06 1.800
+ 2.91305e-06 0.000 2.91600e-06 0.000 2.91605e-06 1.800 2.91900e-06 1.800 2.91905e-06 0.000 2.92200e-06 0.000
+ 2.92205e-06 1.800 2.92500e-06 1.800 2.92505e-06 0.000 2.92800e-06 0.000 2.92805e-06 1.800 2.93100e-06 1.800
+ 2.93105e-06 0.000 2.94300e-06 0.000 2.94305e-06 1.800 2.95500e-06 1.800 2.95505e-06 0.000 2.96400e-06 0.000
+ 2.96405e-06 1.800 2.97000e-06 1.800 2.97005e-06 0.000 2.97300e-06 0.000 2.97305e-06 1.800 2.99700e-06 1.800
+ 2.99705e-06 0.000 3.00300e-06 0.000 3.00305e-06 1.800 3.00600e-06 1.800 3.00605e-06 0.000 3.01200e-06 0.000
+ 3.01205e-06 1.800 3.01500e-06 1.800 3.01505e-06 0.000 3.01800e-06 0.000 3.01805e-06 1.800 3.02400e-06 1.800
+ 3.02405e-06 0.000 3.03300e-06 0.000 3.03305e-06 1.800 3.03900e-06 1.800 3.03905e-06 0.000 3.04200e-06 0.000
+ 3.04205e-06 1.800 3.05100e-06 1.800 3.05105e-06 0.000 3.05400e-06 0.000 3.05405e-06 1.800 3.05700e-06 1.800
+ 3.05705e-06 0.000 3.06300e-06 0.000 3.06305e-06 1.800 3.06600e-06 1.800 3.06605e-06 0.000 3.06900e-06 0.000
+ 3.06905e-06 1.800 3.07200e-06 1.800
+ )
Xd_b3 src_b3 b3 vdd gnd tb_inv
Vc0 src_c0 gnd PWL(
+ 0.00000e+00 1.800 3.00000e-09 1.800 3.05000e-09 0.000 6.00000e-09 0.000 6.05000e-09 1.800 9.00000e-09 1.800
+ 9.05000e-09 0.000 1.20000e-08 0.000 1.20500e-08 1.800 1.50000e-08 1.800 1.50500e-08 0.000 1.80000e-08 0.000
+ 1.80500e-08 1.800 2.10000e-08 1.800 2.10500e-08 0.000 2.40000e-08 0.000 2.40500e-08 1.800 2.70000e-08 1.800
+ 2.70500e-08 0.000 3.00000e-08 0.000 3.00500e-08 1.800 3.30000e-08 1.800 3.30500e-08 0.000 3.60000e-08 0.000
+ 3.60500e-08 1.800 3.90000e-08 1.800 3.90500e-08 0.000 4.20000e-08 0.000 4.20500e-08 1.800 4.50000e-08 1.800
+ 4.50500e-08 0.000 4.80000e-08 0.000 4.80500e-08 1.800 5.10000e-08 1.800 5.10500e-08 0.000 5.40000e-08 0.000
+ 5.40500e-08 1.800 5.70000e-08 1.800 5.70500e-08 0.000 6.00000e-08 0.000 6.00500e-08 1.800 6.30000e-08 1.800
+ 6.30500e-08 0.000 6.60000e-08 0.000 6.60500e-08 1.800 6.90000e-08 1.800 6.90500e-08 0.000 7.20000e-08 0.000
+ 7.20500e-08 1.800 7.50000e-08 1.800 7.50500e-08 0.000 7.80000e-08 0.000 7.80500e-08 1.800 8.10000e-08 1.800
+ 8.10500e-08 0.000 8.40000e-08 0.000 8.40500e-08 1.800 8.70000e-08 1.800 8.70500e-08 0.000 9.00000e-08 0.000
+ 9.00500e-08 1.800 9.30000e-08 1.800 9.30500e-08 0.000 9.60000e-08 0.000 9.60500e-08 1.800 9.90000e-08 1.800
+ 9.90500e-08 0.000 1.02000e-07 0.000 1.02050e-07 1.800 1.05000e-07 1.800 1.05050e-07 0.000 1.08000e-07 0.000
+ 1.08050e-07 1.800 1.11000e-07 1.800 1.11050e-07 0.000 1.14000e-07 0.000 1.14050e-07 1.800 1.17000e-07 1.800
+ 1.17050e-07 0.000 1.20000e-07 0.000 1.20050e-07 1.800 1.23000e-07 1.800 1.23050e-07 0.000 1.26000e-07 0.000
+ 1.26050e-07 1.800 1.29000e-07 1.800 1.29050e-07 0.000 1.32000e-07 0.000 1.32050e-07 1.800 1.35000e-07 1.800
+ 1.35050e-07 0.000 1.38000e-07 0.000 1.38050e-07 1.800 1.41000e-07 1.800 1.41050e-07 0.000 1.44000e-07 0.000
+ 1.44050e-07 1.800 1.47000e-07 1.800 1.47050e-07 0.000 1.50000e-07 0.000 1.50050e-07 1.800 1.53000e-07 1.800
+ 1.53050e-07 0.000 1.56000e-07 0.000 1.56050e-07 1.800 1.59000e-07 1.800 1.59050e-07 0.000 1.62000e-07 0.000
+ 1.62050e-07 1.800 1.65000e-07 1.800 1.65050e-07 0.000 1.68000e-07 0.000 1.68050e-07 1.800 1.71000e-07 1.800
+ 1.71050e-07 0.000 1.74000e-07 0.000 1.74050e-07 1.800 1.77000e-07 1.800 1.77050e-07 0.000 1.80000e-07 0.000
+ 1.80050e-07 1.800 1.83000e-07 1.800 1.83050e-07 0.000 1.86000e-07 0.000 1.86050e-07 1.800 1.89000e-07 1.800
+ 1.89050e-07 0.000 1.92000e-07 0.000 1.92050e-07 1.800 1.95000e-07 1.800 1.95050e-07 0.000 1.98000e-07 0.000
+ 1.98050e-07 1.800 2.01000e-07 1.800 2.01050e-07 0.000 2.04000e-07 0.000 2.04050e-07 1.800 2.07000e-07 1.800
+ 2.07050e-07 0.000 2.10000e-07 0.000 2.10050e-07 1.800 2.13000e-07 1.800 2.13050e-07 0.000 2.16000e-07 0.000
+ 2.16050e-07 1.800 2.19000e-07 1.800 2.19050e-07 0.000 2.22000e-07 0.000 2.22050e-07 1.800 2.25000e-07 1.800
+ 2.25050e-07 0.000 2.28000e-07 0.000 2.28050e-07 1.800 2.31000e-07 1.800 2.31050e-07 0.000 2.34000e-07 0.000
+ 2.34050e-07 1.800 2.37000e-07 1.800 2.37050e-07 0.000 2.40000e-07 0.000 2.40050e-07 1.800 2.43000e-07 1.800
+ 2.43050e-07 0.000 2.46000e-07 0.000 2.46050e-07 1.800 2.49000e-07 1.800 2.49050e-07 0.000 2.52000e-07 0.000
+ 2.52050e-07 1.800 2.55000e-07 1.800 2.55050e-07 0.000 2.58000e-07 0.000 2.58050e-07 1.800 2.61000e-07 1.800
+ 2.61050e-07 0.000 2.64000e-07 0.000 2.64050e-07 1.800 2.67000e-07 1.800 2.67050e-07 0.000 2.70000e-07 0.000
+ 2.70050e-07 1.800 2.73000e-07 1.800 2.73050e-07 0.000 2.76000e-07 0.000 2.76050e-07 1.800 2.79000e-07 1.800
+ 2.79050e-07 0.000 2.82000e-07 0.000 2.82050e-07 1.800 2.85000e-07 1.800 2.85050e-07 0.000 2.88000e-07 0.000
+ 2.88050e-07 1.800 2.91000e-07 1.800 2.91050e-07 0.000 2.94000e-07 0.000 2.94050e-07 1.800 2.97000e-07 1.800
+ 2.97050e-07 0.000 3.00000e-07 0.000 3.00050e-07 1.800 3.03000e-07 1.800 3.03050e-07 0.000 3.06000e-07 0.000
+ 3.06050e-07 1.800 3.09000e-07 1.800 3.09050e-07 0.000 3.12000e-07 0.000 3.12050e-07 1.800 3.15000e-07 1.800
+ 3.15050e-07 0.000 3.18000e-07 0.000 3.18050e-07 1.800 3.21000e-07 1.800 3.21050e-07 0.000 3.24000e-07 0.000
+ 3.24050e-07 1.800 3.27000e-07 1.800 3.27050e-07 0.000 3.30000e-07 0.000 3.30050e-07 1.800 3.33000e-07 1.800
+ 3.33050e-07 0.000 3.36000e-07 0.000 3.36050e-07 1.800 3.39000e-07 1.800 3.39050e-07 0.000 3.42000e-07 0.000
+ 3.42050e-07 1.800 3.45000e-07 1.800 3.45050e-07 0.000 3.48000e-07 0.000 3.48050e-07 1.800 3.51000e-07 1.800
+ 3.51050e-07 0.000 3.54000e-07 0.000 3.54050e-07 1.800 3.57000e-07 1.800 3.57050e-07 0.000 3.60000e-07 0.000
+ 3.60050e-07 1.800 3.63000e-07 1.800 3.63050e-07 0.000 3.66000e-07 0.000 3.66050e-07 1.800 3.69000e-07 1.800
+ 3.69050e-07 0.000 3.72000e-07 0.000 3.72050e-07 1.800 3.75000e-07 1.800 3.75050e-07 0.000 3.78000e-07 0.000
+ 3.78050e-07 1.800 3.81000e-07 1.800 3.81050e-07 0.000 3.84000e-07 0.000 3.84050e-07 1.800 3.87000e-07 1.800
+ 3.87050e-07 0.000 3.90000e-07 0.000 3.90050e-07 1.800 3.93000e-07 1.800 3.93050e-07 0.000 3.96000e-07 0.000
+ 3.96050e-07 1.800 3.99000e-07 1.800 3.99050e-07 0.000 4.02000e-07 0.000 4.02050e-07 1.800 4.05000e-07 1.800
+ 4.05050e-07 0.000 4.08000e-07 0.000 4.08050e-07 1.800 4.11000e-07 1.800 4.11050e-07 0.000 4.14000e-07 0.000
+ 4.14050e-07 1.800 4.17000e-07 1.800 4.17050e-07 0.000 4.20000e-07 0.000 4.20050e-07 1.800 4.23000e-07 1.800
+ 4.23050e-07 0.000 4.26000e-07 0.000 4.26050e-07 1.800 4.29000e-07 1.800 4.29050e-07 0.000 4.32000e-07 0.000
+ 4.32050e-07 1.800 4.35000e-07 1.800 4.35050e-07 0.000 4.38000e-07 0.000 4.38050e-07 1.800 4.41000e-07 1.800
+ 4.41050e-07 0.000 4.44000e-07 0.000 4.44050e-07 1.800 4.47000e-07 1.800 4.47050e-07 0.000 4.50000e-07 0.000
+ 4.50050e-07 1.800 4.53000e-07 1.800 4.53050e-07 0.000 4.56000e-07 0.000 4.56050e-07 1.800 4.59000e-07 1.800
+ 4.59050e-07 0.000 4.62000e-07 0.000 4.62050e-07 1.800 4.65000e-07 1.800 4.65050e-07 0.000 4.68000e-07 0.000
+ 4.68050e-07 1.800 4.71000e-07 1.800 4.71050e-07 0.000 4.74000e-07 0.000 4.74050e-07 1.800 4.77000e-07 1.800
+ 4.77050e-07 0.000 4.80000e-07 0.000 4.80050e-07 1.800 4.83000e-07 1.800 4.83050e-07 0.000 4.86000e-07 0.000
+ 4.86050e-07 1.800 4.89000e-07 1.800 4.89050e-07 0.000 4.92000e-07 0.000 4.92050e-07 1.800 4.95000e-07 1.800
+ 4.95050e-07 0.000 4.98000e-07 0.000 4.98050e-07 1.800 5.01000e-07 1.800 5.01050e-07 0.000 5.04000e-07 0.000
+ 5.04050e-07 1.800 5.07000e-07 1.800 5.07050e-07 0.000 5.10000e-07 0.000 5.10050e-07 1.800 5.13000e-07 1.800
+ 5.13050e-07 0.000 5.16000e-07 0.000 5.16050e-07 1.800 5.19000e-07 1.800 5.19050e-07 0.000 5.22000e-07 0.000
+ 5.22050e-07 1.800 5.25000e-07 1.800 5.25050e-07 0.000 5.28000e-07 0.000 5.28050e-07 1.800 5.31000e-07 1.800
+ 5.31050e-07 0.000 5.34000e-07 0.000 5.34050e-07 1.800 5.37000e-07 1.800 5.37050e-07 0.000 5.40000e-07 0.000
+ 5.40050e-07 1.800 5.43000e-07 1.800 5.43050e-07 0.000 5.46000e-07 0.000 5.46050e-07 1.800 5.49000e-07 1.800
+ 5.49050e-07 0.000 5.52000e-07 0.000 5.52050e-07 1.800 5.55000e-07 1.800 5.55050e-07 0.000 5.58000e-07 0.000
+ 5.58050e-07 1.800 5.61000e-07 1.800 5.61050e-07 0.000 5.64000e-07 0.000 5.64050e-07 1.800 5.67000e-07 1.800
+ 5.67050e-07 0.000 5.70000e-07 0.000 5.70050e-07 1.800 5.73000e-07 1.800 5.73050e-07 0.000 5.76000e-07 0.000
+ 5.76050e-07 1.800 5.79000e-07 1.800 5.79050e-07 0.000 5.82000e-07 0.000 5.82050e-07 1.800 5.85000e-07 1.800
+ 5.85050e-07 0.000 5.88000e-07 0.000 5.88050e-07 1.800 5.91000e-07 1.800 5.91050e-07 0.000 5.94000e-07 0.000
+ 5.94050e-07 1.800 5.97000e-07 1.800 5.97050e-07 0.000 6.00000e-07 0.000 6.00050e-07 1.800 6.03000e-07 1.800
+ 6.03050e-07 0.000 6.06000e-07 0.000 6.06050e-07 1.800 6.09000e-07 1.800 6.09050e-07 0.000 6.12000e-07 0.000
+ 6.12050e-07 1.800 6.15000e-07 1.800 6.15050e-07 0.000 6.18000e-07 0.000 6.18050e-07 1.800 6.21000e-07 1.800
+ 6.21050e-07 0.000 6.24000e-07 0.000 6.24050e-07 1.800 6.27000e-07 1.800 6.27050e-07 0.000 6.30000e-07 0.000
+ 6.30050e-07 1.800 6.33000e-07 1.800 6.33050e-07 0.000 6.36000e-07 0.000 6.36050e-07 1.800 6.39000e-07 1.800
+ 6.39050e-07 0.000 6.42000e-07 0.000 6.42050e-07 1.800 6.45000e-07 1.800 6.45050e-07 0.000 6.48000e-07 0.000
+ 6.48050e-07 1.800 6.51000e-07 1.800 6.51050e-07 0.000 6.54000e-07 0.000 6.54050e-07 1.800 6.57000e-07 1.800
+ 6.57050e-07 0.000 6.60000e-07 0.000 6.60050e-07 1.800 6.63000e-07 1.800 6.63050e-07 0.000 6.66000e-07 0.000
+ 6.66050e-07 1.800 6.69000e-07 1.800 6.69050e-07 0.000 6.72000e-07 0.000 6.72050e-07 1.800 6.75000e-07 1.800
+ 6.75050e-07 0.000 6.78000e-07 0.000 6.78050e-07 1.800 6.81000e-07 1.800 6.81050e-07 0.000 6.84000e-07 0.000
+ 6.84050e-07 1.800 6.87000e-07 1.800 6.87050e-07 0.000 6.90000e-07 0.000 6.90050e-07 1.800 6.93000e-07 1.800
+ 6.93050e-07 0.000 6.96000e-07 0.000 6.96050e-07 1.800 6.99000e-07 1.800 6.99050e-07 0.000 7.02000e-07 0.000
+ 7.02050e-07 1.800 7.05000e-07 1.800 7.05050e-07 0.000 7.08000e-07 0.000 7.08050e-07 1.800 7.11000e-07 1.800
+ 7.11050e-07 0.000 7.14000e-07 0.000 7.14050e-07 1.800 7.17000e-07 1.800 7.17050e-07 0.000 7.20000e-07 0.000
+ 7.20050e-07 1.800 7.23000e-07 1.800 7.23050e-07 0.000 7.26000e-07 0.000 7.26050e-07 1.800 7.29000e-07 1.800
+ 7.29050e-07 0.000 7.32000e-07 0.000 7.32050e-07 1.800 7.35000e-07 1.800 7.35050e-07 0.000 7.38000e-07 0.000
+ 7.38050e-07 1.800 7.41000e-07 1.800 7.41050e-07 0.000 7.44000e-07 0.000 7.44050e-07 1.800 7.47000e-07 1.800
+ 7.47050e-07 0.000 7.50000e-07 0.000 7.50050e-07 1.800 7.53000e-07 1.800 7.53050e-07 0.000 7.56000e-07 0.000
+ 7.56050e-07 1.800 7.59000e-07 1.800 7.59050e-07 0.000 7.62000e-07 0.000 7.62050e-07 1.800 7.65000e-07 1.800
+ 7.65050e-07 0.000 7.68000e-07 0.000 7.68050e-07 1.800 7.71000e-07 1.800 7.71050e-07 0.000 7.74000e-07 0.000
+ 7.74050e-07 1.800 7.77000e-07 1.800 7.77050e-07 0.000 7.80000e-07 0.000 7.80050e-07 1.800 7.83000e-07 1.800
+ 7.83050e-07 0.000 7.86000e-07 0.000 7.86050e-07 1.800 7.89000e-07 1.800 7.89050e-07 0.000 7.92000e-07 0.000
+ 7.92050e-07 1.800 7.95000e-07 1.800 7.95050e-07 0.000 7.98000e-07 0.000 7.98050e-07 1.800 8.01000e-07 1.800
+ 8.01050e-07 0.000 8.04000e-07 0.000 8.04050e-07 1.800 8.07000e-07 1.800 8.07050e-07 0.000 8.10000e-07 0.000
+ 8.10050e-07 1.800 8.13000e-07 1.800 8.13050e-07 0.000 8.16000e-07 0.000 8.16050e-07 1.800 8.19000e-07 1.800
+ 8.19050e-07 0.000 8.22000e-07 0.000 8.22050e-07 1.800 8.25000e-07 1.800 8.25050e-07 0.000 8.28000e-07 0.000
+ 8.28050e-07 1.800 8.31000e-07 1.800 8.31050e-07 0.000 8.34000e-07 0.000 8.34050e-07 1.800 8.37000e-07 1.800
+ 8.37050e-07 0.000 8.40000e-07 0.000 8.40050e-07 1.800 8.43000e-07 1.800 8.43050e-07 0.000 8.46000e-07 0.000
+ 8.46050e-07 1.800 8.49000e-07 1.800 8.49050e-07 0.000 8.52000e-07 0.000 8.52050e-07 1.800 8.55000e-07 1.800
+ 8.55050e-07 0.000 8.58000e-07 0.000 8.58050e-07 1.800 8.61000e-07 1.800 8.61050e-07 0.000 8.64000e-07 0.000
+ 8.64050e-07 1.800 8.67000e-07 1.800 8.67050e-07 0.000 8.70000e-07 0.000 8.70050e-07 1.800 8.73000e-07 1.800
+ 8.73050e-07 0.000 8.76000e-07 0.000 8.76050e-07 1.800 8.79000e-07 1.800 8.79050e-07 0.000 8.82000e-07 0.000
+ 8.82050e-07 1.800 8.85000e-07 1.800 8.85050e-07 0.000 8.88000e-07 0.000 8.88050e-07 1.800 8.91000e-07 1.800
+ 8.91050e-07 0.000 8.94000e-07 0.000 8.94050e-07 1.800 8.97000e-07 1.800 8.97050e-07 0.000 9.00000e-07 0.000
+ 9.00050e-07 1.800 9.03000e-07 1.800 9.03050e-07 0.000 9.06000e-07 0.000 9.06050e-07 1.800 9.09000e-07 1.800
+ 9.09050e-07 0.000 9.12000e-07 0.000 9.12050e-07 1.800 9.15000e-07 1.800 9.15050e-07 0.000 9.18000e-07 0.000
+ 9.18050e-07 1.800 9.21000e-07 1.800 9.21050e-07 0.000 9.24000e-07 0.000 9.24050e-07 1.800 9.27000e-07 1.800
+ 9.27050e-07 0.000 9.30000e-07 0.000 9.30050e-07 1.800 9.33000e-07 1.800 9.33050e-07 0.000 9.36000e-07 0.000
+ 9.36050e-07 1.800 9.39000e-07 1.800 9.39050e-07 0.000 9.42000e-07 0.000 9.42050e-07 1.800 9.45000e-07 1.800
+ 9.45050e-07 0.000 9.48000e-07 0.000 9.48050e-07 1.800 9.51000e-07 1.800 9.51050e-07 0.000 9.54000e-07 0.000
+ 9.54050e-07 1.800 9.57000e-07 1.800 9.57050e-07 0.000 9.60000e-07 0.000 9.60050e-07 1.800 9.63000e-07 1.800
+ 9.63050e-07 0.000 9.66000e-07 0.000 9.66050e-07 1.800 9.69000e-07 1.800 9.69050e-07 0.000 9.72000e-07 0.000
+ 9.72050e-07 1.800 9.75000e-07 1.800 9.75050e-07 0.000 9.78000e-07 0.000 9.78050e-07 1.800 9.81000e-07 1.800
+ 9.81050e-07 0.000 9.84000e-07 0.000 9.84050e-07 1.800 9.87000e-07 1.800 9.87050e-07 0.000 9.90000e-07 0.000
+ 9.90050e-07 1.800 9.93000e-07 1.800 9.93050e-07 0.000 9.96000e-07 0.000 9.96050e-07 1.800 9.99000e-07 1.800
+ 9.99050e-07 0.000 1.00200e-06 0.000 1.00205e-06 1.800 1.00500e-06 1.800 1.00505e-06 0.000 1.00800e-06 0.000
+ 1.00805e-06 1.800 1.01100e-06 1.800 1.01105e-06 0.000 1.01400e-06 0.000 1.01405e-06 1.800 1.01700e-06 1.800
+ 1.01705e-06 0.000 1.02000e-06 0.000 1.02005e-06 1.800 1.02300e-06 1.800 1.02305e-06 0.000 1.02600e-06 0.000
+ 1.02605e-06 1.800 1.02900e-06 1.800 1.02905e-06 0.000 1.03200e-06 0.000 1.03205e-06 1.800 1.03500e-06 1.800
+ 1.03505e-06 0.000 1.03800e-06 0.000 1.03805e-06 1.800 1.04100e-06 1.800 1.04105e-06 0.000 1.04400e-06 0.000
+ 1.04405e-06 1.800 1.04700e-06 1.800 1.04705e-06 0.000 1.05000e-06 0.000 1.05005e-06 1.800 1.05300e-06 1.800
+ 1.05305e-06 0.000 1.05600e-06 0.000 1.05605e-06 1.800 1.05900e-06 1.800 1.05905e-06 0.000 1.06200e-06 0.000
+ 1.06205e-06 1.800 1.06500e-06 1.800 1.06505e-06 0.000 1.06800e-06 0.000 1.06805e-06 1.800 1.07100e-06 1.800
+ 1.07105e-06 0.000 1.07400e-06 0.000 1.07405e-06 1.800 1.07700e-06 1.800 1.07705e-06 0.000 1.08000e-06 0.000
+ 1.08005e-06 1.800 1.08300e-06 1.800 1.08305e-06 0.000 1.08600e-06 0.000 1.08605e-06 1.800 1.08900e-06 1.800
+ 1.08905e-06 0.000 1.09200e-06 0.000 1.09205e-06 1.800 1.09500e-06 1.800 1.09505e-06 0.000 1.09800e-06 0.000
+ 1.09805e-06 1.800 1.10100e-06 1.800 1.10105e-06 0.000 1.10400e-06 0.000 1.10405e-06 1.800 1.10700e-06 1.800
+ 1.10705e-06 0.000 1.11000e-06 0.000 1.11005e-06 1.800 1.11300e-06 1.800 1.11305e-06 0.000 1.11600e-06 0.000
+ 1.11605e-06 1.800 1.11900e-06 1.800 1.11905e-06 0.000 1.12200e-06 0.000 1.12205e-06 1.800 1.12500e-06 1.800
+ 1.12505e-06 0.000 1.12800e-06 0.000 1.12805e-06 1.800 1.13100e-06 1.800 1.13105e-06 0.000 1.13400e-06 0.000
+ 1.13405e-06 1.800 1.13700e-06 1.800 1.13705e-06 0.000 1.14000e-06 0.000 1.14005e-06 1.800 1.14300e-06 1.800
+ 1.14305e-06 0.000 1.14600e-06 0.000 1.14605e-06 1.800 1.14900e-06 1.800 1.14905e-06 0.000 1.15200e-06 0.000
+ 1.15205e-06 1.800 1.15500e-06 1.800 1.15505e-06 0.000 1.15800e-06 0.000 1.15805e-06 1.800 1.16100e-06 1.800
+ 1.16105e-06 0.000 1.16400e-06 0.000 1.16405e-06 1.800 1.16700e-06 1.800 1.16705e-06 0.000 1.17000e-06 0.000
+ 1.17005e-06 1.800 1.17300e-06 1.800 1.17305e-06 0.000 1.17600e-06 0.000 1.17605e-06 1.800 1.17900e-06 1.800
+ 1.17905e-06 0.000 1.18200e-06 0.000 1.18205e-06 1.800 1.18500e-06 1.800 1.18505e-06 0.000 1.18800e-06 0.000
+ 1.18805e-06 1.800 1.19100e-06 1.800 1.19105e-06 0.000 1.19400e-06 0.000 1.19405e-06 1.800 1.19700e-06 1.800
+ 1.19705e-06 0.000 1.20000e-06 0.000 1.20005e-06 1.800 1.20300e-06 1.800 1.20305e-06 0.000 1.20600e-06 0.000
+ 1.20605e-06 1.800 1.20900e-06 1.800 1.20905e-06 0.000 1.21200e-06 0.000 1.21205e-06 1.800 1.21500e-06 1.800
+ 1.21505e-06 0.000 1.21800e-06 0.000 1.21805e-06 1.800 1.22100e-06 1.800 1.22105e-06 0.000 1.22400e-06 0.000
+ 1.22405e-06 1.800 1.22700e-06 1.800 1.22705e-06 0.000 1.23000e-06 0.000 1.23005e-06 1.800 1.23300e-06 1.800
+ 1.23305e-06 0.000 1.23600e-06 0.000 1.23605e-06 1.800 1.23900e-06 1.800 1.23905e-06 0.000 1.24200e-06 0.000
+ 1.24205e-06 1.800 1.24500e-06 1.800 1.24505e-06 0.000 1.24800e-06 0.000 1.24805e-06 1.800 1.25100e-06 1.800
+ 1.25105e-06 0.000 1.25400e-06 0.000 1.25405e-06 1.800 1.25700e-06 1.800 1.25705e-06 0.000 1.26000e-06 0.000
+ 1.26005e-06 1.800 1.26300e-06 1.800 1.26305e-06 0.000 1.26600e-06 0.000 1.26605e-06 1.800 1.26900e-06 1.800
+ 1.26905e-06 0.000 1.27200e-06 0.000 1.27205e-06 1.800 1.27500e-06 1.800 1.27505e-06 0.000 1.27800e-06 0.000
+ 1.27805e-06 1.800 1.28100e-06 1.800 1.28105e-06 0.000 1.28400e-06 0.000 1.28405e-06 1.800 1.28700e-06 1.800
+ 1.28705e-06 0.000 1.29000e-06 0.000 1.29005e-06 1.800 1.29300e-06 1.800 1.29305e-06 0.000 1.29600e-06 0.000
+ 1.29605e-06 1.800 1.29900e-06 1.800 1.29905e-06 0.000 1.30200e-06 0.000 1.30205e-06 1.800 1.30500e-06 1.800
+ 1.30505e-06 0.000 1.30800e-06 0.000 1.30805e-06 1.800 1.31100e-06 1.800 1.31105e-06 0.000 1.31400e-06 0.000
+ 1.31405e-06 1.800 1.31700e-06 1.800 1.31705e-06 0.000 1.32000e-06 0.000 1.32005e-06 1.800 1.32300e-06 1.800
+ 1.32305e-06 0.000 1.32600e-06 0.000 1.32605e-06 1.800 1.32900e-06 1.800 1.32905e-06 0.000 1.33200e-06 0.000
+ 1.33205e-06 1.800 1.33500e-06 1.800 1.33505e-06 0.000 1.33800e-06 0.000 1.33805e-06 1.800 1.34100e-06 1.800
+ 1.34105e-06 0.000 1.34400e-06 0.000 1.34405e-06 1.800 1.34700e-06 1.800 1.34705e-06 0.000 1.35000e-06 0.000
+ 1.35005e-06 1.800 1.35300e-06 1.800 1.35305e-06 0.000 1.35600e-06 0.000 1.35605e-06 1.800 1.35900e-06 1.800
+ 1.35905e-06 0.000 1.36200e-06 0.000 1.36205e-06 1.800 1.36500e-06 1.800 1.36505e-06 0.000 1.36800e-06 0.000
+ 1.36805e-06 1.800 1.37100e-06 1.800 1.37105e-06 0.000 1.37400e-06 0.000 1.37405e-06 1.800 1.37700e-06 1.800
+ 1.37705e-06 0.000 1.38000e-06 0.000 1.38005e-06 1.800 1.38300e-06 1.800 1.38305e-06 0.000 1.38600e-06 0.000
+ 1.38605e-06 1.800 1.38900e-06 1.800 1.38905e-06 0.000 1.39200e-06 0.000 1.39205e-06 1.800 1.39500e-06 1.800
+ 1.39505e-06 0.000 1.39800e-06 0.000 1.39805e-06 1.800 1.40100e-06 1.800 1.40105e-06 0.000 1.40400e-06 0.000
+ 1.40405e-06 1.800 1.40700e-06 1.800 1.40705e-06 0.000 1.41000e-06 0.000 1.41005e-06 1.800 1.41300e-06 1.800
+ 1.41305e-06 0.000 1.41600e-06 0.000 1.41605e-06 1.800 1.41900e-06 1.800 1.41905e-06 0.000 1.42200e-06 0.000
+ 1.42205e-06 1.800 1.42500e-06 1.800 1.42505e-06 0.000 1.42800e-06 0.000 1.42805e-06 1.800 1.43100e-06 1.800
+ 1.43105e-06 0.000 1.43400e-06 0.000 1.43405e-06 1.800 1.43700e-06 1.800 1.43705e-06 0.000 1.44000e-06 0.000
+ 1.44005e-06 1.800 1.44300e-06 1.800 1.44305e-06 0.000 1.44600e-06 0.000 1.44605e-06 1.800 1.44900e-06 1.800
+ 1.44905e-06 0.000 1.45200e-06 0.000 1.45205e-06 1.800 1.45500e-06 1.800 1.45505e-06 0.000 1.45800e-06 0.000
+ 1.45805e-06 1.800 1.46100e-06 1.800 1.46105e-06 0.000 1.46400e-06 0.000 1.46405e-06 1.800 1.46700e-06 1.800
+ 1.46705e-06 0.000 1.47000e-06 0.000 1.47005e-06 1.800 1.47300e-06 1.800 1.47305e-06 0.000 1.47600e-06 0.000
+ 1.47605e-06 1.800 1.47900e-06 1.800 1.47905e-06 0.000 1.48200e-06 0.000 1.48205e-06 1.800 1.48500e-06 1.800
+ 1.48505e-06 0.000 1.48800e-06 0.000 1.48805e-06 1.800 1.49100e-06 1.800 1.49105e-06 0.000 1.49400e-06 0.000
+ 1.49405e-06 1.800 1.49700e-06 1.800 1.49705e-06 0.000 1.50000e-06 0.000 1.50005e-06 1.800 1.50300e-06 1.800
+ 1.50305e-06 0.000 1.50600e-06 0.000 1.50605e-06 1.800 1.50900e-06 1.800 1.50905e-06 0.000 1.51200e-06 0.000
+ 1.51205e-06 1.800 1.51500e-06 1.800 1.51505e-06 0.000 1.51800e-06 0.000 1.51805e-06 1.800 1.52100e-06 1.800
+ 1.52105e-06 0.000 1.52400e-06 0.000 1.52405e-06 1.800 1.52700e-06 1.800 1.52705e-06 0.000 1.53000e-06 0.000
+ 1.53005e-06 1.800 1.53300e-06 1.800 1.53305e-06 0.000 1.53600e-06 0.000 1.53605e-06 1.800 1.53900e-06 1.800
+ 1.53905e-06 0.000 1.54800e-06 0.000 1.54805e-06 1.800 1.55100e-06 1.800 1.55105e-06 0.000 1.56300e-06 0.000
+ 1.56305e-06 1.800 1.56600e-06 1.800 1.56605e-06 0.000 1.56900e-06 0.000 1.56905e-06 1.800 1.57200e-06 1.800
+ 1.57205e-06 0.000 1.57500e-06 0.000 1.57505e-06 1.800 1.57800e-06 1.800 1.57805e-06 0.000 1.58100e-06 0.000
+ 1.58105e-06 1.800 1.58400e-06 1.800 1.58405e-06 0.000 1.58700e-06 0.000 1.58705e-06 1.800 1.59300e-06 1.800
+ 1.59305e-06 0.000 1.59900e-06 0.000 1.59905e-06 1.800 1.61400e-06 1.800 1.61405e-06 0.000 1.61700e-06 0.000
+ 1.61705e-06 1.800 1.62000e-06 1.800 1.62005e-06 0.000 1.62300e-06 0.000 1.62305e-06 1.800 1.62600e-06 1.800
+ 1.62605e-06 0.000 1.62900e-06 0.000 1.62905e-06 1.800 1.63800e-06 1.800 1.63805e-06 0.000 1.65300e-06 0.000
+ 1.65305e-06 1.800 1.65600e-06 1.800 1.65605e-06 0.000 1.66200e-06 0.000 1.66205e-06 1.800 1.66500e-06 1.800
+ 1.66505e-06 0.000 1.67400e-06 0.000 1.67405e-06 1.800 1.67700e-06 1.800 1.67705e-06 0.000 1.68900e-06 0.000
+ 1.68905e-06 1.800 1.69200e-06 1.800 1.69205e-06 0.000 1.69500e-06 0.000 1.69505e-06 1.800 1.70100e-06 1.800
+ 1.70105e-06 0.000 1.70400e-06 0.000 1.70405e-06 1.800 1.70700e-06 1.800 1.70705e-06 0.000 1.71600e-06 0.000
+ 1.71605e-06 1.800 1.72500e-06 1.800 1.72505e-06 0.000 1.72800e-06 0.000 1.72805e-06 1.800 1.73400e-06 1.800
+ 1.73405e-06 0.000 1.73700e-06 0.000 1.73705e-06 1.800 1.74300e-06 1.800 1.74305e-06 0.000 1.75500e-06 0.000
+ 1.75505e-06 1.800 1.76400e-06 1.800 1.76405e-06 0.000 1.76700e-06 0.000 1.76705e-06 1.800 1.77300e-06 1.800
+ 1.77305e-06 0.000 1.77900e-06 0.000 1.77905e-06 1.800 1.78200e-06 1.800 1.78205e-06 0.000 1.79700e-06 0.000
+ 1.79705e-06 1.800 1.80600e-06 1.800 1.80605e-06 0.000 1.81200e-06 0.000 1.81205e-06 1.800 1.82700e-06 1.800
+ 1.82705e-06 0.000 1.84200e-06 0.000 1.84205e-06 1.800 1.84800e-06 1.800 1.84805e-06 0.000 1.85100e-06 0.000
+ 1.85105e-06 1.800 1.85700e-06 1.800 1.85705e-06 0.000 1.86300e-06 0.000 1.86305e-06 1.800 1.86600e-06 1.800
+ 1.86605e-06 0.000 1.86900e-06 0.000 1.86905e-06 1.800 1.87200e-06 1.800 1.87205e-06 0.000 1.88400e-06 0.000
+ 1.88405e-06 1.800 1.88700e-06 1.800 1.88705e-06 0.000 1.89000e-06 0.000 1.89005e-06 1.800 1.89300e-06 1.800
+ 1.89305e-06 0.000 1.90500e-06 0.000 1.90505e-06 1.800 1.91100e-06 1.800 1.91105e-06 0.000 1.91400e-06 0.000
+ 1.91405e-06 1.800 1.91700e-06 1.800 1.91705e-06 0.000 1.92000e-06 0.000 1.92005e-06 1.800 1.92300e-06 1.800
+ 1.92305e-06 0.000 1.93200e-06 0.000 1.93205e-06 1.800 1.93800e-06 1.800 1.93805e-06 0.000 1.94100e-06 0.000
+ 1.94105e-06 1.800 1.94400e-06 1.800 1.94405e-06 0.000 1.94700e-06 0.000 1.94705e-06 1.800 1.95000e-06 1.800
+ 1.95005e-06 0.000 1.95600e-06 0.000 1.95605e-06 1.800 1.95900e-06 1.800 1.95905e-06 0.000 1.96200e-06 0.000
+ 1.96205e-06 1.800 1.96800e-06 1.800 1.96805e-06 0.000 1.97700e-06 0.000 1.97705e-06 1.800 1.98300e-06 1.800
+ 1.98305e-06 0.000 1.99800e-06 0.000 1.99805e-06 1.800 2.00400e-06 1.800 2.00405e-06 0.000 2.00700e-06 0.000
+ 2.00705e-06 1.800 2.01000e-06 1.800 2.01005e-06 0.000 2.01300e-06 0.000 2.01305e-06 1.800 2.02500e-06 1.800
+ 2.02505e-06 0.000 2.03400e-06 0.000 2.03405e-06 1.800 2.04000e-06 1.800 2.04005e-06 0.000 2.04300e-06 0.000
+ 2.04305e-06 1.800 2.05200e-06 1.800 2.05205e-06 0.000 2.05800e-06 0.000 2.05805e-06 1.800 2.06400e-06 1.800
+ 2.06405e-06 0.000 2.06700e-06 0.000 2.06705e-06 1.800 2.07000e-06 1.800 2.07005e-06 0.000 2.07300e-06 0.000
+ 2.07305e-06 1.800 2.07600e-06 1.800 2.07605e-06 0.000 2.08200e-06 0.000 2.08205e-06 1.800 2.08800e-06 1.800
+ 2.08805e-06 0.000 2.09100e-06 0.000 2.09105e-06 1.800 2.09400e-06 1.800 2.09405e-06 0.000 2.09700e-06 0.000
+ 2.09705e-06 1.800 2.10000e-06 1.800 2.10005e-06 0.000 2.10300e-06 0.000 2.10305e-06 1.800 2.10900e-06 1.800
+ 2.10905e-06 0.000 2.11500e-06 0.000 2.11505e-06 1.800 2.12700e-06 1.800 2.12705e-06 0.000 2.13600e-06 0.000
+ 2.13605e-06 1.800 2.14200e-06 1.800 2.14205e-06 0.000 2.14500e-06 0.000 2.14505e-06 1.800 2.16300e-06 1.800
+ 2.16305e-06 0.000 2.16600e-06 0.000 2.16605e-06 1.800 2.16900e-06 1.800 2.16905e-06 0.000 2.17200e-06 0.000
+ 2.17205e-06 1.800 2.17500e-06 1.800 2.17505e-06 0.000 2.20200e-06 0.000 2.20205e-06 1.800 2.20800e-06 1.800
+ 2.20805e-06 0.000 2.21100e-06 0.000 2.21105e-06 1.800 2.21400e-06 1.800 2.21405e-06 0.000 2.21700e-06 0.000
+ 2.21705e-06 1.800 2.22300e-06 1.800 2.22305e-06 0.000 2.23200e-06 0.000 2.23205e-06 1.800 2.23500e-06 1.800
+ 2.23505e-06 0.000 2.23800e-06 0.000 2.23805e-06 1.800 2.24400e-06 1.800 2.24405e-06 0.000 2.24700e-06 0.000
+ 2.24705e-06 1.800 2.25300e-06 1.800 2.25305e-06 0.000 2.25600e-06 0.000 2.25605e-06 1.800 2.25900e-06 1.800
+ 2.25905e-06 0.000 2.27100e-06 0.000 2.27105e-06 1.800 2.27700e-06 1.800 2.27705e-06 0.000 2.28000e-06 0.000
+ 2.28005e-06 1.800 2.28600e-06 1.800 2.28605e-06 0.000 2.28900e-06 0.000 2.28905e-06 1.800 2.29800e-06 1.800
+ 2.29805e-06 0.000 2.30100e-06 0.000 2.30105e-06 1.800 2.30700e-06 1.800 2.30705e-06 0.000 2.31000e-06 0.000
+ 2.31005e-06 1.800 2.31600e-06 1.800 2.31605e-06 0.000 2.32200e-06 0.000 2.32205e-06 1.800 2.34900e-06 1.800
+ 2.34905e-06 0.000 2.35200e-06 0.000 2.35205e-06 1.800 2.35800e-06 1.800 2.35805e-06 0.000 2.36100e-06 0.000
+ 2.36105e-06 1.800 2.36700e-06 1.800 2.36705e-06 0.000 2.37000e-06 0.000 2.37005e-06 1.800 2.37300e-06 1.800
+ 2.37305e-06 0.000 2.37600e-06 0.000 2.37605e-06 1.800 2.38500e-06 1.800 2.38505e-06 0.000 2.39400e-06 0.000
+ 2.39405e-06 1.800 2.39700e-06 1.800 2.39705e-06 0.000 2.40000e-06 0.000 2.40005e-06 1.800 2.40300e-06 1.800
+ 2.40305e-06 0.000 2.41200e-06 0.000 2.41205e-06 1.800 2.41800e-06 1.800 2.41805e-06 0.000 2.43000e-06 0.000
+ 2.43005e-06 1.800 2.45100e-06 1.800 2.45105e-06 0.000 2.45400e-06 0.000 2.45405e-06 1.800 2.46000e-06 1.800
+ 2.46005e-06 0.000 2.47200e-06 0.000 2.47205e-06 1.800 2.47500e-06 1.800 2.47505e-06 0.000 2.47800e-06 0.000
+ 2.47805e-06 1.800 2.48700e-06 1.800 2.48705e-06 0.000 2.49900e-06 0.000 2.49905e-06 1.800 2.51100e-06 1.800
+ 2.51105e-06 0.000 2.51400e-06 0.000 2.51405e-06 1.800 2.52300e-06 1.800 2.52305e-06 0.000 2.52900e-06 0.000
+ 2.52905e-06 1.800 2.53200e-06 1.800 2.53205e-06 0.000 2.53800e-06 0.000 2.53805e-06 1.800 2.54100e-06 1.800
+ 2.54105e-06 0.000 2.54400e-06 0.000 2.54405e-06 1.800 2.54700e-06 1.800 2.54705e-06 0.000 2.55600e-06 0.000
+ 2.55605e-06 1.800 2.55900e-06 1.800 2.55905e-06 0.000 2.56200e-06 0.000 2.56205e-06 1.800 2.56500e-06 1.800
+ 2.56505e-06 0.000 2.57100e-06 0.000 2.57105e-06 1.800 2.57700e-06 1.800 2.57705e-06 0.000 2.58000e-06 0.000
+ 2.58005e-06 1.800 2.60400e-06 1.800 2.60405e-06 0.000 2.61300e-06 0.000 2.61305e-06 1.800 2.63100e-06 1.800
+ 2.63105e-06 0.000 2.64000e-06 0.000 2.64005e-06 1.800 2.64300e-06 1.800 2.64305e-06 0.000 2.64600e-06 0.000
+ 2.64605e-06 1.800 2.64900e-06 1.800 2.64905e-06 0.000 2.66100e-06 0.000 2.66105e-06 1.800 2.67300e-06 1.800
+ 2.67305e-06 0.000 2.67600e-06 0.000 2.67605e-06 1.800 2.67900e-06 1.800 2.67905e-06 0.000 2.68800e-06 0.000
+ 2.68805e-06 1.800 2.69100e-06 1.800 2.69105e-06 0.000 2.69400e-06 0.000 2.69405e-06 1.800 2.70000e-06 1.800
+ 2.70005e-06 0.000 2.70300e-06 0.000 2.70305e-06 1.800 2.71200e-06 1.800 2.71205e-06 0.000 2.71500e-06 0.000
+ 2.71505e-06 1.800 2.71800e-06 1.800 2.71805e-06 0.000 2.72400e-06 0.000 2.72405e-06 1.800 2.72700e-06 1.800
+ 2.72705e-06 0.000 2.73000e-06 0.000 2.73005e-06 1.800 2.73300e-06 1.800 2.73305e-06 0.000 2.73600e-06 0.000
+ 2.73605e-06 1.800 2.73900e-06 1.800 2.73905e-06 0.000 2.74200e-06 0.000 2.74205e-06 1.800 2.74800e-06 1.800
+ 2.74805e-06 0.000 2.76300e-06 0.000 2.76305e-06 1.800 2.76600e-06 1.800 2.76605e-06 0.000 2.76900e-06 0.000
+ 2.76905e-06 1.800 2.79000e-06 1.800 2.79005e-06 0.000 2.80200e-06 0.000 2.80205e-06 1.800 2.80500e-06 1.800
+ 2.80505e-06 0.000 2.80800e-06 0.000 2.80805e-06 1.800 2.81100e-06 1.800 2.81105e-06 0.000 2.82300e-06 0.000
+ 2.82305e-06 1.800 2.82600e-06 1.800 2.82605e-06 0.000 2.82900e-06 0.000 2.82905e-06 1.800 2.83800e-06 1.800
+ 2.83805e-06 0.000 2.84100e-06 0.000 2.84105e-06 1.800 2.84700e-06 1.800 2.84705e-06 0.000 2.85300e-06 0.000
+ 2.85305e-06 1.800 2.85900e-06 1.800 2.85905e-06 0.000 2.86500e-06 0.000 2.86505e-06 1.800 2.87400e-06 1.800
+ 2.87405e-06 0.000 2.88000e-06 0.000 2.88005e-06 1.800 2.88300e-06 1.800 2.88305e-06 0.000 2.88600e-06 0.000
+ 2.88605e-06 1.800 2.90100e-06 1.800 2.90105e-06 0.000 2.91000e-06 0.000 2.91005e-06 1.800 2.91300e-06 1.800
+ 2.91305e-06 0.000 2.91900e-06 0.000 2.91905e-06 1.800 2.92200e-06 1.800 2.92205e-06 0.000 2.92800e-06 0.000
+ 2.92805e-06 1.800 2.93400e-06 1.800 2.93405e-06 0.000 2.94300e-06 0.000 2.94305e-06 1.800 2.94600e-06 1.800
+ 2.94605e-06 0.000 2.94900e-06 0.000 2.94905e-06 1.800 2.95200e-06 1.800 2.95205e-06 0.000 2.96100e-06 0.000
+ 2.96105e-06 1.800 2.96400e-06 1.800 2.96405e-06 0.000 2.96700e-06 0.000 2.96705e-06 1.800 2.97300e-06 1.800
+ 2.97305e-06 0.000 2.97600e-06 0.000 2.97605e-06 1.800 2.97900e-06 1.800 2.97905e-06 0.000 2.98200e-06 0.000
+ 2.98205e-06 1.800 2.99100e-06 1.800 2.99105e-06 0.000 2.99400e-06 0.000 2.99405e-06 1.800 3.00000e-06 1.800
+ 3.00005e-06 0.000 3.01500e-06 0.000 3.01505e-06 1.800 3.01800e-06 1.800 3.01805e-06 0.000 3.02100e-06 0.000
+ 3.02105e-06 1.800 3.02400e-06 1.800 3.02405e-06 0.000 3.03000e-06 0.000 3.03005e-06 1.800 3.03300e-06 1.800
+ 3.03305e-06 0.000 3.03900e-06 0.000 3.03905e-06 1.800 3.04200e-06 1.800 3.04205e-06 0.000 3.04800e-06 0.000
+ 3.04805e-06 1.800 3.05700e-06 1.800 3.05705e-06 0.000 3.06000e-06 0.000 3.06005e-06 1.800 3.06300e-06 1.800
+ 3.06305e-06 0.000 3.07200e-06 0.000
+ )
Xd_c0 src_c0 c0 vdd gnd tb_inv
Xl_s0 s0 lo_s0 vdd gnd tb_inv
Xl_s1 s1 lo_s1 vdd gnd tb_inv
Xl_s2 s2 lo_s2 vdd gnd tb_inv
Xl_s3 s3 lo_s3 vdd gnd tb_inv
Xl_c4 c4 lo_c4 vdd gnd tb_inv
X0 a0 a1 a2 a3 b0 b1 b2 b3 c0 s0 s1 s2 s3 c4 vdd gnd final_post_post
.tran 200p 3.07200e-06
.control
set wr_singlescale
set wr_vecnames
run
set curplottitle=Bhargav-2025102061-1.6-final-adder-postlayout
wrdata wave.txt v(a0) v(a1) v(a2) v(a3) v(b0) v(b1) v(b2) v(b3) v(c0) v(s0) v(s1) v(s2) v(s3) v(c4) i(VDD)
quit
.endc
.end
