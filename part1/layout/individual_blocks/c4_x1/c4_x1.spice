* NGSPICE file created from c4_x1.ext - technology: scmos

.global Vdd Gnd

.subckt c4_x1 c0b c4 g0b g1b g2b g3b t0b t1b t2b t3b vdd gnd
M1000 a_62_10# g0b a_79_20# Gnd nfet w=4.5u l=0.18u
+  ad=1.4175p pd=5.13u as=2.43p ps=10.08u
M1001 c4 c0b a_124_173# vdd pfet w=4.5u l=0.18u
+  ad=3.24p pd=5.94u as=3.24p ps=5.94u
M1002 a_79_20# t1b gnd Gnd nfet w=3.6u l=0.18u
+  ad=2.997p pd=5.94u as=1.3365p ps=5.13u
M1003 vdd g3b c4 vdd pfet w=1.8u l=0.18u
+  ad=1.296p pd=5.13u as=0.972p ps=4.68u
M1004 a_25_173# t2b a_70_173# vdd pfet w=4.5u l=0.18u
+  ad=2.025p pd=9.9u as=1.4175p ps=5.13u
M1005 a_124_173# c0b c4 vdd pfet w=4.5u l=0.18u
+  ad=3.24p pd=5.94u as=3.24p ps=5.94u
M1006 gnd t0b a_62_10# Gnd nfet w=4.5u l=0.18u
+  ad=2.025p pd=9.9u as=1.4175p ps=5.13u
M1007 gnd c0b a_62_10# Gnd nfet w=4.5u l=0.18u
+  ad=1.3365p pd=5.13u as=2.43p ps=10.08u
M1008 vdd t3b a_25_173# vdd pfet w=4.5u l=0.18u
+  ad=2.025p pd=9.9u as=1.4175p ps=5.13u
M1009 c4 g1b a_70_173# vdd pfet w=5.4u l=0.18u
+  ad=4.698p pd=8.64u as=2.916p ps=11.88u
M1010 a_34_30# t2b gnd Gnd nfet w=2.7u l=0.18u
+  ad=2.754p pd=5.94u as=0.81p ps=3.33u
M1011 a_115_173# g0b c4 vdd pfet w=7.2u l=0.18u
+  ad=2.025p pd=7.83u as=4.698p ps=8.64u
M1012 a_115_173# t0b a_124_173# vdd pfet w=4.5u l=0.18u
+  ad=3.24p pd=5.94u as=3.24p ps=5.94u
M1013 a_16_10# g2b a_34_30# Gnd nfet w=4.5u l=0.18u
+  ad=2.025p pd=9.9u as=2.754p ps=5.94u
M1014 a_25_173# g2b c4 vdd pfet w=3.6u l=0.18u
+  ad=2.997p pd=5.94u as=1.944p ps=8.28u
M1015 a_70_173# t1b a_115_173# vdd pfet w=4.5u l=0.18u
+  ad=3.24p pd=5.94u as=3.24p ps=5.94u
M1016 a_16_10# g3b c4 Gnd nfet w=4.5u l=0.18u
+  ad=1.1745p pd=5.13u as=2.43p ps=10.08u
M1017 a_70_173# t2b a_25_173# vdd pfet w=4.5u l=0.18u
+  ad=1.4175p pd=5.13u as=2.997p ps=5.94u
M1018 a_25_173# t3b vdd vdd pfet w=4.5u l=0.18u
+  ad=1.4175p pd=5.13u as=1.296p ps=5.13u
M1019 gnd t3b a_16_10# Gnd nfet w=1.8u l=0.18u
+  ad=0.81p pd=3.33u as=1.1745p ps=5.13u
M1020 a_115_173# t1b a_70_173# vdd pfet w=4.5u l=0.18u
+  ad=2.025p pd=9.9u as=3.24p ps=5.94u
M1021 a_34_30# g1b a_79_20# Gnd nfet w=4.5u l=0.18u
+  ad=2.025p pd=9.9u as=2.997p ps=5.94u
M1022 a_124_173# t0b a_115_173# vdd pfet w=4.5u l=0.18u
+  ad=3.24p pd=5.94u as=2.025p ps=7.83u
C0 a_115_173# a_124_173# 0.02112f
C1 c0b gnd 0.00582f
C2 c4 gnd 0.04128f
C3 g2b t1b 0.00914f
C4 t0b c0b 0.02756f
C5 t3b gnd 0.00234f
C6 c4 t0b 0.34002f
C7 g3b c0b 0.99075f
C8 t2b t1b 0.07421f
C9 g0b t1b 0.00894f
C10 g1b c0b 0.02741f
C11 t2b g2b 0.00978f
C12 g3b c4 0.0194f
C13 vdd t0b 0.03791f
C14 a_34_30# gnd 0.08331f
C15 g0b g2b 1.21595f
C16 t3b g3b 0.38048f
C17 g1b c4 0.01578f
C18 a_79_20# c0b 0.01921f
C19 a_62_10# t1b 0.47425f
C20 vdd g3b 0.02123f
C21 a_124_173# t1b 0.44229f
C22 a_62_10# g2b 0.62747f
C23 a_79_20# c4 0.28196f
C24 a_34_30# g3b 0.15648f
C25 a_124_173# g2b 0.42346f
C26 a_16_10# c4 0.53083f
C27 a_70_173# c0b 0.01892f
C28 a_115_173# t0b 0.02967f
C29 vdd g1b 0.01902f
C30 a_62_10# g0b 0.02395f
C31 a_34_30# g1b 0.01449f
C32 a_16_10# t3b 0.01289f
C33 a_70_173# c4 0.15861f
C34 a_25_173# g2b 0.01416f
C35 a_34_30# a_79_20# 0.56468f
C36 a_25_173# t2b 0.02876f
C37 a_70_173# vdd 0.04268f
C38 a_16_10# a_34_30# 0.19717f
C39 a_70_173# a_115_173# 1.09683f
C40 t1b gnd 0.00396f
C41 g2b gnd 0.00105f
C42 t0b t1b 0.00926f
C43 t2b gnd 0.00315f
C44 g2b t0b 0.00926f
C45 c4 c0b 0.02039f
C46 g3b t1b 0.00926f
C47 g3b g2b 0.00946f
C48 g0b gnd 0.00105f
C49 g1b t1b 1.2873f
C50 g0b t0b 0.39007f
C51 vdd c0b 0.03804f
C52 a_62_10# gnd 0.90905f
C53 g1b g2b 0.00914f
C54 t2b g3b 0.00926f
C55 t3b c4 0.16345f
C56 a_79_20# t1b 0.03772f
C57 vdd c4 0.59172f
C58 g0b g3b 0.00926f
C59 a_62_10# t0b 0.00739f
C60 a_34_30# c0b 0.38168f
C61 a_79_20# g2b 0.0196f
C62 a_70_173# t1b 0.02068f
C63 a_115_173# c0b 0.0186f
C64 g0b g1b 0.00926f
C65 vdd t3b 0.04706f
C66 a_124_173# t0b 0.04412f
C67 a_62_10# g3b 0.15648f
C68 a_16_10# g2b 0.01447f
C69 a_79_20# t2b 0.0016f
C70 a_79_20# g0b 0.00852f
C71 a_62_10# g1b 0.00914f
C72 a_16_10# t2b 0.00926f
C73 a_115_173# c4 0.3939f
C74 a_62_10# a_79_20# 0.62013f
C75 a_70_173# t2b 0.02211f
C76 a_124_173# g1b 0.0196f
C77 a_115_173# vdd 0.08556f
C78 a_70_173# g0b 0.00958f
C79 a_16_10# a_62_10# 0.52998f
C80 a_70_173# a_124_173# 0.15687f
C81 a_25_173# a_70_173# 1.23686f
C82 t0b gnd 0.00582f
C83 c0b t1b 0.10418f
C84 g3b gnd 0.00105f
C85 g2b c0b 0.01827f
C86 c4 g2b 0.01442f
C87 g1b gnd 0.00105f
C88 g3b t0b 0.00926f
C89 g0b c0b 0.54365f
C90 g1b t0b 0.61864f
C91 vdd t1b 0.03804f
C92 a_79_20# gnd 0.08356f
C93 t2b c4 0.01852f
C94 a_34_30# t1b 0.00914f
C95 a_62_10# c0b 0.02941f
C96 vdd g2b 0.01902f
C97 a_16_10# gnd 0.49524f
C98 g0b c4 0.01724f
C99 g1b g3b 0.00946f
C100 t3b t2b 0.29755f
C101 vdd t2b 0.03765f
C102 a_124_173# c0b 0.02862f
C103 a_34_30# g2b 0.57179f
C104 a_79_20# g3b 0.1561f
C105 a_115_173# t1b 0.02981f
C106 a_79_20# g1b 0.2109f
C107 a_34_30# t2b 0.0047f
C108 a_124_173# c4 0.0098f
C109 a_70_173# t0b 0.01872f
C110 a_16_10# g3b 0.58615f
C111 vdd g0b 0.01994f
C112 a_25_173# c4 0.6205f
C113 a_124_173# vdd 0.02828f
C114 a_34_30# a_62_10# 0.01018f
C115 a_115_173# g0b 0.00977f
C116 a_70_173# g1b 0.01631f
C117 a_25_173# t3b 0.02218f
C118 a_25_173# vdd 0.86589f
.ends
