* Registered system at T=1500.0 ps
.include ../../../spice/models/TSMC_180nm.txt
.options reltol=1e-4
VDD vdd_core gnd 1.8
Vsense vdd_core vdd 0
* dff_tspc_x0p8_1p4_1p4_2: TSPC positive-edge flip-flop
* GENERATED from part1/cells/library.py. Do not edit by hand.
.subckt dff_tspc_x0p8_1p4_1p4_2 d clk q vdd gnd
Ms0p1 s0xp1 d vdd vdd CMOSP W=2.8800e-06 L=1.8000e-07 AS=1.5552e-12 PS=6.8400e-06 AD=7.7760e-13 PD=6.3000e-06
Ms0p2 a clk s0xp1 vdd CMOSP W=2.8800e-06 L=1.8000e-07 AS=7.7760e-13 PS=6.3000e-06 AD=1.5552e-12 PD=6.8400e-06
Ms0n1 a d gnd gnd CMOSN W=7.2000e-07 L=1.8000e-07 AS=3.8880e-13 PS=2.5200e-06 AD=3.8880e-13 PD=2.5200e-06
Ms1p1 b clk vdd vdd CMOSP W=2.5200e-06 L=1.8000e-07 AS=1.3608e-12 PS=6.1200e-06 AD=1.3608e-12 PD=6.1200e-06
Ms1n1 b a s1xn1 gnd CMOSN W=2.5200e-06 L=1.8000e-07 AS=6.8040e-13 PS=5.5800e-06 AD=1.3608e-12 PD=6.1200e-06
Ms1n2 s1xn1 clk gnd gnd CMOSN W=2.5200e-06 L=1.8000e-07 AS=1.3608e-12 PS=6.1200e-06 AD=6.8040e-13 PD=5.5800e-06
Ms2p1 qb b vdd vdd CMOSP W=2.5200e-06 L=1.8000e-07 AS=1.3608e-12 PS=6.1200e-06 AD=1.3608e-12 PD=6.1200e-06
Ms2n1 qb clk s2xn1 gnd CMOSN W=2.5200e-06 L=1.8000e-07 AS=6.8040e-13 PS=5.5800e-06 AD=1.3608e-12 PD=6.1200e-06
Ms2n2 s2xn1 b gnd gnd CMOSN W=2.5200e-06 L=1.8000e-07 AS=1.3608e-12 PS=6.1200e-06 AD=6.8040e-13 PD=5.5800e-06
Ms3p1 q qb vdd vdd CMOSP W=3.6000e-06 L=1.8000e-07 AS=1.9440e-12 PS=8.2800e-06 AD=1.9440e-12 PD=8.2800e-06
Ms3n1 q qb gnd gnd CMOSN W=1.8000e-06 L=1.8000e-07 AS=9.7200e-13 PS=4.6800e-06 AD=9.7200e-13 PD=4.6800e-06
.ends dff_tspc_x0p8_1p4_1p4_2
* nand2_x1: 2-input NAND
* GENERATED from part1/cells/library.py. Do not edit by hand.
.subckt nand2_x1 i0 i1 y vdd gnd
Mp1 y i0 vdd vdd CMOSP W=1.8000e-06 L=1.8000e-07 AS=9.7200e-13 PS=4.6800e-06 AD=9.7200e-13 PD=4.6800e-06
Mp2 y i1 vdd vdd CMOSP W=1.8000e-06 L=1.8000e-07 AS=9.7200e-13 PS=4.6800e-06 AD=9.7200e-13 PD=4.6800e-06
Mn1 y i0 xn1 gnd CMOSN W=1.8000e-06 L=1.8000e-07 AS=4.8600e-13 PS=4.1400e-06 AD=9.7200e-13 PD=4.6800e-06
Mn2 xn1 i1 gnd gnd CMOSN W=1.8000e-06 L=1.8000e-07 AS=9.7200e-13 PS=4.6800e-06 AD=4.8600e-13 PD=4.1400e-06
.ends nand2_x1
* nor2_x1: 2-input NOR
* GENERATED from part1/cells/library.py. Do not edit by hand.
.subckt nor2_x1 i0 i1 y vdd gnd
Mp1 xp1 i0 vdd vdd CMOSP W=3.6000e-06 L=1.8000e-07 AS=1.9440e-12 PS=8.2800e-06 AD=9.7200e-13 PD=7.7400e-06
Mp2 y i1 xp1 vdd CMOSP W=3.6000e-06 L=1.8000e-07 AS=9.7200e-13 PS=7.7400e-06 AD=1.9440e-12 PD=8.2800e-06
Mn1 y i0 gnd gnd CMOSN W=9.0000e-07 L=1.8000e-07 AS=4.8600e-13 PS=2.8800e-06 AD=4.8600e-13 PD=2.8800e-06
Mn2 y i1 gnd gnd CMOSN W=9.0000e-07 L=1.8000e-07 AS=4.8600e-13 PS=2.8800e-06 AD=4.8600e-13 PD=2.8800e-06
.ends nor2_x1
* aoi21_x1: NOT(a b + c)
* GENERATED from part1/cells/library.py. Do not edit by hand.
.subckt aoi21_x1 a b c y vdd gnd
Mp1 xp1 a vdd vdd CMOSP W=3.6000e-06 L=1.8000e-07 AS=1.9440e-12 PS=8.2800e-06 AD=1.9440e-12 PD=8.2800e-06
Mp2 xp1 b vdd vdd CMOSP W=3.6000e-06 L=1.8000e-07 AS=1.9440e-12 PS=8.2800e-06 AD=1.9440e-12 PD=8.2800e-06
Mp3 y c xp1 vdd CMOSP W=3.6000e-06 L=1.8000e-07 AS=1.9440e-12 PS=8.2800e-06 AD=1.9440e-12 PD=8.2800e-06
Mn1 y a xn1 gnd CMOSN W=1.8000e-06 L=1.8000e-07 AS=4.8600e-13 PS=4.1400e-06 AD=9.7200e-13 PD=4.6800e-06
Mn2 xn1 b gnd gnd CMOSN W=1.8000e-06 L=1.8000e-07 AS=9.7200e-13 PS=4.6800e-06 AD=4.8600e-13 PD=4.1400e-06
Mn3 y c gnd gnd CMOSN W=9.0000e-07 L=1.8000e-07 AS=4.8600e-13 PS=2.8800e-06 AD=4.8600e-13 PD=2.8800e-06
.ends aoi21_x1
* oai21_x1: NOT((a + b) c)
* GENERATED from part1/cells/library.py. Do not edit by hand.
.subckt oai21_x1 a b c y vdd gnd
Mp1 xp1 a vdd vdd CMOSP W=3.6000e-06 L=1.8000e-07 AS=1.9440e-12 PS=8.2800e-06 AD=9.7200e-13 PD=7.7400e-06
Mp2 y b xp1 vdd CMOSP W=3.6000e-06 L=1.8000e-07 AS=9.7200e-13 PS=7.7400e-06 AD=1.9440e-12 PD=8.2800e-06
Mp3 y c vdd vdd CMOSP W=1.8000e-06 L=1.8000e-07 AS=9.7200e-13 PS=4.6800e-06 AD=9.7200e-13 PD=4.6800e-06
Mn1 y a xn1 gnd CMOSN W=1.8000e-06 L=1.8000e-07 AS=9.7200e-13 PS=4.6800e-06 AD=9.7200e-13 PD=4.6800e-06
Mn2 y b xn1 gnd CMOSN W=1.8000e-06 L=1.8000e-07 AS=9.7200e-13 PS=4.6800e-06 AD=9.7200e-13 PD=4.6800e-06
Mn3 xn1 c gnd gnd CMOSN W=1.8000e-06 L=1.8000e-07 AS=9.7200e-13 PS=4.6800e-06 AD=9.7200e-13 PD=4.6800e-06
.ends oai21_x1
* inv_x1: inverter
* GENERATED from part1/cells/library.py. Do not edit by hand.
.subckt inv_x1 a y vdd gnd
Mp1 y a vdd vdd CMOSP W=1.8000e-06 L=1.8000e-07 AS=9.7200e-13 PS=4.6800e-06 AD=9.7200e-13 PD=4.6800e-06
Mn1 y a gnd gnd CMOSN W=9.0000e-07 L=1.8000e-07 AS=4.8600e-13 PS=2.8800e-06 AD=4.8600e-13 PD=2.8800e-06
.ends inv_x1
* xor_tg_x1: transmission-gate mux XOR with output inverter
* GENERATED from part1/cells/library.py. Do not edit by hand.
.subckt xor_tg_x1 p pb c s vdd gnd
Ms0p1 cb c vdd vdd CMOSP W=1.8000e-06 L=1.8000e-07 AS=9.7200e-13 PS=4.6800e-06 AD=9.7200e-13 PD=4.6800e-06
Ms0n1 cb c gnd gnd CMOSN W=9.0000e-07 L=1.8000e-07 AS=4.8600e-13 PS=2.8800e-06 AD=4.8600e-13 PD=2.8800e-06
Ms1n p c m gnd CMOSN W=9.0000e-07 L=1.8000e-07 AS=4.8600e-13 PS=2.8800e-06 AD=4.8600e-13 PD=2.8800e-06
Ms1p p cb m vdd CMOSP W=1.8000e-06 L=1.8000e-07 AS=9.7200e-13 PS=4.6800e-06 AD=9.7200e-13 PD=4.6800e-06
Ms2n pb cb m gnd CMOSN W=9.0000e-07 L=1.8000e-07 AS=4.8600e-13 PS=2.8800e-06 AD=4.8600e-13 PD=2.8800e-06
Ms2p pb c m vdd CMOSP W=1.8000e-06 L=1.8000e-07 AS=9.7200e-13 PS=4.6800e-06 AD=9.7200e-13 PD=4.6800e-06
Ms3p1 s m vdd vdd CMOSP W=1.8000e-06 L=1.8000e-07 AS=9.7200e-13 PS=4.6800e-06 AD=9.7200e-13 PD=4.6800e-06
Ms3n1 s m gnd gnd CMOSN W=9.0000e-07 L=1.8000e-07 AS=4.8600e-13 PS=2.8800e-06 AD=4.8600e-13 PD=2.8800e-06
.ends xor_tg_x1
* reg_trial: registered 4-bit adder, Figure 1(i)
* GENERATED from part1/cells/library.py. Do not edit by hand.
.subckt reg_trial d_a0 d_a1 d_a2 d_a3 d_b0 d_b1 d_b2 d_b3 d_c0 clk q_s0 q_s1 q_s2 q_s3 q_c4 vdd gnd
Xfi_a0 d_a0 clk a0 vdd gnd dff_tspc_x0p8_1p4_1p4_2
Xfi_a1 d_a1 clk a1 vdd gnd dff_tspc_x0p8_1p4_1p4_2
Xfi_a2 d_a2 clk a2 vdd gnd dff_tspc_x0p8_1p4_1p4_2
Xfi_a3 d_a3 clk a3 vdd gnd dff_tspc_x0p8_1p4_1p4_2
Xfi_b0 d_b0 clk b0 vdd gnd dff_tspc_x0p8_1p4_1p4_2
Xfi_b1 d_b1 clk b1 vdd gnd dff_tspc_x0p8_1p4_1p4_2
Xfi_b2 d_b2 clk b2 vdd gnd dff_tspc_x0p8_1p4_1p4_2
Xfi_b3 d_b3 clk b3 vdd gnd dff_tspc_x0p8_1p4_1p4_2
Xfi_c0 d_c0 clk c0 vdd gnd dff_tspc_x0p8_1p4_1p4_2
Xnand0 a0 b0 g0b vdd gnd nand2_x1
Xnor0 a0 b0 t0b vdd gnd nor2_x1
Xaoi0 a0 b0 t0b p0 vdd gnd aoi21_x1
Xoai0 a0 b0 g0b p0b vdd gnd oai21_x1
Xnand1 a1 b1 g1b vdd gnd nand2_x1
Xnor1 a1 b1 t1b vdd gnd nor2_x1
Xaoi1 a1 b1 t1b p1 vdd gnd aoi21_x1
Xoai1 a1 b1 g1b p1b vdd gnd oai21_x1
Xnand2 a2 b2 g2b vdd gnd nand2_x1
Xnor2 a2 b2 t2b vdd gnd nor2_x1
Xaoi2 a2 b2 t2b p2 vdd gnd aoi21_x1
Xoai2 a2 b2 g2b p2b vdd gnd oai21_x1
Xnand3 a3 b3 g3b vdd gnd nand2_x1
Xnor3 a3 b3 t3b vdd gnd nor2_x1
Xaoi3 a3 b3 t3b p3 vdd gnd aoi21_x1
Xoai3 a3 b3 g3b p3b vdd gnd oai21_x1
Xinvc0 c0 c0b vdd gnd inv_x1
Xg10 t1b g0b g1b g1_0 vdd gnd oai21_x1
Xt10 t1b t0b t1_0 vdd gnd nor2_x1
Xg32 t3b g2b g3b g3_2 vdd gnd oai21_x1
Xt32 t3b t2b t3_2 vdd gnd nor2_x1
Xig2 g2b g2 vdd gnd inv_x1
Xit2 t2b t2 vdd gnd inv_x1
Xg30 t3_2 g1_0 g3_2 g3_0b vdd gnd aoi21_x1
Xt30 t3_2 t1_0 t3_0b vdd gnd nand2_x1
Xg20 t2 g1_0 g2 g2_0b vdd gnd aoi21_x1
Xt20 t2 t1_0 t2_0b vdd gnd nand2_x1
Xig10 g1_0 g1_0b vdd gnd inv_x1
Xit10 t1_0 t1_0b vdd gnd inv_x1
Xc1 t0b c0b g0b c1 vdd gnd oai21_x1
Xc2 t1_0b c0b g1_0b c2 vdd gnd oai21_x1
Xc3 t2_0b c0b g2_0b c3 vdd gnd oai21_x1
Xc4g t3_0b c0b g3_0b c4 vdd gnd oai21_x1
Xx0 p0 p0b c0 s0 vdd gnd xor_tg_x1
Xx1 p1 p1b c1 s1 vdd gnd xor_tg_x1
Xx2 p2 p2b c2 s2 vdd gnd xor_tg_x1
Xx3 p3 p3b c3 s3 vdd gnd xor_tg_x1
Xfo_s0 s0 clk q_s0 vdd gnd dff_tspc_x0p8_1p4_1p4_2
Xfo_s1 s1 clk q_s1 vdd gnd dff_tspc_x0p8_1p4_1p4_2
Xfo_s2 s2 clk q_s2 vdd gnd dff_tspc_x0p8_1p4_1p4_2
Xfo_s3 s3 clk q_s3 vdd gnd dff_tspc_x0p8_1p4_1p4_2
Xfo_c4 c4 clk q_c4 vdd gnd dff_tspc_x0p8_1p4_1p4_2
.ends reg_trial
.subckt tb_x1 a y vdd gnd
mp y a vdd vdd CMOSP W=1.8e-06 L=1.8e-07 AS=9.72e-13 PS=4.68e-06 AD=9.72e-13 PD=4.68e-06
mn y a gnd gnd CMOSN W=9.0e-07 L=1.8e-07 AS=4.86e-13 PS=2.88e-06 AD=4.86e-13 PD=2.88e-06
.ends
.subckt tb_x8 a y vdd gnd
mp y a vdd vdd CMOSP W=14.4e-06 L=1.8e-07 AS=7.776e-12 PS=3.0e-05 AD=7.776e-12 PD=3.0e-05
mn y a gnd gnd CMOSN W=7.2e-06 L=1.8e-07 AS=3.888e-12 PS=1.548e-05 AD=3.888e-12 PD=1.548e-05
.ends
Vd_a0 sd_a0 gnd PWL(
+ 0.00000e+00 0.00 1.01250e-08 0.00 1.01400e-08 1.80 1.31250e-08 1.80 1.31400e-08 0.00 1.46250e-08 0.00
+ 1.46400e-08 1.80 1.91250e-08 1.80 1.91400e-08 0.00 2.21250e-08 0.00 2.21400e-08 1.80 2.81250e-08 1.80
+ 2.81400e-08 0.00 2.96250e-08 0.00 2.96400e-08 1.80 3.86250e-08 1.80 3.86400e-08 0.00 4.01250e-08 0.00
+ 4.01400e-08 1.80 4.46250e-08 1.80 4.46400e-08 0.00 4.61250e-08 0.00 4.61400e-08 1.80 4.91250e-08 1.80
+ 4.91400e-08 0.00 5.21250e-08 0.00 5.21400e-08 1.80 5.36250e-08 1.80 5.36400e-08 0.00 5.81250e-08 0.00
+ 5.81400e-08 1.80 5.96250e-08 1.80 5.96400e-08 0.00 6.26250e-08 0.00 6.26400e-08 1.80 6.41250e-08 1.80
+ 6.41400e-08 0.00 6.56250e-08 0.00 6.56400e-08 1.80 7.35000e-08 1.80
+ )
Xdrv_a0 sd_a0 d_a0 vdd gnd tb_x1
Vd_a1 sd_a1 gnd PWL(
+ 0.00000e+00 0.00 1.16250e-08 0.00 1.16400e-08 1.80 1.46250e-08 1.80 1.46400e-08 0.00 1.61250e-08 0.00
+ 1.61400e-08 1.80 1.76250e-08 1.80 1.76400e-08 0.00 2.36250e-08 0.00 2.36400e-08 1.80 2.81250e-08 1.80
+ 2.81400e-08 0.00 3.11250e-08 0.00 3.11400e-08 1.80 3.26250e-08 1.80 3.26400e-08 0.00 3.41250e-08 0.00
+ 3.41400e-08 1.80 3.56250e-08 1.80 3.56400e-08 0.00 3.71250e-08 0.00 3.71400e-08 1.80 3.86250e-08 1.80
+ 3.86400e-08 0.00 4.61250e-08 0.00 4.61400e-08 1.80 5.06250e-08 1.80 5.06400e-08 0.00 5.21250e-08 0.00
+ 5.21400e-08 1.80 5.36250e-08 1.80 5.36400e-08 0.00 5.51250e-08 0.00 5.51400e-08 1.80 6.11250e-08 1.80
+ 6.11400e-08 0.00 6.26250e-08 0.00 6.26400e-08 1.80 6.56250e-08 1.80 6.56400e-08 0.00 6.71250e-08 0.00
+ 6.71400e-08 1.80 7.35000e-08 1.80
+ )
Xdrv_a1 sd_a1 d_a1 vdd gnd tb_x1
Vd_a2 sd_a2 gnd PWL(
+ 0.00000e+00 0.00 8.62500e-09 0.00 8.64000e-09 1.80 1.16250e-08 1.80 1.16400e-08 0.00 1.31250e-08 0.00
+ 1.31400e-08 1.80 1.76250e-08 1.80 1.76400e-08 0.00 1.91250e-08 0.00 1.91400e-08 1.80 2.21250e-08 1.80
+ 2.21400e-08 0.00 2.36250e-08 0.00 2.36400e-08 1.80 2.51250e-08 1.80 2.51400e-08 0.00 3.26250e-08 0.00
+ 3.26400e-08 1.80 3.41250e-08 1.80 3.41400e-08 0.00 4.16250e-08 0.00 4.16400e-08 1.80 4.46250e-08 1.80
+ 4.46400e-08 0.00 4.61250e-08 0.00 4.61400e-08 1.80 4.91250e-08 1.80 4.91400e-08 0.00 5.06250e-08 0.00
+ 5.06400e-08 1.80 5.96250e-08 1.80 5.96400e-08 0.00 6.11250e-08 0.00 6.11400e-08 1.80 6.41250e-08 1.80
+ 6.41400e-08 0.00 6.56250e-08 0.00 6.56400e-08 1.80 6.71250e-08 1.80 6.71400e-08 0.00 7.35000e-08 0.00
+ )
Xdrv_a2 sd_a2 d_a2 vdd gnd tb_x1
Vd_a3 sd_a3 gnd PWL(
+ 0.00000e+00 0.00 1.16250e-08 0.00 1.16400e-08 1.80 1.46250e-08 1.80 1.46400e-08 0.00 1.61250e-08 0.00
+ 1.61400e-08 1.80 1.91250e-08 1.80 1.91400e-08 0.00 2.21250e-08 0.00 2.21400e-08 1.80 2.36250e-08 1.80
+ 2.36400e-08 0.00 2.81250e-08 0.00 2.81400e-08 1.80 3.11250e-08 1.80 3.11400e-08 0.00 3.26250e-08 0.00
+ 3.26400e-08 1.80 3.41250e-08 1.80 3.41400e-08 0.00 3.71250e-08 0.00 3.71400e-08 1.80 3.86250e-08 1.80
+ 3.86400e-08 0.00 4.01250e-08 0.00 4.01400e-08 1.80 4.46250e-08 1.80 4.46400e-08 0.00 5.06250e-08 0.00
+ 5.06400e-08 1.80 5.21250e-08 1.80 5.21400e-08 0.00 5.81250e-08 0.00 5.81400e-08 1.80 5.96250e-08 1.80
+ 5.96400e-08 0.00 6.11250e-08 0.00 6.11400e-08 1.80 6.41250e-08 1.80 6.41400e-08 0.00 6.56250e-08 0.00
+ 6.56400e-08 1.80 6.71250e-08 1.80 6.71400e-08 0.00 7.35000e-08 0.00
+ )
Xdrv_a3 sd_a3 d_a3 vdd gnd tb_x1
Vd_b0 sd_b0 gnd PWL(
+ 0.00000e+00 1.80 1.01250e-08 1.80 1.01400e-08 0.00 1.46250e-08 0.00 1.46400e-08 1.80 1.76250e-08 1.80
+ 1.76400e-08 0.00 2.21250e-08 0.00 2.21400e-08 1.80 2.36250e-08 1.80 2.36400e-08 0.00 2.66250e-08 0.00
+ 2.66400e-08 1.80 2.96250e-08 1.80 2.96400e-08 0.00 3.71250e-08 0.00 3.71400e-08 1.80 3.86250e-08 1.80
+ 3.86400e-08 0.00 4.31250e-08 0.00 4.31400e-08 1.80 5.06250e-08 1.80 5.06400e-08 0.00 5.66250e-08 0.00
+ 5.66400e-08 1.80 5.96250e-08 1.80 5.96400e-08 0.00 6.11250e-08 0.00 6.11400e-08 1.80 6.41250e-08 1.80
+ 6.41400e-08 0.00 7.35000e-08 0.00
+ )
Xdrv_b0 sd_b0 d_b0 vdd gnd tb_x1
Vd_b1 sd_b1 gnd PWL(
+ 0.00000e+00 1.80 1.31250e-08 1.80 1.31400e-08 0.00 1.46250e-08 0.00 1.46400e-08 1.80 1.61250e-08 1.80
+ 1.61400e-08 0.00 2.06250e-08 0.00 2.06400e-08 1.80 2.21250e-08 1.80 2.21400e-08 0.00 2.36250e-08 0.00
+ 2.36400e-08 1.80 2.51250e-08 1.80 2.51400e-08 0.00 2.81250e-08 0.00 2.81400e-08 1.80 2.96250e-08 1.80
+ 2.96400e-08 0.00 3.11250e-08 0.00 3.11400e-08 1.80 3.26250e-08 1.80 3.26400e-08 0.00 4.01250e-08 0.00
+ 4.01400e-08 1.80 4.16250e-08 1.80 4.16400e-08 0.00 4.61250e-08 0.00 4.61400e-08 1.80 4.76250e-08 1.80
+ 4.76400e-08 0.00 5.06250e-08 0.00 5.06400e-08 1.80 5.21250e-08 1.80 5.21400e-08 0.00 5.81250e-08 0.00
+ 5.81400e-08 1.80 5.96250e-08 1.80 5.96400e-08 0.00 6.26250e-08 0.00 6.26400e-08 1.80 6.41250e-08 1.80
+ 6.41400e-08 0.00 6.56250e-08 0.00 6.56400e-08 1.80 6.71250e-08 1.80 6.71400e-08 0.00 7.35000e-08 0.00
+ )
Xdrv_b1 sd_b1 d_b1 vdd gnd tb_x1
Vd_b2 sd_b2 gnd PWL(
+ 0.00000e+00 1.80 8.62500e-09 1.80 8.64000e-09 0.00 1.01250e-08 0.00 1.01400e-08 1.80 1.46250e-08 1.80
+ 1.46400e-08 0.00 1.91250e-08 0.00 1.91400e-08 1.80 2.06250e-08 1.80 2.06400e-08 0.00 2.21250e-08 0.00
+ 2.21400e-08 1.80 2.36250e-08 1.80 2.36400e-08 0.00 2.51250e-08 0.00 2.51400e-08 1.80 2.81250e-08 1.80
+ 2.81400e-08 0.00 3.26250e-08 0.00 3.26400e-08 1.80 3.56250e-08 1.80 3.56400e-08 0.00 3.86250e-08 0.00
+ 3.86400e-08 1.80 4.31250e-08 1.80 4.31400e-08 0.00 4.46250e-08 0.00 4.46400e-08 1.80 5.21250e-08 1.80
+ 5.21400e-08 0.00 5.36250e-08 0.00 5.36400e-08 1.80 5.66250e-08 1.80 5.66400e-08 0.00 6.41250e-08 0.00
+ 6.41400e-08 1.80 6.56250e-08 1.80 6.56400e-08 0.00 7.35000e-08 0.00
+ )
Xdrv_b2 sd_b2 d_b2 vdd gnd tb_x1
Vd_b3 sd_b3 gnd PWL(
+ 0.00000e+00 1.80 1.01250e-08 1.80 1.01400e-08 0.00 1.31250e-08 0.00 1.31400e-08 1.80 2.06250e-08 1.80
+ 2.06400e-08 0.00 2.21250e-08 0.00 2.21400e-08 1.80 2.51250e-08 1.80 2.51400e-08 0.00 2.81250e-08 0.00
+ 2.81400e-08 1.80 2.96250e-08 1.80 2.96400e-08 0.00 3.11250e-08 0.00 3.11400e-08 1.80 3.26250e-08 1.80
+ 3.26400e-08 0.00 3.41250e-08 0.00 3.41400e-08 1.80 3.71250e-08 1.80 3.71400e-08 0.00 3.86250e-08 0.00
+ 3.86400e-08 1.80 4.01250e-08 1.80 4.01400e-08 0.00 4.16250e-08 0.00 4.16400e-08 1.80 4.31250e-08 1.80
+ 4.31400e-08 0.00 4.46250e-08 0.00 4.46400e-08 1.80 4.61250e-08 1.80 4.61400e-08 0.00 4.76250e-08 0.00
+ 4.76400e-08 1.80 4.91250e-08 1.80 4.91400e-08 0.00 5.21250e-08 0.00 5.21400e-08 1.80 5.51250e-08 1.80
+ 5.51400e-08 0.00 5.66250e-08 0.00 5.66400e-08 1.80 5.81250e-08 1.80 5.81400e-08 0.00 5.96250e-08 0.00
+ 5.96400e-08 1.80 6.56250e-08 1.80 6.56400e-08 0.00 7.35000e-08 0.00
+ )
Xdrv_b3 sd_b3 d_b3 vdd gnd tb_x1
Vd_c0 sd_c0 gnd PWL(
+ 0.00000e+00 1.80 4.12500e-09 1.80 4.14000e-09 0.00 5.62500e-09 0.00 5.64000e-09 1.80 7.12500e-09 1.80
+ 7.14000e-09 0.00 1.01250e-08 0.00 1.01400e-08 1.80 1.16250e-08 1.80 1.16400e-08 0.00 1.31250e-08 0.00
+ 1.31400e-08 1.80 1.76250e-08 1.80 1.76400e-08 0.00 1.91250e-08 0.00 1.91400e-08 1.80 2.51250e-08 1.80
+ 2.51400e-08 0.00 2.81250e-08 0.00 2.81400e-08 1.80 3.26250e-08 1.80 3.26400e-08 0.00 3.41250e-08 0.00
+ 3.41400e-08 1.80 4.01250e-08 1.80 4.01400e-08 0.00 4.16250e-08 0.00 4.16400e-08 1.80 4.76250e-08 1.80
+ 4.76400e-08 0.00 5.06250e-08 0.00 5.06400e-08 1.80 5.36250e-08 1.80 5.36400e-08 0.00 5.51250e-08 0.00
+ 5.51400e-08 1.80 5.96250e-08 1.80 5.96400e-08 0.00 6.11250e-08 0.00 6.11400e-08 1.80 6.71250e-08 1.80
+ 6.71400e-08 0.00 7.35000e-08 0.00
+ )
Xdrv_c0 sd_c0 d_c0 vdd gnd tb_x1
Vclk sc gnd PWL(
+ 0 0 2.99000e-09 0 3.01000e-09 1.8 3.74000e-09 1.8 3.76000e-09 0 4.49000e-09 0
+ 4.51000e-09 1.8 5.24000e-09 1.8 5.26000e-09 0 5.99000e-09 0 6.01000e-09 1.8 6.74000e-09 1.8
+ 6.76000e-09 0 7.49000e-09 0 7.51000e-09 1.8 8.24000e-09 1.8 8.26000e-09 0 8.99000e-09 0
+ 9.01000e-09 1.8 9.74000e-09 1.8 9.76000e-09 0 1.04900e-08 0 1.05100e-08 1.8 1.12400e-08 1.8
+ 1.12600e-08 0 1.19900e-08 0 1.20100e-08 1.8 1.27400e-08 1.8 1.27600e-08 0 1.34900e-08 0
+ 1.35100e-08 1.8 1.42400e-08 1.8 1.42600e-08 0 1.49900e-08 0 1.50100e-08 1.8 1.57400e-08 1.8
+ 1.57600e-08 0 1.64900e-08 0 1.65100e-08 1.8 1.72400e-08 1.8 1.72600e-08 0 1.79900e-08 0
+ 1.80100e-08 1.8 1.87400e-08 1.8 1.87600e-08 0 1.94900e-08 0 1.95100e-08 1.8 2.02400e-08 1.8
+ 2.02600e-08 0 2.09900e-08 0 2.10100e-08 1.8 2.17400e-08 1.8 2.17600e-08 0 2.24900e-08 0
+ 2.25100e-08 1.8 2.32400e-08 1.8 2.32600e-08 0 2.39900e-08 0 2.40100e-08 1.8 2.47400e-08 1.8
+ 2.47600e-08 0 2.54900e-08 0 2.55100e-08 1.8 2.62400e-08 1.8 2.62600e-08 0 2.69900e-08 0
+ 2.70100e-08 1.8 2.77400e-08 1.8 2.77600e-08 0 2.84900e-08 0 2.85100e-08 1.8 2.92400e-08 1.8
+ 2.92600e-08 0 2.99900e-08 0 3.00100e-08 1.8 3.07400e-08 1.8 3.07600e-08 0 3.14900e-08 0
+ 3.15100e-08 1.8 3.22400e-08 1.8 3.22600e-08 0 3.29900e-08 0 3.30100e-08 1.8 3.37400e-08 1.8
+ 3.37600e-08 0 3.44900e-08 0 3.45100e-08 1.8 3.52400e-08 1.8 3.52600e-08 0 3.59900e-08 0
+ 3.60100e-08 1.8 3.67400e-08 1.8 3.67600e-08 0 3.74900e-08 0 3.75100e-08 1.8 3.82400e-08 1.8
+ 3.82600e-08 0 3.89900e-08 0 3.90100e-08 1.8 3.97400e-08 1.8 3.97600e-08 0 4.04900e-08 0
+ 4.05100e-08 1.8 4.12400e-08 1.8 4.12600e-08 0 4.19900e-08 0 4.20100e-08 1.8 4.27400e-08 1.8
+ 4.27600e-08 0 4.34900e-08 0 4.35100e-08 1.8 4.42400e-08 1.8 4.42600e-08 0 4.49900e-08 0
+ 4.50100e-08 1.8 4.57400e-08 1.8 4.57600e-08 0 4.64900e-08 0 4.65100e-08 1.8 4.72400e-08 1.8
+ 4.72600e-08 0 4.79900e-08 0 4.80100e-08 1.8 4.87400e-08 1.8 4.87600e-08 0 4.94900e-08 0
+ 4.95100e-08 1.8 5.02400e-08 1.8 5.02600e-08 0 5.09900e-08 0 5.10100e-08 1.8 5.17400e-08 1.8
+ 5.17600e-08 0 5.24900e-08 0 5.25100e-08 1.8 5.32400e-08 1.8 5.32600e-08 0 5.39900e-08 0
+ 5.40100e-08 1.8 5.47400e-08 1.8 5.47600e-08 0 5.54900e-08 0 5.55100e-08 1.8 5.62400e-08 1.8
+ 5.62600e-08 0 5.69900e-08 0 5.70100e-08 1.8 5.77400e-08 1.8 5.77600e-08 0 5.84900e-08 0
+ 5.85100e-08 1.8 5.92400e-08 1.8 5.92600e-08 0 5.99900e-08 0 6.00100e-08 1.8 6.07400e-08 1.8
+ 6.07600e-08 0 6.14900e-08 0 6.15100e-08 1.8 6.22400e-08 1.8 6.22600e-08 0 6.29900e-08 0
+ 6.30100e-08 1.8 6.37400e-08 1.8 6.37600e-08 0 6.44900e-08 0 6.45100e-08 1.8 6.52400e-08 1.8
+ 6.52600e-08 0 6.59900e-08 0 6.60100e-08 1.8 6.67400e-08 1.8 6.67600e-08 0 6.74900e-08 0
+ 6.75100e-08 1.8 6.82400e-08 1.8 6.82600e-08 0 6.89900e-08 0 6.90100e-08 1.8 6.97400e-08 1.8
+ 6.97600e-08 0 7.04900e-08 0 7.05100e-08 1.8 7.12400e-08 1.8 7.12600e-08 0 7.19900e-08 0
+ 7.20100e-08 1.8 7.27400e-08 1.8 7.27600e-08 0
+ )
Xc1 sc c1 vdd gnd tb_x1
Xc2 c1 clk vdd gnd tb_x8
X0 d_a0 d_a1 d_a2 d_a3 d_b0 d_b1 d_b2 d_b3 d_c0 clk q_s0 q_s1 q_s2 q_s3 q_c4 vdd gnd reg_trial
Xl_q_s0 q_s0 lo_q_s0 vdd gnd tb_x1
Xl_q_s1 q_s1 lo_q_s1 vdd gnd tb_x1
Xl_q_s2 q_s2 lo_q_s2 vdd gnd tb_x1
Xl_q_s3 q_s3 lo_q_s3 vdd gnd tb_x1
Xl_q_c4 q_c4 lo_q_c4 vdd gnd tb_x1
.tran 5p 7.35000e-08
.meas tran iavg AVG i(Vsense) FROM=4.50000e-09 TO=7.20000e-08
.control
set wr_singlescale
set wr_vecnames
run
set curplottitle=Bhargav-2025102061-1.6-sch_1500
wrdata sch_1500.txt v(q_s0) v(q_s1) v(q_s2) v(q_s3) v(q_c4) v(clk) v(d_a0) v(d_a1) v(d_a2) v(d_a3) v(d_b0) v(d_b1) v(d_b2) v(d_b3) v(d_c0)
quit
.endc
.end
