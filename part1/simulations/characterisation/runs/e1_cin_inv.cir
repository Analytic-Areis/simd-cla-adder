* E1 input capacitance of inverter
.include ../../../../TSMC_180nm.txt
.options reltol=1e-4
VDD vdd gnd 1.8
.subckt inv in out vdd gnd
mp out in vdd vdd CMOSP W=1.8000e-06 L=1.8000e-07 AS=9.7200e-13 PS=4.6800e-06 AD=9.7200e-13 PD=4.6800e-06
mn out in gnd gnd CMOSN W=9.0000e-07 L=1.8000e-07 AS=4.8600e-13 PS=2.8800e-06 AD=4.8600e-13 PD=2.8800e-06
.ends
Vg g gnd PWL(0 0 1n 0 2n 1.8 3n 1.8)
X1 g o vdd gnd inv
.subckt invload in out vdd gnd
mp out in vdd vdd CMOSP W=1.8000e-06 L=1.8000e-07 AS=9.7200e-13 PS=4.6800e-06 AD=9.7200e-13 PD=4.6800e-06
mn out in gnd gnd CMOSN W=9.0000e-07 L=1.8000e-07 AS=4.8600e-13 PS=2.8800e-06 AD=4.8600e-13 PD=2.8800e-06
.ends
X2 o o2 vdd gnd invload
.tran 1p 3n
.meas tran q INTEG i(Vg) FROM=1n TO=3n
.end
