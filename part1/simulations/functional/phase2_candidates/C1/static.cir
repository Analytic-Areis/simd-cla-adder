* DC supply current of cla_c1
.include ../../../../spice/models/TSMC_180nm.txt
VDD vdd gnd 1.8
* xor_static12_x1: static XOR, AOI22 with two inverters
* GENERATED from part1/cells/library.py. Do not edit by hand.
.subckt xor_static12_x1 p c s vdd gnd
Ms0p1 pb p vdd vdd CMOSP W=1.8000e-06 L=1.8000e-07 AS=9.7200e-13 PS=4.6800e-06 AD=9.7200e-13 PD=4.6800e-06
Ms0n1 pb p gnd gnd CMOSN W=9.0000e-07 L=1.8000e-07 AS=4.8600e-13 PS=2.8800e-06 AD=4.8600e-13 PD=2.8800e-06
Ms1p1 cb c vdd vdd CMOSP W=1.8000e-06 L=1.8000e-07 AS=9.7200e-13 PS=4.6800e-06 AD=9.7200e-13 PD=4.6800e-06
Ms1n1 cb c gnd gnd CMOSN W=9.0000e-07 L=1.8000e-07 AS=4.8600e-13 PS=2.8800e-06 AD=4.8600e-13 PD=2.8800e-06
Ms2p1 s2xp1 p vdd vdd CMOSP W=3.6000e-06 L=1.8000e-07 AS=1.9440e-12 PS=8.2800e-06 AD=1.9440e-12 PD=8.2800e-06
Ms2p2 s2xp1 c vdd vdd CMOSP W=3.6000e-06 L=1.8000e-07 AS=1.9440e-12 PS=8.2800e-06 AD=1.9440e-12 PD=8.2800e-06
Ms2p3 s pb s2xp1 vdd CMOSP W=3.6000e-06 L=1.8000e-07 AS=1.9440e-12 PS=8.2800e-06 AD=1.9440e-12 PD=8.2800e-06
Ms2p4 s cb s2xp1 vdd CMOSP W=3.6000e-06 L=1.8000e-07 AS=1.9440e-12 PS=8.2800e-06 AD=1.9440e-12 PD=8.2800e-06
Ms2n1 s p s2xn1 gnd CMOSN W=1.8000e-06 L=1.8000e-07 AS=4.8600e-13 PS=4.1400e-06 AD=9.7200e-13 PD=4.6800e-06
Ms2n2 s2xn1 c gnd gnd CMOSN W=1.8000e-06 L=1.8000e-07 AS=9.7200e-13 PS=4.6800e-06 AD=4.8600e-13 PD=4.1400e-06
Ms2n3 s pb s2xn2 gnd CMOSN W=1.8000e-06 L=1.8000e-07 AS=4.8600e-13 PS=4.1400e-06 AD=9.7200e-13 PD=4.6800e-06
Ms2n4 s2xn2 cb gnd gnd CMOSN W=1.8000e-06 L=1.8000e-07 AS=9.7200e-13 PS=4.6800e-06 AD=4.8600e-13 PD=4.1400e-06
.ends xor_static12_x1
* nand2_x1: 2-input NAND
* GENERATED from part1/cells/library.py. Do not edit by hand.
.subckt nand2_x1 i0 i1 y vdd gnd
Mp1 y i0 vdd vdd CMOSP W=1.8000e-06 L=1.8000e-07 AS=9.7200e-13 PS=4.6800e-06 AD=9.7200e-13 PD=4.6800e-06
Mp2 y i1 vdd vdd CMOSP W=1.8000e-06 L=1.8000e-07 AS=9.7200e-13 PS=4.6800e-06 AD=9.7200e-13 PD=4.6800e-06
Mn1 y i0 xn1 gnd CMOSN W=1.8000e-06 L=1.8000e-07 AS=4.8600e-13 PS=4.1400e-06 AD=9.7200e-13 PD=4.6800e-06
Mn2 xn1 i1 gnd gnd CMOSN W=1.8000e-06 L=1.8000e-07 AS=9.7200e-13 PS=4.6800e-06 AD=4.8600e-13 PD=4.1400e-06
.ends nand2_x1
* inv_x1: inverter
* GENERATED from part1/cells/library.py. Do not edit by hand.
.subckt inv_x1 a y vdd gnd
Mp1 y a vdd vdd CMOSP W=1.8000e-06 L=1.8000e-07 AS=9.7200e-13 PS=4.6800e-06 AD=9.7200e-13 PD=4.6800e-06
Mn1 y a gnd gnd CMOSN W=9.0000e-07 L=1.8000e-07 AS=4.8600e-13 PS=2.8800e-06 AD=4.8600e-13 PD=2.8800e-06
.ends inv_x1
* nand3_x1: 3-input NAND
* GENERATED from part1/cells/library.py. Do not edit by hand.
.subckt nand3_x1 i0 i1 i2 y vdd gnd
Mp1 y i0 vdd vdd CMOSP W=1.8000e-06 L=1.8000e-07 AS=9.7200e-13 PS=4.6800e-06 AD=9.7200e-13 PD=4.6800e-06
Mp2 y i1 vdd vdd CMOSP W=1.8000e-06 L=1.8000e-07 AS=9.7200e-13 PS=4.6800e-06 AD=9.7200e-13 PD=4.6800e-06
Mp3 y i2 vdd vdd CMOSP W=1.8000e-06 L=1.8000e-07 AS=9.7200e-13 PS=4.6800e-06 AD=9.7200e-13 PD=4.6800e-06
Mn1 y i0 xn1 gnd CMOSN W=2.7000e-06 L=1.8000e-07 AS=7.2900e-13 PS=5.9400e-06 AD=1.4580e-12 PD=6.4800e-06
Mn2 xn1 i1 xn2 gnd CMOSN W=2.7000e-06 L=1.8000e-07 AS=7.2900e-13 PS=5.9400e-06 AD=7.2900e-13 PD=5.9400e-06
Mn3 xn2 i2 gnd gnd CMOSN W=2.7000e-06 L=1.8000e-07 AS=1.4580e-12 PS=6.4800e-06 AD=7.2900e-13 PD=5.9400e-06
.ends nand3_x1
* nand4_x1: 4-input NAND
* GENERATED from part1/cells/library.py. Do not edit by hand.
.subckt nand4_x1 i0 i1 i2 i3 y vdd gnd
Mp1 y i0 vdd vdd CMOSP W=1.8000e-06 L=1.8000e-07 AS=9.7200e-13 PS=4.6800e-06 AD=9.7200e-13 PD=4.6800e-06
Mp2 y i1 vdd vdd CMOSP W=1.8000e-06 L=1.8000e-07 AS=9.7200e-13 PS=4.6800e-06 AD=9.7200e-13 PD=4.6800e-06
Mp3 y i2 vdd vdd CMOSP W=1.8000e-06 L=1.8000e-07 AS=9.7200e-13 PS=4.6800e-06 AD=9.7200e-13 PD=4.6800e-06
Mp4 y i3 vdd vdd CMOSP W=1.8000e-06 L=1.8000e-07 AS=9.7200e-13 PS=4.6800e-06 AD=9.7200e-13 PD=4.6800e-06
Mn1 y i0 xn1 gnd CMOSN W=3.6000e-06 L=1.8000e-07 AS=9.7200e-13 PS=7.7400e-06 AD=1.9440e-12 PD=8.2800e-06
Mn2 xn1 i1 xn2 gnd CMOSN W=3.6000e-06 L=1.8000e-07 AS=9.7200e-13 PS=7.7400e-06 AD=9.7200e-13 PD=7.7400e-06
Mn3 xn2 i2 xn3 gnd CMOSN W=3.6000e-06 L=1.8000e-07 AS=9.7200e-13 PS=7.7400e-06 AD=9.7200e-13 PD=7.7400e-06
Mn4 xn3 i3 gnd gnd CMOSN W=3.6000e-06 L=1.8000e-07 AS=1.9440e-12 PS=8.2800e-06 AD=9.7200e-13 PD=7.7400e-06
.ends nand4_x1
* nand5_x1: 5-input NAND
* GENERATED from part1/cells/library.py. Do not edit by hand.
.subckt nand5_x1 i0 i1 i2 i3 i4 y vdd gnd
Mp1 y i0 vdd vdd CMOSP W=1.8000e-06 L=1.8000e-07 AS=9.7200e-13 PS=4.6800e-06 AD=9.7200e-13 PD=4.6800e-06
Mp2 y i1 vdd vdd CMOSP W=1.8000e-06 L=1.8000e-07 AS=9.7200e-13 PS=4.6800e-06 AD=9.7200e-13 PD=4.6800e-06
Mp3 y i2 vdd vdd CMOSP W=1.8000e-06 L=1.8000e-07 AS=9.7200e-13 PS=4.6800e-06 AD=9.7200e-13 PD=4.6800e-06
Mp4 y i3 vdd vdd CMOSP W=1.8000e-06 L=1.8000e-07 AS=9.7200e-13 PS=4.6800e-06 AD=9.7200e-13 PD=4.6800e-06
Mp5 y i4 vdd vdd CMOSP W=1.8000e-06 L=1.8000e-07 AS=9.7200e-13 PS=4.6800e-06 AD=9.7200e-13 PD=4.6800e-06
Mn1 y i0 xn1 gnd CMOSN W=4.5000e-06 L=1.8000e-07 AS=1.2150e-12 PS=9.5400e-06 AD=2.4300e-12 PD=1.0080e-05
Mn2 xn1 i1 xn2 gnd CMOSN W=4.5000e-06 L=1.8000e-07 AS=1.2150e-12 PS=9.5400e-06 AD=1.2150e-12 PD=9.5400e-06
Mn3 xn2 i2 xn3 gnd CMOSN W=4.5000e-06 L=1.8000e-07 AS=1.2150e-12 PS=9.5400e-06 AD=1.2150e-12 PD=9.5400e-06
Mn4 xn3 i3 xn4 gnd CMOSN W=4.5000e-06 L=1.8000e-07 AS=1.2150e-12 PS=9.5400e-06 AD=1.2150e-12 PD=9.5400e-06
Mn5 xn4 i4 gnd gnd CMOSN W=4.5000e-06 L=1.8000e-07 AS=2.4300e-12 PS=1.0080e-05 AD=1.2150e-12 PD=9.5400e-06
.ends nand5_x1
* cla_c1: Candidate C1: textbook XOR propagate, NAND-NAND carries
* GENERATED from part1/cells/library.py. Do not edit by hand.
.subckt cla_c1 a0 a1 a2 a3 b0 b1 b2 b3 c0 s0 s1 s2 s3 c4 vdd gnd
Xpx0 a0 b0 p0 vdd gnd xor_static12_x1
Xgn0 a0 b0 g0b vdd gnd nand2_x1
Xgi0 g0b g0 vdd gnd inv_x1
Xpx1 a1 b1 p1 vdd gnd xor_static12_x1
Xgn1 a1 b1 g1b vdd gnd nand2_x1
Xgi1 g1b g1 vdd gnd inv_x1
Xpx2 a2 b2 p2 vdd gnd xor_static12_x1
Xgn2 a2 b2 g2b vdd gnd nand2_x1
Xgi2 g2b g2 vdd gnd inv_x1
Xpx3 a3 b3 p3 vdd gnd xor_static12_x1
Xgn3 a3 b3 g3b vdd gnd nand2_x1
Xgi3 g3b g3 vdd gnd inv_x1
Xcn1_0 p0 c0 n1_0 vdd gnd nand2_x1
Xcm1 g0b n1_0 c1 vdd gnd nand2_x1
Xcn2_1 p1 g0 n2_1 vdd gnd nand2_x1
Xcn2_0 p1 p0 c0 n2_0 vdd gnd nand3_x1
Xcm2 g1b n2_1 n2_0 c2 vdd gnd nand3_x1
Xcn3_2 p2 g1 n3_2 vdd gnd nand2_x1
Xcn3_1 p2 p1 g0 n3_1 vdd gnd nand3_x1
Xcn3_0 p2 p1 p0 c0 n3_0 vdd gnd nand4_x1
Xcm3 g2b n3_2 n3_1 n3_0 c3 vdd gnd nand4_x1
Xcn4_3 p3 g2 n4_3 vdd gnd nand2_x1
Xcn4_2 p3 p2 g1 n4_2 vdd gnd nand3_x1
Xcn4_1 p3 p2 p1 g0 n4_1 vdd gnd nand4_x1
Xcn4_0 p3 p2 p1 p0 c0 n4_0 vdd gnd nand5_x1
Xcm4 g3b n4_3 n4_2 n4_1 n4_0 c4 vdd gnd nand5_x1
Xsx0 p0 c0 s0 vdd gnd xor_static12_x1
Xsx1 p1 c1 s1 vdd gnd xor_static12_x1
Xsx2 p2 c2 s2 vdd gnd xor_static12_x1
Xsx3 p3 c3 s3 vdd gnd xor_static12_x1
.ends cla_c1
.subckt tb_inv a y vdd gnd
mp y a vdd vdd CMOSP W=1.8e-06 L=1.8e-07 AS=9.72e-13 PS=4.68e-06 AD=9.72e-13 PD=4.68e-06
mn y a gnd gnd CMOSN W=9.0e-07 L=1.8e-07 AS=4.86e-13 PS=2.88e-06 AD=4.86e-13 PD=2.88e-06
.ends
Va0 src_a0 gnd 1.8
Xd_a0 src_a0 a0 vdd gnd tb_inv
Va1 src_a1 gnd 1.8
Xd_a1 src_a1 a1 vdd gnd tb_inv
Va2 src_a2 gnd 1.8
Xd_a2 src_a2 a2 vdd gnd tb_inv
Va3 src_a3 gnd 1.8
Xd_a3 src_a3 a3 vdd gnd tb_inv
Vb0 src_b0 gnd 1.8
Xd_b0 src_b0 b0 vdd gnd tb_inv
Vb1 src_b1 gnd 1.8
Xd_b1 src_b1 b1 vdd gnd tb_inv
Vb2 src_b2 gnd 1.8
Xd_b2 src_b2 b2 vdd gnd tb_inv
Vb3 src_b3 gnd 1.8
Xd_b3 src_b3 b3 vdd gnd tb_inv
Vc0 src_c0 gnd 1.8
Xd_c0 src_c0 c0 vdd gnd tb_inv
Xl_s0 s0 lo_s0 vdd gnd tb_inv
Xl_s1 s1 lo_s1 vdd gnd tb_inv
Xl_s2 s2 lo_s2 vdd gnd tb_inv
Xl_s3 s3 lo_s3 vdd gnd tb_inv
Xl_c4 c4 lo_c4 vdd gnd tb_inv
X0 a0 a1 a2 a3 b0 b1 b2 b3 c0 s0 s1 s2 s3 c4 vdd gnd cla_c1
.control
alter Va0 = 1.8
alter Va1 = 1.8
alter Va2 = 1.8
alter Va3 = 1.8
alter Vb0 = 1.8
alter Vb1 = 1.8
alter Vb2 = 1.8
alter Vb3 = 1.8
alter Vc0 = 1.8
op
print i(VDD) >> dc_current.txt
alter Va0 = 1.8
alter Va1 = 1.8
alter Va2 = 1.8
alter Va3 = 1.8
alter Vb0 = 1.8
alter Vb1 = 1.8
alter Vb2 = 1.8
alter Vb3 = 1.8
alter Vc0 = 0.0
op
print i(VDD) >> dc_current.txt
alter Va0 = 1.8
alter Va1 = 1.8
alter Va2 = 1.8
alter Va3 = 1.8
alter Vb0 = 1.8
alter Vb1 = 1.8
alter Vb2 = 1.8
alter Vb3 = 0.0
alter Vc0 = 1.8
op
print i(VDD) >> dc_current.txt
alter Va0 = 1.8
alter Va1 = 1.8
alter Va2 = 1.8
alter Va3 = 1.8
alter Vb0 = 1.8
alter Vb1 = 1.8
alter Vb2 = 1.8
alter Vb3 = 0.0
alter Vc0 = 0.0
op
print i(VDD) >> dc_current.txt
alter Va0 = 1.8
alter Va1 = 1.8
alter Va2 = 1.8
alter Va3 = 1.8
alter Vb0 = 1.8
alter Vb1 = 1.8
alter Vb2 = 0.0
alter Vb3 = 1.8
alter Vc0 = 1.8
op
print i(VDD) >> dc_current.txt
alter Va0 = 1.8
alter Va1 = 1.8
alter Va2 = 1.8
alter Va3 = 1.8
alter Vb0 = 1.8
alter Vb1 = 1.8
alter Vb2 = 0.0
alter Vb3 = 1.8
alter Vc0 = 0.0
op
print i(VDD) >> dc_current.txt
alter Va0 = 1.8
alter Va1 = 1.8
alter Va2 = 1.8
alter Va3 = 1.8
alter Vb0 = 1.8
alter Vb1 = 1.8
alter Vb2 = 0.0
alter Vb3 = 0.0
alter Vc0 = 1.8
op
print i(VDD) >> dc_current.txt
alter Va0 = 1.8
alter Va1 = 1.8
alter Va2 = 1.8
alter Va3 = 1.8
alter Vb0 = 1.8
alter Vb1 = 1.8
alter Vb2 = 0.0
alter Vb3 = 0.0
alter Vc0 = 0.0
op
print i(VDD) >> dc_current.txt
alter Va0 = 1.8
alter Va1 = 1.8
alter Va2 = 1.8
alter Va3 = 1.8
alter Vb0 = 1.8
alter Vb1 = 0.0
alter Vb2 = 1.8
alter Vb3 = 1.8
alter Vc0 = 1.8
op
print i(VDD) >> dc_current.txt
alter Va0 = 1.8
alter Va1 = 1.8
alter Va2 = 1.8
alter Va3 = 1.8
alter Vb0 = 1.8
alter Vb1 = 0.0
alter Vb2 = 1.8
alter Vb3 = 1.8
alter Vc0 = 0.0
op
print i(VDD) >> dc_current.txt
alter Va0 = 1.8
alter Va1 = 1.8
alter Va2 = 1.8
alter Va3 = 1.8
alter Vb0 = 1.8
alter Vb1 = 0.0
alter Vb2 = 1.8
alter Vb3 = 0.0
alter Vc0 = 1.8
op
print i(VDD) >> dc_current.txt
alter Va0 = 1.8
alter Va1 = 1.8
alter Va2 = 1.8
alter Va3 = 1.8
alter Vb0 = 1.8
alter Vb1 = 0.0
alter Vb2 = 1.8
alter Vb3 = 0.0
alter Vc0 = 0.0
op
print i(VDD) >> dc_current.txt
alter Va0 = 1.8
alter Va1 = 1.8
alter Va2 = 1.8
alter Va3 = 1.8
alter Vb0 = 1.8
alter Vb1 = 0.0
alter Vb2 = 0.0
alter Vb3 = 1.8
alter Vc0 = 1.8
op
print i(VDD) >> dc_current.txt
alter Va0 = 1.8
alter Va1 = 1.8
alter Va2 = 1.8
alter Va3 = 1.8
alter Vb0 = 1.8
alter Vb1 = 0.0
alter Vb2 = 0.0
alter Vb3 = 1.8
alter Vc0 = 0.0
op
print i(VDD) >> dc_current.txt
alter Va0 = 1.8
alter Va1 = 1.8
alter Va2 = 1.8
alter Va3 = 1.8
alter Vb0 = 1.8
alter Vb1 = 0.0
alter Vb2 = 0.0
alter Vb3 = 0.0
alter Vc0 = 1.8
op
print i(VDD) >> dc_current.txt
alter Va0 = 1.8
alter Va1 = 1.8
alter Va2 = 1.8
alter Va3 = 1.8
alter Vb0 = 1.8
alter Vb1 = 0.0
alter Vb2 = 0.0
alter Vb3 = 0.0
alter Vc0 = 0.0
op
print i(VDD) >> dc_current.txt
alter Va0 = 1.8
alter Va1 = 1.8
alter Va2 = 1.8
alter Va3 = 1.8
alter Vb0 = 0.0
alter Vb1 = 1.8
alter Vb2 = 1.8
alter Vb3 = 1.8
alter Vc0 = 1.8
op
print i(VDD) >> dc_current.txt
alter Va0 = 1.8
alter Va1 = 1.8
alter Va2 = 1.8
alter Va3 = 1.8
alter Vb0 = 0.0
alter Vb1 = 1.8
alter Vb2 = 1.8
alter Vb3 = 1.8
alter Vc0 = 0.0
op
print i(VDD) >> dc_current.txt
alter Va0 = 1.8
alter Va1 = 1.8
alter Va2 = 1.8
alter Va3 = 1.8
alter Vb0 = 0.0
alter Vb1 = 1.8
alter Vb2 = 1.8
alter Vb3 = 0.0
alter Vc0 = 1.8
op
print i(VDD) >> dc_current.txt
alter Va0 = 1.8
alter Va1 = 1.8
alter Va2 = 1.8
alter Va3 = 1.8
alter Vb0 = 0.0
alter Vb1 = 1.8
alter Vb2 = 1.8
alter Vb3 = 0.0
alter Vc0 = 0.0
op
print i(VDD) >> dc_current.txt
alter Va0 = 1.8
alter Va1 = 1.8
alter Va2 = 1.8
alter Va3 = 1.8
alter Vb0 = 0.0
alter Vb1 = 1.8
alter Vb2 = 0.0
alter Vb3 = 1.8
alter Vc0 = 1.8
op
print i(VDD) >> dc_current.txt
alter Va0 = 1.8
alter Va1 = 1.8
alter Va2 = 1.8
alter Va3 = 1.8
alter Vb0 = 0.0
alter Vb1 = 1.8
alter Vb2 = 0.0
alter Vb3 = 1.8
alter Vc0 = 0.0
op
print i(VDD) >> dc_current.txt
alter Va0 = 1.8
alter Va1 = 1.8
alter Va2 = 1.8
alter Va3 = 1.8
alter Vb0 = 0.0
alter Vb1 = 1.8
alter Vb2 = 0.0
alter Vb3 = 0.0
alter Vc0 = 1.8
op
print i(VDD) >> dc_current.txt
alter Va0 = 1.8
alter Va1 = 1.8
alter Va2 = 1.8
alter Va3 = 1.8
alter Vb0 = 0.0
alter Vb1 = 1.8
alter Vb2 = 0.0
alter Vb3 = 0.0
alter Vc0 = 0.0
op
print i(VDD) >> dc_current.txt
alter Va0 = 1.8
alter Va1 = 1.8
alter Va2 = 1.8
alter Va3 = 1.8
alter Vb0 = 0.0
alter Vb1 = 0.0
alter Vb2 = 1.8
alter Vb3 = 1.8
alter Vc0 = 1.8
op
print i(VDD) >> dc_current.txt
alter Va0 = 1.8
alter Va1 = 1.8
alter Va2 = 1.8
alter Va3 = 1.8
alter Vb0 = 0.0
alter Vb1 = 0.0
alter Vb2 = 1.8
alter Vb3 = 1.8
alter Vc0 = 0.0
op
print i(VDD) >> dc_current.txt
alter Va0 = 1.8
alter Va1 = 1.8
alter Va2 = 1.8
alter Va3 = 1.8
alter Vb0 = 0.0
alter Vb1 = 0.0
alter Vb2 = 1.8
alter Vb3 = 0.0
alter Vc0 = 1.8
op
print i(VDD) >> dc_current.txt
alter Va0 = 1.8
alter Va1 = 1.8
alter Va2 = 1.8
alter Va3 = 1.8
alter Vb0 = 0.0
alter Vb1 = 0.0
alter Vb2 = 1.8
alter Vb3 = 0.0
alter Vc0 = 0.0
op
print i(VDD) >> dc_current.txt
alter Va0 = 1.8
alter Va1 = 1.8
alter Va2 = 1.8
alter Va3 = 1.8
alter Vb0 = 0.0
alter Vb1 = 0.0
alter Vb2 = 0.0
alter Vb3 = 1.8
alter Vc0 = 1.8
op
print i(VDD) >> dc_current.txt
alter Va0 = 1.8
alter Va1 = 1.8
alter Va2 = 1.8
alter Va3 = 1.8
alter Vb0 = 0.0
alter Vb1 = 0.0
alter Vb2 = 0.0
alter Vb3 = 1.8
alter Vc0 = 0.0
op
print i(VDD) >> dc_current.txt
alter Va0 = 1.8
alter Va1 = 1.8
alter Va2 = 1.8
alter Va3 = 1.8
alter Vb0 = 0.0
alter Vb1 = 0.0
alter Vb2 = 0.0
alter Vb3 = 0.0
alter Vc0 = 1.8
op
print i(VDD) >> dc_current.txt
alter Va0 = 1.8
alter Va1 = 1.8
alter Va2 = 1.8
alter Va3 = 1.8
alter Vb0 = 0.0
alter Vb1 = 0.0
alter Vb2 = 0.0
alter Vb3 = 0.0
alter Vc0 = 0.0
op
print i(VDD) >> dc_current.txt
alter Va0 = 1.8
alter Va1 = 1.8
alter Va2 = 1.8
alter Va3 = 0.0
alter Vb0 = 1.8
alter Vb1 = 1.8
alter Vb2 = 1.8
alter Vb3 = 1.8
alter Vc0 = 1.8
op
print i(VDD) >> dc_current.txt
alter Va0 = 1.8
alter Va1 = 1.8
alter Va2 = 1.8
alter Va3 = 0.0
alter Vb0 = 1.8
alter Vb1 = 1.8
alter Vb2 = 1.8
alter Vb3 = 1.8
alter Vc0 = 0.0
op
print i(VDD) >> dc_current.txt
alter Va0 = 1.8
alter Va1 = 1.8
alter Va2 = 1.8
alter Va3 = 0.0
alter Vb0 = 1.8
alter Vb1 = 1.8
alter Vb2 = 1.8
alter Vb3 = 0.0
alter Vc0 = 1.8
op
print i(VDD) >> dc_current.txt
alter Va0 = 1.8
alter Va1 = 1.8
alter Va2 = 1.8
alter Va3 = 0.0
alter Vb0 = 1.8
alter Vb1 = 1.8
alter Vb2 = 1.8
alter Vb3 = 0.0
alter Vc0 = 0.0
op
print i(VDD) >> dc_current.txt
alter Va0 = 1.8
alter Va1 = 1.8
alter Va2 = 1.8
alter Va3 = 0.0
alter Vb0 = 1.8
alter Vb1 = 1.8
alter Vb2 = 0.0
alter Vb3 = 1.8
alter Vc0 = 1.8
op
print i(VDD) >> dc_current.txt
alter Va0 = 1.8
alter Va1 = 1.8
alter Va2 = 1.8
alter Va3 = 0.0
alter Vb0 = 1.8
alter Vb1 = 1.8
alter Vb2 = 0.0
alter Vb3 = 1.8
alter Vc0 = 0.0
op
print i(VDD) >> dc_current.txt
alter Va0 = 1.8
alter Va1 = 1.8
alter Va2 = 1.8
alter Va3 = 0.0
alter Vb0 = 1.8
alter Vb1 = 1.8
alter Vb2 = 0.0
alter Vb3 = 0.0
alter Vc0 = 1.8
op
print i(VDD) >> dc_current.txt
alter Va0 = 1.8
alter Va1 = 1.8
alter Va2 = 1.8
alter Va3 = 0.0
alter Vb0 = 1.8
alter Vb1 = 1.8
alter Vb2 = 0.0
alter Vb3 = 0.0
alter Vc0 = 0.0
op
print i(VDD) >> dc_current.txt
alter Va0 = 1.8
alter Va1 = 1.8
alter Va2 = 1.8
alter Va3 = 0.0
alter Vb0 = 1.8
alter Vb1 = 0.0
alter Vb2 = 1.8
alter Vb3 = 1.8
alter Vc0 = 1.8
op
print i(VDD) >> dc_current.txt
alter Va0 = 1.8
alter Va1 = 1.8
alter Va2 = 1.8
alter Va3 = 0.0
alter Vb0 = 1.8
alter Vb1 = 0.0
alter Vb2 = 1.8
alter Vb3 = 1.8
alter Vc0 = 0.0
op
print i(VDD) >> dc_current.txt
alter Va0 = 1.8
alter Va1 = 1.8
alter Va2 = 1.8
alter Va3 = 0.0
alter Vb0 = 1.8
alter Vb1 = 0.0
alter Vb2 = 1.8
alter Vb3 = 0.0
alter Vc0 = 1.8
op
print i(VDD) >> dc_current.txt
alter Va0 = 1.8
alter Va1 = 1.8
alter Va2 = 1.8
alter Va3 = 0.0
alter Vb0 = 1.8
alter Vb1 = 0.0
alter Vb2 = 1.8
alter Vb3 = 0.0
alter Vc0 = 0.0
op
print i(VDD) >> dc_current.txt
alter Va0 = 1.8
alter Va1 = 1.8
alter Va2 = 1.8
alter Va3 = 0.0
alter Vb0 = 1.8
alter Vb1 = 0.0
alter Vb2 = 0.0
alter Vb3 = 1.8
alter Vc0 = 1.8
op
print i(VDD) >> dc_current.txt
alter Va0 = 1.8
alter Va1 = 1.8
alter Va2 = 1.8
alter Va3 = 0.0
alter Vb0 = 1.8
alter Vb1 = 0.0
alter Vb2 = 0.0
alter Vb3 = 1.8
alter Vc0 = 0.0
op
print i(VDD) >> dc_current.txt
alter Va0 = 1.8
alter Va1 = 1.8
alter Va2 = 1.8
alter Va3 = 0.0
alter Vb0 = 1.8
alter Vb1 = 0.0
alter Vb2 = 0.0
alter Vb3 = 0.0
alter Vc0 = 1.8
op
print i(VDD) >> dc_current.txt
alter Va0 = 1.8
alter Va1 = 1.8
alter Va2 = 1.8
alter Va3 = 0.0
alter Vb0 = 1.8
alter Vb1 = 0.0
alter Vb2 = 0.0
alter Vb3 = 0.0
alter Vc0 = 0.0
op
print i(VDD) >> dc_current.txt
alter Va0 = 1.8
alter Va1 = 1.8
alter Va2 = 1.8
alter Va3 = 0.0
alter Vb0 = 0.0
alter Vb1 = 1.8
alter Vb2 = 1.8
alter Vb3 = 1.8
alter Vc0 = 1.8
op
print i(VDD) >> dc_current.txt
alter Va0 = 1.8
alter Va1 = 1.8
alter Va2 = 1.8
alter Va3 = 0.0
alter Vb0 = 0.0
alter Vb1 = 1.8
alter Vb2 = 1.8
alter Vb3 = 1.8
alter Vc0 = 0.0
op
print i(VDD) >> dc_current.txt
alter Va0 = 1.8
alter Va1 = 1.8
alter Va2 = 1.8
alter Va3 = 0.0
alter Vb0 = 0.0
alter Vb1 = 1.8
alter Vb2 = 1.8
alter Vb3 = 0.0
alter Vc0 = 1.8
op
print i(VDD) >> dc_current.txt
alter Va0 = 1.8
alter Va1 = 1.8
alter Va2 = 1.8
alter Va3 = 0.0
alter Vb0 = 0.0
alter Vb1 = 1.8
alter Vb2 = 1.8
alter Vb3 = 0.0
alter Vc0 = 0.0
op
print i(VDD) >> dc_current.txt
alter Va0 = 1.8
alter Va1 = 1.8
alter Va2 = 1.8
alter Va3 = 0.0
alter Vb0 = 0.0
alter Vb1 = 1.8
alter Vb2 = 0.0
alter Vb3 = 1.8
alter Vc0 = 1.8
op
print i(VDD) >> dc_current.txt
alter Va0 = 1.8
alter Va1 = 1.8
alter Va2 = 1.8
alter Va3 = 0.0
alter Vb0 = 0.0
alter Vb1 = 1.8
alter Vb2 = 0.0
alter Vb3 = 1.8
alter Vc0 = 0.0
op
print i(VDD) >> dc_current.txt
alter Va0 = 1.8
alter Va1 = 1.8
alter Va2 = 1.8
alter Va3 = 0.0
alter Vb0 = 0.0
alter Vb1 = 1.8
alter Vb2 = 0.0
alter Vb3 = 0.0
alter Vc0 = 1.8
op
print i(VDD) >> dc_current.txt
alter Va0 = 1.8
alter Va1 = 1.8
alter Va2 = 1.8
alter Va3 = 0.0
alter Vb0 = 0.0
alter Vb1 = 1.8
alter Vb2 = 0.0
alter Vb3 = 0.0
alter Vc0 = 0.0
op
print i(VDD) >> dc_current.txt
alter Va0 = 1.8
alter Va1 = 1.8
alter Va2 = 1.8
alter Va3 = 0.0
alter Vb0 = 0.0
alter Vb1 = 0.0
alter Vb2 = 1.8
alter Vb3 = 1.8
alter Vc0 = 1.8
op
print i(VDD) >> dc_current.txt
alter Va0 = 1.8
alter Va1 = 1.8
alter Va2 = 1.8
alter Va3 = 0.0
alter Vb0 = 0.0
alter Vb1 = 0.0
alter Vb2 = 1.8
alter Vb3 = 1.8
alter Vc0 = 0.0
op
print i(VDD) >> dc_current.txt
alter Va0 = 1.8
alter Va1 = 1.8
alter Va2 = 1.8
alter Va3 = 0.0
alter Vb0 = 0.0
alter Vb1 = 0.0
alter Vb2 = 1.8
alter Vb3 = 0.0
alter Vc0 = 1.8
op
print i(VDD) >> dc_current.txt
alter Va0 = 1.8
alter Va1 = 1.8
alter Va2 = 1.8
alter Va3 = 0.0
alter Vb0 = 0.0
alter Vb1 = 0.0
alter Vb2 = 1.8
alter Vb3 = 0.0
alter Vc0 = 0.0
op
print i(VDD) >> dc_current.txt
alter Va0 = 1.8
alter Va1 = 1.8
alter Va2 = 1.8
alter Va3 = 0.0
alter Vb0 = 0.0
alter Vb1 = 0.0
alter Vb2 = 0.0
alter Vb3 = 1.8
alter Vc0 = 1.8
op
print i(VDD) >> dc_current.txt
alter Va0 = 1.8
alter Va1 = 1.8
alter Va2 = 1.8
alter Va3 = 0.0
alter Vb0 = 0.0
alter Vb1 = 0.0
alter Vb2 = 0.0
alter Vb3 = 1.8
alter Vc0 = 0.0
op
print i(VDD) >> dc_current.txt
alter Va0 = 1.8
alter Va1 = 1.8
alter Va2 = 1.8
alter Va3 = 0.0
alter Vb0 = 0.0
alter Vb1 = 0.0
alter Vb2 = 0.0
alter Vb3 = 0.0
alter Vc0 = 1.8
op
print i(VDD) >> dc_current.txt
alter Va0 = 1.8
alter Va1 = 1.8
alter Va2 = 1.8
alter Va3 = 0.0
alter Vb0 = 0.0
alter Vb1 = 0.0
alter Vb2 = 0.0
alter Vb3 = 0.0
alter Vc0 = 0.0
op
print i(VDD) >> dc_current.txt
alter Va0 = 1.8
alter Va1 = 1.8
alter Va2 = 0.0
alter Va3 = 1.8
alter Vb0 = 1.8
alter Vb1 = 1.8
alter Vb2 = 1.8
alter Vb3 = 1.8
alter Vc0 = 1.8
op
print i(VDD) >> dc_current.txt
alter Va0 = 1.8
alter Va1 = 1.8
alter Va2 = 0.0
alter Va3 = 1.8
alter Vb0 = 1.8
alter Vb1 = 1.8
alter Vb2 = 1.8
alter Vb3 = 1.8
alter Vc0 = 0.0
op
print i(VDD) >> dc_current.txt
alter Va0 = 1.8
alter Va1 = 1.8
alter Va2 = 0.0
alter Va3 = 1.8
alter Vb0 = 1.8
alter Vb1 = 1.8
alter Vb2 = 1.8
alter Vb3 = 0.0
alter Vc0 = 1.8
op
print i(VDD) >> dc_current.txt
alter Va0 = 1.8
alter Va1 = 1.8
alter Va2 = 0.0
alter Va3 = 1.8
alter Vb0 = 1.8
alter Vb1 = 1.8
alter Vb2 = 1.8
alter Vb3 = 0.0
alter Vc0 = 0.0
op
print i(VDD) >> dc_current.txt
alter Va0 = 1.8
alter Va1 = 1.8
alter Va2 = 0.0
alter Va3 = 1.8
alter Vb0 = 1.8
alter Vb1 = 1.8
alter Vb2 = 0.0
alter Vb3 = 1.8
alter Vc0 = 1.8
op
print i(VDD) >> dc_current.txt
alter Va0 = 1.8
alter Va1 = 1.8
alter Va2 = 0.0
alter Va3 = 1.8
alter Vb0 = 1.8
alter Vb1 = 1.8
alter Vb2 = 0.0
alter Vb3 = 1.8
alter Vc0 = 0.0
op
print i(VDD) >> dc_current.txt
alter Va0 = 1.8
alter Va1 = 1.8
alter Va2 = 0.0
alter Va3 = 1.8
alter Vb0 = 1.8
alter Vb1 = 1.8
alter Vb2 = 0.0
alter Vb3 = 0.0
alter Vc0 = 1.8
op
print i(VDD) >> dc_current.txt
alter Va0 = 1.8
alter Va1 = 1.8
alter Va2 = 0.0
alter Va3 = 1.8
alter Vb0 = 1.8
alter Vb1 = 1.8
alter Vb2 = 0.0
alter Vb3 = 0.0
alter Vc0 = 0.0
op
print i(VDD) >> dc_current.txt
alter Va0 = 1.8
alter Va1 = 1.8
alter Va2 = 0.0
alter Va3 = 1.8
alter Vb0 = 1.8
alter Vb1 = 0.0
alter Vb2 = 1.8
alter Vb3 = 1.8
alter Vc0 = 1.8
op
print i(VDD) >> dc_current.txt
alter Va0 = 1.8
alter Va1 = 1.8
alter Va2 = 0.0
alter Va3 = 1.8
alter Vb0 = 1.8
alter Vb1 = 0.0
alter Vb2 = 1.8
alter Vb3 = 1.8
alter Vc0 = 0.0
op
print i(VDD) >> dc_current.txt
alter Va0 = 1.8
alter Va1 = 1.8
alter Va2 = 0.0
alter Va3 = 1.8
alter Vb0 = 1.8
alter Vb1 = 0.0
alter Vb2 = 1.8
alter Vb3 = 0.0
alter Vc0 = 1.8
op
print i(VDD) >> dc_current.txt
alter Va0 = 1.8
alter Va1 = 1.8
alter Va2 = 0.0
alter Va3 = 1.8
alter Vb0 = 1.8
alter Vb1 = 0.0
alter Vb2 = 1.8
alter Vb3 = 0.0
alter Vc0 = 0.0
op
print i(VDD) >> dc_current.txt
alter Va0 = 1.8
alter Va1 = 1.8
alter Va2 = 0.0
alter Va3 = 1.8
alter Vb0 = 1.8
alter Vb1 = 0.0
alter Vb2 = 0.0
alter Vb3 = 1.8
alter Vc0 = 1.8
op
print i(VDD) >> dc_current.txt
alter Va0 = 1.8
alter Va1 = 1.8
alter Va2 = 0.0
alter Va3 = 1.8
alter Vb0 = 1.8
alter Vb1 = 0.0
alter Vb2 = 0.0
alter Vb3 = 1.8
alter Vc0 = 0.0
op
print i(VDD) >> dc_current.txt
alter Va0 = 1.8
alter Va1 = 1.8
alter Va2 = 0.0
alter Va3 = 1.8
alter Vb0 = 1.8
alter Vb1 = 0.0
alter Vb2 = 0.0
alter Vb3 = 0.0
alter Vc0 = 1.8
op
print i(VDD) >> dc_current.txt
alter Va0 = 1.8
alter Va1 = 1.8
alter Va2 = 0.0
alter Va3 = 1.8
alter Vb0 = 1.8
alter Vb1 = 0.0
alter Vb2 = 0.0
alter Vb3 = 0.0
alter Vc0 = 0.0
op
print i(VDD) >> dc_current.txt
alter Va0 = 1.8
alter Va1 = 1.8
alter Va2 = 0.0
alter Va3 = 1.8
alter Vb0 = 0.0
alter Vb1 = 1.8
alter Vb2 = 1.8
alter Vb3 = 1.8
alter Vc0 = 1.8
op
print i(VDD) >> dc_current.txt
alter Va0 = 1.8
alter Va1 = 1.8
alter Va2 = 0.0
alter Va3 = 1.8
alter Vb0 = 0.0
alter Vb1 = 1.8
alter Vb2 = 1.8
alter Vb3 = 1.8
alter Vc0 = 0.0
op
print i(VDD) >> dc_current.txt
alter Va0 = 1.8
alter Va1 = 1.8
alter Va2 = 0.0
alter Va3 = 1.8
alter Vb0 = 0.0
alter Vb1 = 1.8
alter Vb2 = 1.8
alter Vb3 = 0.0
alter Vc0 = 1.8
op
print i(VDD) >> dc_current.txt
alter Va0 = 1.8
alter Va1 = 1.8
alter Va2 = 0.0
alter Va3 = 1.8
alter Vb0 = 0.0
alter Vb1 = 1.8
alter Vb2 = 1.8
alter Vb3 = 0.0
alter Vc0 = 0.0
op
print i(VDD) >> dc_current.txt
alter Va0 = 1.8
alter Va1 = 1.8
alter Va2 = 0.0
alter Va3 = 1.8
alter Vb0 = 0.0
alter Vb1 = 1.8
alter Vb2 = 0.0
alter Vb3 = 1.8
alter Vc0 = 1.8
op
print i(VDD) >> dc_current.txt
alter Va0 = 1.8
alter Va1 = 1.8
alter Va2 = 0.0
alter Va3 = 1.8
alter Vb0 = 0.0
alter Vb1 = 1.8
alter Vb2 = 0.0
alter Vb3 = 1.8
alter Vc0 = 0.0
op
print i(VDD) >> dc_current.txt
alter Va0 = 1.8
alter Va1 = 1.8
alter Va2 = 0.0
alter Va3 = 1.8
alter Vb0 = 0.0
alter Vb1 = 1.8
alter Vb2 = 0.0
alter Vb3 = 0.0
alter Vc0 = 1.8
op
print i(VDD) >> dc_current.txt
alter Va0 = 1.8
alter Va1 = 1.8
alter Va2 = 0.0
alter Va3 = 1.8
alter Vb0 = 0.0
alter Vb1 = 1.8
alter Vb2 = 0.0
alter Vb3 = 0.0
alter Vc0 = 0.0
op
print i(VDD) >> dc_current.txt
alter Va0 = 1.8
alter Va1 = 1.8
alter Va2 = 0.0
alter Va3 = 1.8
alter Vb0 = 0.0
alter Vb1 = 0.0
alter Vb2 = 1.8
alter Vb3 = 1.8
alter Vc0 = 1.8
op
print i(VDD) >> dc_current.txt
alter Va0 = 1.8
alter Va1 = 1.8
alter Va2 = 0.0
alter Va3 = 1.8
alter Vb0 = 0.0
alter Vb1 = 0.0
alter Vb2 = 1.8
alter Vb3 = 1.8
alter Vc0 = 0.0
op
print i(VDD) >> dc_current.txt
alter Va0 = 1.8
alter Va1 = 1.8
alter Va2 = 0.0
alter Va3 = 1.8
alter Vb0 = 0.0
alter Vb1 = 0.0
alter Vb2 = 1.8
alter Vb3 = 0.0
alter Vc0 = 1.8
op
print i(VDD) >> dc_current.txt
alter Va0 = 1.8
alter Va1 = 1.8
alter Va2 = 0.0
alter Va3 = 1.8
alter Vb0 = 0.0
alter Vb1 = 0.0
alter Vb2 = 1.8
alter Vb3 = 0.0
alter Vc0 = 0.0
op
print i(VDD) >> dc_current.txt
alter Va0 = 1.8
alter Va1 = 1.8
alter Va2 = 0.0
alter Va3 = 1.8
alter Vb0 = 0.0
alter Vb1 = 0.0
alter Vb2 = 0.0
alter Vb3 = 1.8
alter Vc0 = 1.8
op
print i(VDD) >> dc_current.txt
alter Va0 = 1.8
alter Va1 = 1.8
alter Va2 = 0.0
alter Va3 = 1.8
alter Vb0 = 0.0
alter Vb1 = 0.0
alter Vb2 = 0.0
alter Vb3 = 1.8
alter Vc0 = 0.0
op
print i(VDD) >> dc_current.txt
alter Va0 = 1.8
alter Va1 = 1.8
alter Va2 = 0.0
alter Va3 = 1.8
alter Vb0 = 0.0
alter Vb1 = 0.0
alter Vb2 = 0.0
alter Vb3 = 0.0
alter Vc0 = 1.8
op
print i(VDD) >> dc_current.txt
alter Va0 = 1.8
alter Va1 = 1.8
alter Va2 = 0.0
alter Va3 = 1.8
alter Vb0 = 0.0
alter Vb1 = 0.0
alter Vb2 = 0.0
alter Vb3 = 0.0
alter Vc0 = 0.0
op
print i(VDD) >> dc_current.txt
alter Va0 = 1.8
alter Va1 = 1.8
alter Va2 = 0.0
alter Va3 = 0.0
alter Vb0 = 1.8
alter Vb1 = 1.8
alter Vb2 = 1.8
alter Vb3 = 1.8
alter Vc0 = 1.8
op
print i(VDD) >> dc_current.txt
alter Va0 = 1.8
alter Va1 = 1.8
alter Va2 = 0.0
alter Va3 = 0.0
alter Vb0 = 1.8
alter Vb1 = 1.8
alter Vb2 = 1.8
alter Vb3 = 1.8
alter Vc0 = 0.0
op
print i(VDD) >> dc_current.txt
alter Va0 = 1.8
alter Va1 = 1.8
alter Va2 = 0.0
alter Va3 = 0.0
alter Vb0 = 1.8
alter Vb1 = 1.8
alter Vb2 = 1.8
alter Vb3 = 0.0
alter Vc0 = 1.8
op
print i(VDD) >> dc_current.txt
alter Va0 = 1.8
alter Va1 = 1.8
alter Va2 = 0.0
alter Va3 = 0.0
alter Vb0 = 1.8
alter Vb1 = 1.8
alter Vb2 = 1.8
alter Vb3 = 0.0
alter Vc0 = 0.0
op
print i(VDD) >> dc_current.txt
alter Va0 = 1.8
alter Va1 = 1.8
alter Va2 = 0.0
alter Va3 = 0.0
alter Vb0 = 1.8
alter Vb1 = 1.8
alter Vb2 = 0.0
alter Vb3 = 1.8
alter Vc0 = 1.8
op
print i(VDD) >> dc_current.txt
alter Va0 = 1.8
alter Va1 = 1.8
alter Va2 = 0.0
alter Va3 = 0.0
alter Vb0 = 1.8
alter Vb1 = 1.8
alter Vb2 = 0.0
alter Vb3 = 1.8
alter Vc0 = 0.0
op
print i(VDD) >> dc_current.txt
alter Va0 = 1.8
alter Va1 = 1.8
alter Va2 = 0.0
alter Va3 = 0.0
alter Vb0 = 1.8
alter Vb1 = 1.8
alter Vb2 = 0.0
alter Vb3 = 0.0
alter Vc0 = 1.8
op
print i(VDD) >> dc_current.txt
alter Va0 = 1.8
alter Va1 = 1.8
alter Va2 = 0.0
alter Va3 = 0.0
alter Vb0 = 1.8
alter Vb1 = 1.8
alter Vb2 = 0.0
alter Vb3 = 0.0
alter Vc0 = 0.0
op
print i(VDD) >> dc_current.txt
alter Va0 = 1.8
alter Va1 = 1.8
alter Va2 = 0.0
alter Va3 = 0.0
alter Vb0 = 1.8
alter Vb1 = 0.0
alter Vb2 = 1.8
alter Vb3 = 1.8
alter Vc0 = 1.8
op
print i(VDD) >> dc_current.txt
alter Va0 = 1.8
alter Va1 = 1.8
alter Va2 = 0.0
alter Va3 = 0.0
alter Vb0 = 1.8
alter Vb1 = 0.0
alter Vb2 = 1.8
alter Vb3 = 1.8
alter Vc0 = 0.0
op
print i(VDD) >> dc_current.txt
alter Va0 = 1.8
alter Va1 = 1.8
alter Va2 = 0.0
alter Va3 = 0.0
alter Vb0 = 1.8
alter Vb1 = 0.0
alter Vb2 = 1.8
alter Vb3 = 0.0
alter Vc0 = 1.8
op
print i(VDD) >> dc_current.txt
alter Va0 = 1.8
alter Va1 = 1.8
alter Va2 = 0.0
alter Va3 = 0.0
alter Vb0 = 1.8
alter Vb1 = 0.0
alter Vb2 = 1.8
alter Vb3 = 0.0
alter Vc0 = 0.0
op
print i(VDD) >> dc_current.txt
alter Va0 = 1.8
alter Va1 = 1.8
alter Va2 = 0.0
alter Va3 = 0.0
alter Vb0 = 1.8
alter Vb1 = 0.0
alter Vb2 = 0.0
alter Vb3 = 1.8
alter Vc0 = 1.8
op
print i(VDD) >> dc_current.txt
alter Va0 = 1.8
alter Va1 = 1.8
alter Va2 = 0.0
alter Va3 = 0.0
alter Vb0 = 1.8
alter Vb1 = 0.0
alter Vb2 = 0.0
alter Vb3 = 1.8
alter Vc0 = 0.0
op
print i(VDD) >> dc_current.txt
alter Va0 = 1.8
alter Va1 = 1.8
alter Va2 = 0.0
alter Va3 = 0.0
alter Vb0 = 1.8
alter Vb1 = 0.0
alter Vb2 = 0.0
alter Vb3 = 0.0
alter Vc0 = 1.8
op
print i(VDD) >> dc_current.txt
alter Va0 = 1.8
alter Va1 = 1.8
alter Va2 = 0.0
alter Va3 = 0.0
alter Vb0 = 1.8
alter Vb1 = 0.0
alter Vb2 = 0.0
alter Vb3 = 0.0
alter Vc0 = 0.0
op
print i(VDD) >> dc_current.txt
alter Va0 = 1.8
alter Va1 = 1.8
alter Va2 = 0.0
alter Va3 = 0.0
alter Vb0 = 0.0
alter Vb1 = 1.8
alter Vb2 = 1.8
alter Vb3 = 1.8
alter Vc0 = 1.8
op
print i(VDD) >> dc_current.txt
alter Va0 = 1.8
alter Va1 = 1.8
alter Va2 = 0.0
alter Va3 = 0.0
alter Vb0 = 0.0
alter Vb1 = 1.8
alter Vb2 = 1.8
alter Vb3 = 1.8
alter Vc0 = 0.0
op
print i(VDD) >> dc_current.txt
alter Va0 = 1.8
alter Va1 = 1.8
alter Va2 = 0.0
alter Va3 = 0.0
alter Vb0 = 0.0
alter Vb1 = 1.8
alter Vb2 = 1.8
alter Vb3 = 0.0
alter Vc0 = 1.8
op
print i(VDD) >> dc_current.txt
alter Va0 = 1.8
alter Va1 = 1.8
alter Va2 = 0.0
alter Va3 = 0.0
alter Vb0 = 0.0
alter Vb1 = 1.8
alter Vb2 = 1.8
alter Vb3 = 0.0
alter Vc0 = 0.0
op
print i(VDD) >> dc_current.txt
alter Va0 = 1.8
alter Va1 = 1.8
alter Va2 = 0.0
alter Va3 = 0.0
alter Vb0 = 0.0
alter Vb1 = 1.8
alter Vb2 = 0.0
alter Vb3 = 1.8
alter Vc0 = 1.8
op
print i(VDD) >> dc_current.txt
alter Va0 = 1.8
alter Va1 = 1.8
alter Va2 = 0.0
alter Va3 = 0.0
alter Vb0 = 0.0
alter Vb1 = 1.8
alter Vb2 = 0.0
alter Vb3 = 1.8
alter Vc0 = 0.0
op
print i(VDD) >> dc_current.txt
alter Va0 = 1.8
alter Va1 = 1.8
alter Va2 = 0.0
alter Va3 = 0.0
alter Vb0 = 0.0
alter Vb1 = 1.8
alter Vb2 = 0.0
alter Vb3 = 0.0
alter Vc0 = 1.8
op
print i(VDD) >> dc_current.txt
alter Va0 = 1.8
alter Va1 = 1.8
alter Va2 = 0.0
alter Va3 = 0.0
alter Vb0 = 0.0
alter Vb1 = 1.8
alter Vb2 = 0.0
alter Vb3 = 0.0
alter Vc0 = 0.0
op
print i(VDD) >> dc_current.txt
alter Va0 = 1.8
alter Va1 = 1.8
alter Va2 = 0.0
alter Va3 = 0.0
alter Vb0 = 0.0
alter Vb1 = 0.0
alter Vb2 = 1.8
alter Vb3 = 1.8
alter Vc0 = 1.8
op
print i(VDD) >> dc_current.txt
alter Va0 = 1.8
alter Va1 = 1.8
alter Va2 = 0.0
alter Va3 = 0.0
alter Vb0 = 0.0
alter Vb1 = 0.0
alter Vb2 = 1.8
alter Vb3 = 1.8
alter Vc0 = 0.0
op
print i(VDD) >> dc_current.txt
alter Va0 = 1.8
alter Va1 = 1.8
alter Va2 = 0.0
alter Va3 = 0.0
alter Vb0 = 0.0
alter Vb1 = 0.0
alter Vb2 = 1.8
alter Vb3 = 0.0
alter Vc0 = 1.8
op
print i(VDD) >> dc_current.txt
alter Va0 = 1.8
alter Va1 = 1.8
alter Va2 = 0.0
alter Va3 = 0.0
alter Vb0 = 0.0
alter Vb1 = 0.0
alter Vb2 = 1.8
alter Vb3 = 0.0
alter Vc0 = 0.0
op
print i(VDD) >> dc_current.txt
alter Va0 = 1.8
alter Va1 = 1.8
alter Va2 = 0.0
alter Va3 = 0.0
alter Vb0 = 0.0
alter Vb1 = 0.0
alter Vb2 = 0.0
alter Vb3 = 1.8
alter Vc0 = 1.8
op
print i(VDD) >> dc_current.txt
alter Va0 = 1.8
alter Va1 = 1.8
alter Va2 = 0.0
alter Va3 = 0.0
alter Vb0 = 0.0
alter Vb1 = 0.0
alter Vb2 = 0.0
alter Vb3 = 1.8
alter Vc0 = 0.0
op
print i(VDD) >> dc_current.txt
alter Va0 = 1.8
alter Va1 = 1.8
alter Va2 = 0.0
alter Va3 = 0.0
alter Vb0 = 0.0
alter Vb1 = 0.0
alter Vb2 = 0.0
alter Vb3 = 0.0
alter Vc0 = 1.8
op
print i(VDD) >> dc_current.txt
alter Va0 = 1.8
alter Va1 = 1.8
alter Va2 = 0.0
alter Va3 = 0.0
alter Vb0 = 0.0
alter Vb1 = 0.0
alter Vb2 = 0.0
alter Vb3 = 0.0
alter Vc0 = 0.0
op
print i(VDD) >> dc_current.txt
alter Va0 = 1.8
alter Va1 = 0.0
alter Va2 = 1.8
alter Va3 = 1.8
alter Vb0 = 1.8
alter Vb1 = 1.8
alter Vb2 = 1.8
alter Vb3 = 1.8
alter Vc0 = 1.8
op
print i(VDD) >> dc_current.txt
alter Va0 = 1.8
alter Va1 = 0.0
alter Va2 = 1.8
alter Va3 = 1.8
alter Vb0 = 1.8
alter Vb1 = 1.8
alter Vb2 = 1.8
alter Vb3 = 1.8
alter Vc0 = 0.0
op
print i(VDD) >> dc_current.txt
alter Va0 = 1.8
alter Va1 = 0.0
alter Va2 = 1.8
alter Va3 = 1.8
alter Vb0 = 1.8
alter Vb1 = 1.8
alter Vb2 = 1.8
alter Vb3 = 0.0
alter Vc0 = 1.8
op
print i(VDD) >> dc_current.txt
alter Va0 = 1.8
alter Va1 = 0.0
alter Va2 = 1.8
alter Va3 = 1.8
alter Vb0 = 1.8
alter Vb1 = 1.8
alter Vb2 = 1.8
alter Vb3 = 0.0
alter Vc0 = 0.0
op
print i(VDD) >> dc_current.txt
alter Va0 = 1.8
alter Va1 = 0.0
alter Va2 = 1.8
alter Va3 = 1.8
alter Vb0 = 1.8
alter Vb1 = 1.8
alter Vb2 = 0.0
alter Vb3 = 1.8
alter Vc0 = 1.8
op
print i(VDD) >> dc_current.txt
alter Va0 = 1.8
alter Va1 = 0.0
alter Va2 = 1.8
alter Va3 = 1.8
alter Vb0 = 1.8
alter Vb1 = 1.8
alter Vb2 = 0.0
alter Vb3 = 1.8
alter Vc0 = 0.0
op
print i(VDD) >> dc_current.txt
alter Va0 = 1.8
alter Va1 = 0.0
alter Va2 = 1.8
alter Va3 = 1.8
alter Vb0 = 1.8
alter Vb1 = 1.8
alter Vb2 = 0.0
alter Vb3 = 0.0
alter Vc0 = 1.8
op
print i(VDD) >> dc_current.txt
alter Va0 = 1.8
alter Va1 = 0.0
alter Va2 = 1.8
alter Va3 = 1.8
alter Vb0 = 1.8
alter Vb1 = 1.8
alter Vb2 = 0.0
alter Vb3 = 0.0
alter Vc0 = 0.0
op
print i(VDD) >> dc_current.txt
alter Va0 = 1.8
alter Va1 = 0.0
alter Va2 = 1.8
alter Va3 = 1.8
alter Vb0 = 1.8
alter Vb1 = 0.0
alter Vb2 = 1.8
alter Vb3 = 1.8
alter Vc0 = 1.8
op
print i(VDD) >> dc_current.txt
alter Va0 = 1.8
alter Va1 = 0.0
alter Va2 = 1.8
alter Va3 = 1.8
alter Vb0 = 1.8
alter Vb1 = 0.0
alter Vb2 = 1.8
alter Vb3 = 1.8
alter Vc0 = 0.0
op
print i(VDD) >> dc_current.txt
alter Va0 = 1.8
alter Va1 = 0.0
alter Va2 = 1.8
alter Va3 = 1.8
alter Vb0 = 1.8
alter Vb1 = 0.0
alter Vb2 = 1.8
alter Vb3 = 0.0
alter Vc0 = 1.8
op
print i(VDD) >> dc_current.txt
alter Va0 = 1.8
alter Va1 = 0.0
alter Va2 = 1.8
alter Va3 = 1.8
alter Vb0 = 1.8
alter Vb1 = 0.0
alter Vb2 = 1.8
alter Vb3 = 0.0
alter Vc0 = 0.0
op
print i(VDD) >> dc_current.txt
alter Va0 = 1.8
alter Va1 = 0.0
alter Va2 = 1.8
alter Va3 = 1.8
alter Vb0 = 1.8
alter Vb1 = 0.0
alter Vb2 = 0.0
alter Vb3 = 1.8
alter Vc0 = 1.8
op
print i(VDD) >> dc_current.txt
alter Va0 = 1.8
alter Va1 = 0.0
alter Va2 = 1.8
alter Va3 = 1.8
alter Vb0 = 1.8
alter Vb1 = 0.0
alter Vb2 = 0.0
alter Vb3 = 1.8
alter Vc0 = 0.0
op
print i(VDD) >> dc_current.txt
alter Va0 = 1.8
alter Va1 = 0.0
alter Va2 = 1.8
alter Va3 = 1.8
alter Vb0 = 1.8
alter Vb1 = 0.0
alter Vb2 = 0.0
alter Vb3 = 0.0
alter Vc0 = 1.8
op
print i(VDD) >> dc_current.txt
alter Va0 = 1.8
alter Va1 = 0.0
alter Va2 = 1.8
alter Va3 = 1.8
alter Vb0 = 1.8
alter Vb1 = 0.0
alter Vb2 = 0.0
alter Vb3 = 0.0
alter Vc0 = 0.0
op
print i(VDD) >> dc_current.txt
alter Va0 = 1.8
alter Va1 = 0.0
alter Va2 = 1.8
alter Va3 = 1.8
alter Vb0 = 0.0
alter Vb1 = 1.8
alter Vb2 = 1.8
alter Vb3 = 1.8
alter Vc0 = 1.8
op
print i(VDD) >> dc_current.txt
alter Va0 = 1.8
alter Va1 = 0.0
alter Va2 = 1.8
alter Va3 = 1.8
alter Vb0 = 0.0
alter Vb1 = 1.8
alter Vb2 = 1.8
alter Vb3 = 1.8
alter Vc0 = 0.0
op
print i(VDD) >> dc_current.txt
alter Va0 = 1.8
alter Va1 = 0.0
alter Va2 = 1.8
alter Va3 = 1.8
alter Vb0 = 0.0
alter Vb1 = 1.8
alter Vb2 = 1.8
alter Vb3 = 0.0
alter Vc0 = 1.8
op
print i(VDD) >> dc_current.txt
alter Va0 = 1.8
alter Va1 = 0.0
alter Va2 = 1.8
alter Va3 = 1.8
alter Vb0 = 0.0
alter Vb1 = 1.8
alter Vb2 = 1.8
alter Vb3 = 0.0
alter Vc0 = 0.0
op
print i(VDD) >> dc_current.txt
alter Va0 = 1.8
alter Va1 = 0.0
alter Va2 = 1.8
alter Va3 = 1.8
alter Vb0 = 0.0
alter Vb1 = 1.8
alter Vb2 = 0.0
alter Vb3 = 1.8
alter Vc0 = 1.8
op
print i(VDD) >> dc_current.txt
alter Va0 = 1.8
alter Va1 = 0.0
alter Va2 = 1.8
alter Va3 = 1.8
alter Vb0 = 0.0
alter Vb1 = 1.8
alter Vb2 = 0.0
alter Vb3 = 1.8
alter Vc0 = 0.0
op
print i(VDD) >> dc_current.txt
alter Va0 = 1.8
alter Va1 = 0.0
alter Va2 = 1.8
alter Va3 = 1.8
alter Vb0 = 0.0
alter Vb1 = 1.8
alter Vb2 = 0.0
alter Vb3 = 0.0
alter Vc0 = 1.8
op
print i(VDD) >> dc_current.txt
alter Va0 = 1.8
alter Va1 = 0.0
alter Va2 = 1.8
alter Va3 = 1.8
alter Vb0 = 0.0
alter Vb1 = 1.8
alter Vb2 = 0.0
alter Vb3 = 0.0
alter Vc0 = 0.0
op
print i(VDD) >> dc_current.txt
alter Va0 = 1.8
alter Va1 = 0.0
alter Va2 = 1.8
alter Va3 = 1.8
alter Vb0 = 0.0
alter Vb1 = 0.0
alter Vb2 = 1.8
alter Vb3 = 1.8
alter Vc0 = 1.8
op
print i(VDD) >> dc_current.txt
alter Va0 = 1.8
alter Va1 = 0.0
alter Va2 = 1.8
alter Va3 = 1.8
alter Vb0 = 0.0
alter Vb1 = 0.0
alter Vb2 = 1.8
alter Vb3 = 1.8
alter Vc0 = 0.0
op
print i(VDD) >> dc_current.txt
alter Va0 = 1.8
alter Va1 = 0.0
alter Va2 = 1.8
alter Va3 = 1.8
alter Vb0 = 0.0
alter Vb1 = 0.0
alter Vb2 = 1.8
alter Vb3 = 0.0
alter Vc0 = 1.8
op
print i(VDD) >> dc_current.txt
alter Va0 = 1.8
alter Va1 = 0.0
alter Va2 = 1.8
alter Va3 = 1.8
alter Vb0 = 0.0
alter Vb1 = 0.0
alter Vb2 = 1.8
alter Vb3 = 0.0
alter Vc0 = 0.0
op
print i(VDD) >> dc_current.txt
alter Va0 = 1.8
alter Va1 = 0.0
alter Va2 = 1.8
alter Va3 = 1.8
alter Vb0 = 0.0
alter Vb1 = 0.0
alter Vb2 = 0.0
alter Vb3 = 1.8
alter Vc0 = 1.8
op
print i(VDD) >> dc_current.txt
alter Va0 = 1.8
alter Va1 = 0.0
alter Va2 = 1.8
alter Va3 = 1.8
alter Vb0 = 0.0
alter Vb1 = 0.0
alter Vb2 = 0.0
alter Vb3 = 1.8
alter Vc0 = 0.0
op
print i(VDD) >> dc_current.txt
alter Va0 = 1.8
alter Va1 = 0.0
alter Va2 = 1.8
alter Va3 = 1.8
alter Vb0 = 0.0
alter Vb1 = 0.0
alter Vb2 = 0.0
alter Vb3 = 0.0
alter Vc0 = 1.8
op
print i(VDD) >> dc_current.txt
alter Va0 = 1.8
alter Va1 = 0.0
alter Va2 = 1.8
alter Va3 = 1.8
alter Vb0 = 0.0
alter Vb1 = 0.0
alter Vb2 = 0.0
alter Vb3 = 0.0
alter Vc0 = 0.0
op
print i(VDD) >> dc_current.txt
alter Va0 = 1.8
alter Va1 = 0.0
alter Va2 = 1.8
alter Va3 = 0.0
alter Vb0 = 1.8
alter Vb1 = 1.8
alter Vb2 = 1.8
alter Vb3 = 1.8
alter Vc0 = 1.8
op
print i(VDD) >> dc_current.txt
alter Va0 = 1.8
alter Va1 = 0.0
alter Va2 = 1.8
alter Va3 = 0.0
alter Vb0 = 1.8
alter Vb1 = 1.8
alter Vb2 = 1.8
alter Vb3 = 1.8
alter Vc0 = 0.0
op
print i(VDD) >> dc_current.txt
alter Va0 = 1.8
alter Va1 = 0.0
alter Va2 = 1.8
alter Va3 = 0.0
alter Vb0 = 1.8
alter Vb1 = 1.8
alter Vb2 = 1.8
alter Vb3 = 0.0
alter Vc0 = 1.8
op
print i(VDD) >> dc_current.txt
alter Va0 = 1.8
alter Va1 = 0.0
alter Va2 = 1.8
alter Va3 = 0.0
alter Vb0 = 1.8
alter Vb1 = 1.8
alter Vb2 = 1.8
alter Vb3 = 0.0
alter Vc0 = 0.0
op
print i(VDD) >> dc_current.txt
alter Va0 = 1.8
alter Va1 = 0.0
alter Va2 = 1.8
alter Va3 = 0.0
alter Vb0 = 1.8
alter Vb1 = 1.8
alter Vb2 = 0.0
alter Vb3 = 1.8
alter Vc0 = 1.8
op
print i(VDD) >> dc_current.txt
alter Va0 = 1.8
alter Va1 = 0.0
alter Va2 = 1.8
alter Va3 = 0.0
alter Vb0 = 1.8
alter Vb1 = 1.8
alter Vb2 = 0.0
alter Vb3 = 1.8
alter Vc0 = 0.0
op
print i(VDD) >> dc_current.txt
alter Va0 = 1.8
alter Va1 = 0.0
alter Va2 = 1.8
alter Va3 = 0.0
alter Vb0 = 1.8
alter Vb1 = 1.8
alter Vb2 = 0.0
alter Vb3 = 0.0
alter Vc0 = 1.8
op
print i(VDD) >> dc_current.txt
alter Va0 = 1.8
alter Va1 = 0.0
alter Va2 = 1.8
alter Va3 = 0.0
alter Vb0 = 1.8
alter Vb1 = 1.8
alter Vb2 = 0.0
alter Vb3 = 0.0
alter Vc0 = 0.0
op
print i(VDD) >> dc_current.txt
alter Va0 = 1.8
alter Va1 = 0.0
alter Va2 = 1.8
alter Va3 = 0.0
alter Vb0 = 1.8
alter Vb1 = 0.0
alter Vb2 = 1.8
alter Vb3 = 1.8
alter Vc0 = 1.8
op
print i(VDD) >> dc_current.txt
alter Va0 = 1.8
alter Va1 = 0.0
alter Va2 = 1.8
alter Va3 = 0.0
alter Vb0 = 1.8
alter Vb1 = 0.0
alter Vb2 = 1.8
alter Vb3 = 1.8
alter Vc0 = 0.0
op
print i(VDD) >> dc_current.txt
alter Va0 = 1.8
alter Va1 = 0.0
alter Va2 = 1.8
alter Va3 = 0.0
alter Vb0 = 1.8
alter Vb1 = 0.0
alter Vb2 = 1.8
alter Vb3 = 0.0
alter Vc0 = 1.8
op
print i(VDD) >> dc_current.txt
alter Va0 = 1.8
alter Va1 = 0.0
alter Va2 = 1.8
alter Va3 = 0.0
alter Vb0 = 1.8
alter Vb1 = 0.0
alter Vb2 = 1.8
alter Vb3 = 0.0
alter Vc0 = 0.0
op
print i(VDD) >> dc_current.txt
alter Va0 = 1.8
alter Va1 = 0.0
alter Va2 = 1.8
alter Va3 = 0.0
alter Vb0 = 1.8
alter Vb1 = 0.0
alter Vb2 = 0.0
alter Vb3 = 1.8
alter Vc0 = 1.8
op
print i(VDD) >> dc_current.txt
alter Va0 = 1.8
alter Va1 = 0.0
alter Va2 = 1.8
alter Va3 = 0.0
alter Vb0 = 1.8
alter Vb1 = 0.0
alter Vb2 = 0.0
alter Vb3 = 1.8
alter Vc0 = 0.0
op
print i(VDD) >> dc_current.txt
alter Va0 = 1.8
alter Va1 = 0.0
alter Va2 = 1.8
alter Va3 = 0.0
alter Vb0 = 1.8
alter Vb1 = 0.0
alter Vb2 = 0.0
alter Vb3 = 0.0
alter Vc0 = 1.8
op
print i(VDD) >> dc_current.txt
alter Va0 = 1.8
alter Va1 = 0.0
alter Va2 = 1.8
alter Va3 = 0.0
alter Vb0 = 1.8
alter Vb1 = 0.0
alter Vb2 = 0.0
alter Vb3 = 0.0
alter Vc0 = 0.0
op
print i(VDD) >> dc_current.txt
alter Va0 = 1.8
alter Va1 = 0.0
alter Va2 = 1.8
alter Va3 = 0.0
alter Vb0 = 0.0
alter Vb1 = 1.8
alter Vb2 = 1.8
alter Vb3 = 1.8
alter Vc0 = 1.8
op
print i(VDD) >> dc_current.txt
alter Va0 = 1.8
alter Va1 = 0.0
alter Va2 = 1.8
alter Va3 = 0.0
alter Vb0 = 0.0
alter Vb1 = 1.8
alter Vb2 = 1.8
alter Vb3 = 1.8
alter Vc0 = 0.0
op
print i(VDD) >> dc_current.txt
alter Va0 = 1.8
alter Va1 = 0.0
alter Va2 = 1.8
alter Va3 = 0.0
alter Vb0 = 0.0
alter Vb1 = 1.8
alter Vb2 = 1.8
alter Vb3 = 0.0
alter Vc0 = 1.8
op
print i(VDD) >> dc_current.txt
alter Va0 = 1.8
alter Va1 = 0.0
alter Va2 = 1.8
alter Va3 = 0.0
alter Vb0 = 0.0
alter Vb1 = 1.8
alter Vb2 = 1.8
alter Vb3 = 0.0
alter Vc0 = 0.0
op
print i(VDD) >> dc_current.txt
alter Va0 = 1.8
alter Va1 = 0.0
alter Va2 = 1.8
alter Va3 = 0.0
alter Vb0 = 0.0
alter Vb1 = 1.8
alter Vb2 = 0.0
alter Vb3 = 1.8
alter Vc0 = 1.8
op
print i(VDD) >> dc_current.txt
alter Va0 = 1.8
alter Va1 = 0.0
alter Va2 = 1.8
alter Va3 = 0.0
alter Vb0 = 0.0
alter Vb1 = 1.8
alter Vb2 = 0.0
alter Vb3 = 1.8
alter Vc0 = 0.0
op
print i(VDD) >> dc_current.txt
alter Va0 = 1.8
alter Va1 = 0.0
alter Va2 = 1.8
alter Va3 = 0.0
alter Vb0 = 0.0
alter Vb1 = 1.8
alter Vb2 = 0.0
alter Vb3 = 0.0
alter Vc0 = 1.8
op
print i(VDD) >> dc_current.txt
alter Va0 = 1.8
alter Va1 = 0.0
alter Va2 = 1.8
alter Va3 = 0.0
alter Vb0 = 0.0
alter Vb1 = 1.8
alter Vb2 = 0.0
alter Vb3 = 0.0
alter Vc0 = 0.0
op
print i(VDD) >> dc_current.txt
alter Va0 = 1.8
alter Va1 = 0.0
alter Va2 = 1.8
alter Va3 = 0.0
alter Vb0 = 0.0
alter Vb1 = 0.0
alter Vb2 = 1.8
alter Vb3 = 1.8
alter Vc0 = 1.8
op
print i(VDD) >> dc_current.txt
alter Va0 = 1.8
alter Va1 = 0.0
alter Va2 = 1.8
alter Va3 = 0.0
alter Vb0 = 0.0
alter Vb1 = 0.0
alter Vb2 = 1.8
alter Vb3 = 1.8
alter Vc0 = 0.0
op
print i(VDD) >> dc_current.txt
alter Va0 = 1.8
alter Va1 = 0.0
alter Va2 = 1.8
alter Va3 = 0.0
alter Vb0 = 0.0
alter Vb1 = 0.0
alter Vb2 = 1.8
alter Vb3 = 0.0
alter Vc0 = 1.8
op
print i(VDD) >> dc_current.txt
alter Va0 = 1.8
alter Va1 = 0.0
alter Va2 = 1.8
alter Va3 = 0.0
alter Vb0 = 0.0
alter Vb1 = 0.0
alter Vb2 = 1.8
alter Vb3 = 0.0
alter Vc0 = 0.0
op
print i(VDD) >> dc_current.txt
alter Va0 = 1.8
alter Va1 = 0.0
alter Va2 = 1.8
alter Va3 = 0.0
alter Vb0 = 0.0
alter Vb1 = 0.0
alter Vb2 = 0.0
alter Vb3 = 1.8
alter Vc0 = 1.8
op
print i(VDD) >> dc_current.txt
alter Va0 = 1.8
alter Va1 = 0.0
alter Va2 = 1.8
alter Va3 = 0.0
alter Vb0 = 0.0
alter Vb1 = 0.0
alter Vb2 = 0.0
alter Vb3 = 1.8
alter Vc0 = 0.0
op
print i(VDD) >> dc_current.txt
alter Va0 = 1.8
alter Va1 = 0.0
alter Va2 = 1.8
alter Va3 = 0.0
alter Vb0 = 0.0
alter Vb1 = 0.0
alter Vb2 = 0.0
alter Vb3 = 0.0
alter Vc0 = 1.8
op
print i(VDD) >> dc_current.txt
alter Va0 = 1.8
alter Va1 = 0.0
alter Va2 = 1.8
alter Va3 = 0.0
alter Vb0 = 0.0
alter Vb1 = 0.0
alter Vb2 = 0.0
alter Vb3 = 0.0
alter Vc0 = 0.0
op
print i(VDD) >> dc_current.txt
alter Va0 = 1.8
alter Va1 = 0.0
alter Va2 = 0.0
alter Va3 = 1.8
alter Vb0 = 1.8
alter Vb1 = 1.8
alter Vb2 = 1.8
alter Vb3 = 1.8
alter Vc0 = 1.8
op
print i(VDD) >> dc_current.txt
alter Va0 = 1.8
alter Va1 = 0.0
alter Va2 = 0.0
alter Va3 = 1.8
alter Vb0 = 1.8
alter Vb1 = 1.8
alter Vb2 = 1.8
alter Vb3 = 1.8
alter Vc0 = 0.0
op
print i(VDD) >> dc_current.txt
alter Va0 = 1.8
alter Va1 = 0.0
alter Va2 = 0.0
alter Va3 = 1.8
alter Vb0 = 1.8
alter Vb1 = 1.8
alter Vb2 = 1.8
alter Vb3 = 0.0
alter Vc0 = 1.8
op
print i(VDD) >> dc_current.txt
alter Va0 = 1.8
alter Va1 = 0.0
alter Va2 = 0.0
alter Va3 = 1.8
alter Vb0 = 1.8
alter Vb1 = 1.8
alter Vb2 = 1.8
alter Vb3 = 0.0
alter Vc0 = 0.0
op
print i(VDD) >> dc_current.txt
alter Va0 = 1.8
alter Va1 = 0.0
alter Va2 = 0.0
alter Va3 = 1.8
alter Vb0 = 1.8
alter Vb1 = 1.8
alter Vb2 = 0.0
alter Vb3 = 1.8
alter Vc0 = 1.8
op
print i(VDD) >> dc_current.txt
alter Va0 = 1.8
alter Va1 = 0.0
alter Va2 = 0.0
alter Va3 = 1.8
alter Vb0 = 1.8
alter Vb1 = 1.8
alter Vb2 = 0.0
alter Vb3 = 1.8
alter Vc0 = 0.0
op
print i(VDD) >> dc_current.txt
alter Va0 = 1.8
alter Va1 = 0.0
alter Va2 = 0.0
alter Va3 = 1.8
alter Vb0 = 1.8
alter Vb1 = 1.8
alter Vb2 = 0.0
alter Vb3 = 0.0
alter Vc0 = 1.8
op
print i(VDD) >> dc_current.txt
alter Va0 = 1.8
alter Va1 = 0.0
alter Va2 = 0.0
alter Va3 = 1.8
alter Vb0 = 1.8
alter Vb1 = 1.8
alter Vb2 = 0.0
alter Vb3 = 0.0
alter Vc0 = 0.0
op
print i(VDD) >> dc_current.txt
alter Va0 = 1.8
alter Va1 = 0.0
alter Va2 = 0.0
alter Va3 = 1.8
alter Vb0 = 1.8
alter Vb1 = 0.0
alter Vb2 = 1.8
alter Vb3 = 1.8
alter Vc0 = 1.8
op
print i(VDD) >> dc_current.txt
alter Va0 = 1.8
alter Va1 = 0.0
alter Va2 = 0.0
alter Va3 = 1.8
alter Vb0 = 1.8
alter Vb1 = 0.0
alter Vb2 = 1.8
alter Vb3 = 1.8
alter Vc0 = 0.0
op
print i(VDD) >> dc_current.txt
alter Va0 = 1.8
alter Va1 = 0.0
alter Va2 = 0.0
alter Va3 = 1.8
alter Vb0 = 1.8
alter Vb1 = 0.0
alter Vb2 = 1.8
alter Vb3 = 0.0
alter Vc0 = 1.8
op
print i(VDD) >> dc_current.txt
alter Va0 = 1.8
alter Va1 = 0.0
alter Va2 = 0.0
alter Va3 = 1.8
alter Vb0 = 1.8
alter Vb1 = 0.0
alter Vb2 = 1.8
alter Vb3 = 0.0
alter Vc0 = 0.0
op
print i(VDD) >> dc_current.txt
alter Va0 = 1.8
alter Va1 = 0.0
alter Va2 = 0.0
alter Va3 = 1.8
alter Vb0 = 1.8
alter Vb1 = 0.0
alter Vb2 = 0.0
alter Vb3 = 1.8
alter Vc0 = 1.8
op
print i(VDD) >> dc_current.txt
alter Va0 = 1.8
alter Va1 = 0.0
alter Va2 = 0.0
alter Va3 = 1.8
alter Vb0 = 1.8
alter Vb1 = 0.0
alter Vb2 = 0.0
alter Vb3 = 1.8
alter Vc0 = 0.0
op
print i(VDD) >> dc_current.txt
alter Va0 = 1.8
alter Va1 = 0.0
alter Va2 = 0.0
alter Va3 = 1.8
alter Vb0 = 1.8
alter Vb1 = 0.0
alter Vb2 = 0.0
alter Vb3 = 0.0
alter Vc0 = 1.8
op
print i(VDD) >> dc_current.txt
alter Va0 = 1.8
alter Va1 = 0.0
alter Va2 = 0.0
alter Va3 = 1.8
alter Vb0 = 1.8
alter Vb1 = 0.0
alter Vb2 = 0.0
alter Vb3 = 0.0
alter Vc0 = 0.0
op
print i(VDD) >> dc_current.txt
alter Va0 = 1.8
alter Va1 = 0.0
alter Va2 = 0.0
alter Va3 = 1.8
alter Vb0 = 0.0
alter Vb1 = 1.8
alter Vb2 = 1.8
alter Vb3 = 1.8
alter Vc0 = 1.8
op
print i(VDD) >> dc_current.txt
alter Va0 = 1.8
alter Va1 = 0.0
alter Va2 = 0.0
alter Va3 = 1.8
alter Vb0 = 0.0
alter Vb1 = 1.8
alter Vb2 = 1.8
alter Vb3 = 1.8
alter Vc0 = 0.0
op
print i(VDD) >> dc_current.txt
alter Va0 = 1.8
alter Va1 = 0.0
alter Va2 = 0.0
alter Va3 = 1.8
alter Vb0 = 0.0
alter Vb1 = 1.8
alter Vb2 = 1.8
alter Vb3 = 0.0
alter Vc0 = 1.8
op
print i(VDD) >> dc_current.txt
alter Va0 = 1.8
alter Va1 = 0.0
alter Va2 = 0.0
alter Va3 = 1.8
alter Vb0 = 0.0
alter Vb1 = 1.8
alter Vb2 = 1.8
alter Vb3 = 0.0
alter Vc0 = 0.0
op
print i(VDD) >> dc_current.txt
alter Va0 = 1.8
alter Va1 = 0.0
alter Va2 = 0.0
alter Va3 = 1.8
alter Vb0 = 0.0
alter Vb1 = 1.8
alter Vb2 = 0.0
alter Vb3 = 1.8
alter Vc0 = 1.8
op
print i(VDD) >> dc_current.txt
alter Va0 = 1.8
alter Va1 = 0.0
alter Va2 = 0.0
alter Va3 = 1.8
alter Vb0 = 0.0
alter Vb1 = 1.8
alter Vb2 = 0.0
alter Vb3 = 1.8
alter Vc0 = 0.0
op
print i(VDD) >> dc_current.txt
alter Va0 = 1.8
alter Va1 = 0.0
alter Va2 = 0.0
alter Va3 = 1.8
alter Vb0 = 0.0
alter Vb1 = 1.8
alter Vb2 = 0.0
alter Vb3 = 0.0
alter Vc0 = 1.8
op
print i(VDD) >> dc_current.txt
alter Va0 = 1.8
alter Va1 = 0.0
alter Va2 = 0.0
alter Va3 = 1.8
alter Vb0 = 0.0
alter Vb1 = 1.8
alter Vb2 = 0.0
alter Vb3 = 0.0
alter Vc0 = 0.0
op
print i(VDD) >> dc_current.txt
alter Va0 = 1.8
alter Va1 = 0.0
alter Va2 = 0.0
alter Va3 = 1.8
alter Vb0 = 0.0
alter Vb1 = 0.0
alter Vb2 = 1.8
alter Vb3 = 1.8
alter Vc0 = 1.8
op
print i(VDD) >> dc_current.txt
alter Va0 = 1.8
alter Va1 = 0.0
alter Va2 = 0.0
alter Va3 = 1.8
alter Vb0 = 0.0
alter Vb1 = 0.0
alter Vb2 = 1.8
alter Vb3 = 1.8
alter Vc0 = 0.0
op
print i(VDD) >> dc_current.txt
alter Va0 = 1.8
alter Va1 = 0.0
alter Va2 = 0.0
alter Va3 = 1.8
alter Vb0 = 0.0
alter Vb1 = 0.0
alter Vb2 = 1.8
alter Vb3 = 0.0
alter Vc0 = 1.8
op
print i(VDD) >> dc_current.txt
alter Va0 = 1.8
alter Va1 = 0.0
alter Va2 = 0.0
alter Va3 = 1.8
alter Vb0 = 0.0
alter Vb1 = 0.0
alter Vb2 = 1.8
alter Vb3 = 0.0
alter Vc0 = 0.0
op
print i(VDD) >> dc_current.txt
alter Va0 = 1.8
alter Va1 = 0.0
alter Va2 = 0.0
alter Va3 = 1.8
alter Vb0 = 0.0
alter Vb1 = 0.0
alter Vb2 = 0.0
alter Vb3 = 1.8
alter Vc0 = 1.8
op
print i(VDD) >> dc_current.txt
alter Va0 = 1.8
alter Va1 = 0.0
alter Va2 = 0.0
alter Va3 = 1.8
alter Vb0 = 0.0
alter Vb1 = 0.0
alter Vb2 = 0.0
alter Vb3 = 1.8
alter Vc0 = 0.0
op
print i(VDD) >> dc_current.txt
alter Va0 = 1.8
alter Va1 = 0.0
alter Va2 = 0.0
alter Va3 = 1.8
alter Vb0 = 0.0
alter Vb1 = 0.0
alter Vb2 = 0.0
alter Vb3 = 0.0
alter Vc0 = 1.8
op
print i(VDD) >> dc_current.txt
alter Va0 = 1.8
alter Va1 = 0.0
alter Va2 = 0.0
alter Va3 = 1.8
alter Vb0 = 0.0
alter Vb1 = 0.0
alter Vb2 = 0.0
alter Vb3 = 0.0
alter Vc0 = 0.0
op
print i(VDD) >> dc_current.txt
alter Va0 = 1.8
alter Va1 = 0.0
alter Va2 = 0.0
alter Va3 = 0.0
alter Vb0 = 1.8
alter Vb1 = 1.8
alter Vb2 = 1.8
alter Vb3 = 1.8
alter Vc0 = 1.8
op
print i(VDD) >> dc_current.txt
alter Va0 = 1.8
alter Va1 = 0.0
alter Va2 = 0.0
alter Va3 = 0.0
alter Vb0 = 1.8
alter Vb1 = 1.8
alter Vb2 = 1.8
alter Vb3 = 1.8
alter Vc0 = 0.0
op
print i(VDD) >> dc_current.txt
alter Va0 = 1.8
alter Va1 = 0.0
alter Va2 = 0.0
alter Va3 = 0.0
alter Vb0 = 1.8
alter Vb1 = 1.8
alter Vb2 = 1.8
alter Vb3 = 0.0
alter Vc0 = 1.8
op
print i(VDD) >> dc_current.txt
alter Va0 = 1.8
alter Va1 = 0.0
alter Va2 = 0.0
alter Va3 = 0.0
alter Vb0 = 1.8
alter Vb1 = 1.8
alter Vb2 = 1.8
alter Vb3 = 0.0
alter Vc0 = 0.0
op
print i(VDD) >> dc_current.txt
alter Va0 = 1.8
alter Va1 = 0.0
alter Va2 = 0.0
alter Va3 = 0.0
alter Vb0 = 1.8
alter Vb1 = 1.8
alter Vb2 = 0.0
alter Vb3 = 1.8
alter Vc0 = 1.8
op
print i(VDD) >> dc_current.txt
alter Va0 = 1.8
alter Va1 = 0.0
alter Va2 = 0.0
alter Va3 = 0.0
alter Vb0 = 1.8
alter Vb1 = 1.8
alter Vb2 = 0.0
alter Vb3 = 1.8
alter Vc0 = 0.0
op
print i(VDD) >> dc_current.txt
alter Va0 = 1.8
alter Va1 = 0.0
alter Va2 = 0.0
alter Va3 = 0.0
alter Vb0 = 1.8
alter Vb1 = 1.8
alter Vb2 = 0.0
alter Vb3 = 0.0
alter Vc0 = 1.8
op
print i(VDD) >> dc_current.txt
alter Va0 = 1.8
alter Va1 = 0.0
alter Va2 = 0.0
alter Va3 = 0.0
alter Vb0 = 1.8
alter Vb1 = 1.8
alter Vb2 = 0.0
alter Vb3 = 0.0
alter Vc0 = 0.0
op
print i(VDD) >> dc_current.txt
alter Va0 = 1.8
alter Va1 = 0.0
alter Va2 = 0.0
alter Va3 = 0.0
alter Vb0 = 1.8
alter Vb1 = 0.0
alter Vb2 = 1.8
alter Vb3 = 1.8
alter Vc0 = 1.8
op
print i(VDD) >> dc_current.txt
alter Va0 = 1.8
alter Va1 = 0.0
alter Va2 = 0.0
alter Va3 = 0.0
alter Vb0 = 1.8
alter Vb1 = 0.0
alter Vb2 = 1.8
alter Vb3 = 1.8
alter Vc0 = 0.0
op
print i(VDD) >> dc_current.txt
alter Va0 = 1.8
alter Va1 = 0.0
alter Va2 = 0.0
alter Va3 = 0.0
alter Vb0 = 1.8
alter Vb1 = 0.0
alter Vb2 = 1.8
alter Vb3 = 0.0
alter Vc0 = 1.8
op
print i(VDD) >> dc_current.txt
alter Va0 = 1.8
alter Va1 = 0.0
alter Va2 = 0.0
alter Va3 = 0.0
alter Vb0 = 1.8
alter Vb1 = 0.0
alter Vb2 = 1.8
alter Vb3 = 0.0
alter Vc0 = 0.0
op
print i(VDD) >> dc_current.txt
alter Va0 = 1.8
alter Va1 = 0.0
alter Va2 = 0.0
alter Va3 = 0.0
alter Vb0 = 1.8
alter Vb1 = 0.0
alter Vb2 = 0.0
alter Vb3 = 1.8
alter Vc0 = 1.8
op
print i(VDD) >> dc_current.txt
alter Va0 = 1.8
alter Va1 = 0.0
alter Va2 = 0.0
alter Va3 = 0.0
alter Vb0 = 1.8
alter Vb1 = 0.0
alter Vb2 = 0.0
alter Vb3 = 1.8
alter Vc0 = 0.0
op
print i(VDD) >> dc_current.txt
alter Va0 = 1.8
alter Va1 = 0.0
alter Va2 = 0.0
alter Va3 = 0.0
alter Vb0 = 1.8
alter Vb1 = 0.0
alter Vb2 = 0.0
alter Vb3 = 0.0
alter Vc0 = 1.8
op
print i(VDD) >> dc_current.txt
alter Va0 = 1.8
alter Va1 = 0.0
alter Va2 = 0.0
alter Va3 = 0.0
alter Vb0 = 1.8
alter Vb1 = 0.0
alter Vb2 = 0.0
alter Vb3 = 0.0
alter Vc0 = 0.0
op
print i(VDD) >> dc_current.txt
alter Va0 = 1.8
alter Va1 = 0.0
alter Va2 = 0.0
alter Va3 = 0.0
alter Vb0 = 0.0
alter Vb1 = 1.8
alter Vb2 = 1.8
alter Vb3 = 1.8
alter Vc0 = 1.8
op
print i(VDD) >> dc_current.txt
alter Va0 = 1.8
alter Va1 = 0.0
alter Va2 = 0.0
alter Va3 = 0.0
alter Vb0 = 0.0
alter Vb1 = 1.8
alter Vb2 = 1.8
alter Vb3 = 1.8
alter Vc0 = 0.0
op
print i(VDD) >> dc_current.txt
alter Va0 = 1.8
alter Va1 = 0.0
alter Va2 = 0.0
alter Va3 = 0.0
alter Vb0 = 0.0
alter Vb1 = 1.8
alter Vb2 = 1.8
alter Vb3 = 0.0
alter Vc0 = 1.8
op
print i(VDD) >> dc_current.txt
alter Va0 = 1.8
alter Va1 = 0.0
alter Va2 = 0.0
alter Va3 = 0.0
alter Vb0 = 0.0
alter Vb1 = 1.8
alter Vb2 = 1.8
alter Vb3 = 0.0
alter Vc0 = 0.0
op
print i(VDD) >> dc_current.txt
alter Va0 = 1.8
alter Va1 = 0.0
alter Va2 = 0.0
alter Va3 = 0.0
alter Vb0 = 0.0
alter Vb1 = 1.8
alter Vb2 = 0.0
alter Vb3 = 1.8
alter Vc0 = 1.8
op
print i(VDD) >> dc_current.txt
alter Va0 = 1.8
alter Va1 = 0.0
alter Va2 = 0.0
alter Va3 = 0.0
alter Vb0 = 0.0
alter Vb1 = 1.8
alter Vb2 = 0.0
alter Vb3 = 1.8
alter Vc0 = 0.0
op
print i(VDD) >> dc_current.txt
alter Va0 = 1.8
alter Va1 = 0.0
alter Va2 = 0.0
alter Va3 = 0.0
alter Vb0 = 0.0
alter Vb1 = 1.8
alter Vb2 = 0.0
alter Vb3 = 0.0
alter Vc0 = 1.8
op
print i(VDD) >> dc_current.txt
alter Va0 = 1.8
alter Va1 = 0.0
alter Va2 = 0.0
alter Va3 = 0.0
alter Vb0 = 0.0
alter Vb1 = 1.8
alter Vb2 = 0.0
alter Vb3 = 0.0
alter Vc0 = 0.0
op
print i(VDD) >> dc_current.txt
alter Va0 = 1.8
alter Va1 = 0.0
alter Va2 = 0.0
alter Va3 = 0.0
alter Vb0 = 0.0
alter Vb1 = 0.0
alter Vb2 = 1.8
alter Vb3 = 1.8
alter Vc0 = 1.8
op
print i(VDD) >> dc_current.txt
alter Va0 = 1.8
alter Va1 = 0.0
alter Va2 = 0.0
alter Va3 = 0.0
alter Vb0 = 0.0
alter Vb1 = 0.0
alter Vb2 = 1.8
alter Vb3 = 1.8
alter Vc0 = 0.0
op
print i(VDD) >> dc_current.txt
alter Va0 = 1.8
alter Va1 = 0.0
alter Va2 = 0.0
alter Va3 = 0.0
alter Vb0 = 0.0
alter Vb1 = 0.0
alter Vb2 = 1.8
alter Vb3 = 0.0
alter Vc0 = 1.8
op
print i(VDD) >> dc_current.txt
alter Va0 = 1.8
alter Va1 = 0.0
alter Va2 = 0.0
alter Va3 = 0.0
alter Vb0 = 0.0
alter Vb1 = 0.0
alter Vb2 = 1.8
alter Vb3 = 0.0
alter Vc0 = 0.0
op
print i(VDD) >> dc_current.txt
alter Va0 = 1.8
alter Va1 = 0.0
alter Va2 = 0.0
alter Va3 = 0.0
alter Vb0 = 0.0
alter Vb1 = 0.0
alter Vb2 = 0.0
alter Vb3 = 1.8
alter Vc0 = 1.8
op
print i(VDD) >> dc_current.txt
alter Va0 = 1.8
alter Va1 = 0.0
alter Va2 = 0.0
alter Va3 = 0.0
alter Vb0 = 0.0
alter Vb1 = 0.0
alter Vb2 = 0.0
alter Vb3 = 1.8
alter Vc0 = 0.0
op
print i(VDD) >> dc_current.txt
alter Va0 = 1.8
alter Va1 = 0.0
alter Va2 = 0.0
alter Va3 = 0.0
alter Vb0 = 0.0
alter Vb1 = 0.0
alter Vb2 = 0.0
alter Vb3 = 0.0
alter Vc0 = 1.8
op
print i(VDD) >> dc_current.txt
alter Va0 = 1.8
alter Va1 = 0.0
alter Va2 = 0.0
alter Va3 = 0.0
alter Vb0 = 0.0
alter Vb1 = 0.0
alter Vb2 = 0.0
alter Vb3 = 0.0
alter Vc0 = 0.0
op
print i(VDD) >> dc_current.txt
alter Va0 = 0.0
alter Va1 = 1.8
alter Va2 = 1.8
alter Va3 = 1.8
alter Vb0 = 1.8
alter Vb1 = 1.8
alter Vb2 = 1.8
alter Vb3 = 1.8
alter Vc0 = 1.8
op
print i(VDD) >> dc_current.txt
alter Va0 = 0.0
alter Va1 = 1.8
alter Va2 = 1.8
alter Va3 = 1.8
alter Vb0 = 1.8
alter Vb1 = 1.8
alter Vb2 = 1.8
alter Vb3 = 1.8
alter Vc0 = 0.0
op
print i(VDD) >> dc_current.txt
alter Va0 = 0.0
alter Va1 = 1.8
alter Va2 = 1.8
alter Va3 = 1.8
alter Vb0 = 1.8
alter Vb1 = 1.8
alter Vb2 = 1.8
alter Vb3 = 0.0
alter Vc0 = 1.8
op
print i(VDD) >> dc_current.txt
alter Va0 = 0.0
alter Va1 = 1.8
alter Va2 = 1.8
alter Va3 = 1.8
alter Vb0 = 1.8
alter Vb1 = 1.8
alter Vb2 = 1.8
alter Vb3 = 0.0
alter Vc0 = 0.0
op
print i(VDD) >> dc_current.txt
alter Va0 = 0.0
alter Va1 = 1.8
alter Va2 = 1.8
alter Va3 = 1.8
alter Vb0 = 1.8
alter Vb1 = 1.8
alter Vb2 = 0.0
alter Vb3 = 1.8
alter Vc0 = 1.8
op
print i(VDD) >> dc_current.txt
alter Va0 = 0.0
alter Va1 = 1.8
alter Va2 = 1.8
alter Va3 = 1.8
alter Vb0 = 1.8
alter Vb1 = 1.8
alter Vb2 = 0.0
alter Vb3 = 1.8
alter Vc0 = 0.0
op
print i(VDD) >> dc_current.txt
alter Va0 = 0.0
alter Va1 = 1.8
alter Va2 = 1.8
alter Va3 = 1.8
alter Vb0 = 1.8
alter Vb1 = 1.8
alter Vb2 = 0.0
alter Vb3 = 0.0
alter Vc0 = 1.8
op
print i(VDD) >> dc_current.txt
alter Va0 = 0.0
alter Va1 = 1.8
alter Va2 = 1.8
alter Va3 = 1.8
alter Vb0 = 1.8
alter Vb1 = 1.8
alter Vb2 = 0.0
alter Vb3 = 0.0
alter Vc0 = 0.0
op
print i(VDD) >> dc_current.txt
alter Va0 = 0.0
alter Va1 = 1.8
alter Va2 = 1.8
alter Va3 = 1.8
alter Vb0 = 1.8
alter Vb1 = 0.0
alter Vb2 = 1.8
alter Vb3 = 1.8
alter Vc0 = 1.8
op
print i(VDD) >> dc_current.txt
alter Va0 = 0.0
alter Va1 = 1.8
alter Va2 = 1.8
alter Va3 = 1.8
alter Vb0 = 1.8
alter Vb1 = 0.0
alter Vb2 = 1.8
alter Vb3 = 1.8
alter Vc0 = 0.0
op
print i(VDD) >> dc_current.txt
alter Va0 = 0.0
alter Va1 = 1.8
alter Va2 = 1.8
alter Va3 = 1.8
alter Vb0 = 1.8
alter Vb1 = 0.0
alter Vb2 = 1.8
alter Vb3 = 0.0
alter Vc0 = 1.8
op
print i(VDD) >> dc_current.txt
alter Va0 = 0.0
alter Va1 = 1.8
alter Va2 = 1.8
alter Va3 = 1.8
alter Vb0 = 1.8
alter Vb1 = 0.0
alter Vb2 = 1.8
alter Vb3 = 0.0
alter Vc0 = 0.0
op
print i(VDD) >> dc_current.txt
alter Va0 = 0.0
alter Va1 = 1.8
alter Va2 = 1.8
alter Va3 = 1.8
alter Vb0 = 1.8
alter Vb1 = 0.0
alter Vb2 = 0.0
alter Vb3 = 1.8
alter Vc0 = 1.8
op
print i(VDD) >> dc_current.txt
alter Va0 = 0.0
alter Va1 = 1.8
alter Va2 = 1.8
alter Va3 = 1.8
alter Vb0 = 1.8
alter Vb1 = 0.0
alter Vb2 = 0.0
alter Vb3 = 1.8
alter Vc0 = 0.0
op
print i(VDD) >> dc_current.txt
alter Va0 = 0.0
alter Va1 = 1.8
alter Va2 = 1.8
alter Va3 = 1.8
alter Vb0 = 1.8
alter Vb1 = 0.0
alter Vb2 = 0.0
alter Vb3 = 0.0
alter Vc0 = 1.8
op
print i(VDD) >> dc_current.txt
alter Va0 = 0.0
alter Va1 = 1.8
alter Va2 = 1.8
alter Va3 = 1.8
alter Vb0 = 1.8
alter Vb1 = 0.0
alter Vb2 = 0.0
alter Vb3 = 0.0
alter Vc0 = 0.0
op
print i(VDD) >> dc_current.txt
alter Va0 = 0.0
alter Va1 = 1.8
alter Va2 = 1.8
alter Va3 = 1.8
alter Vb0 = 0.0
alter Vb1 = 1.8
alter Vb2 = 1.8
alter Vb3 = 1.8
alter Vc0 = 1.8
op
print i(VDD) >> dc_current.txt
alter Va0 = 0.0
alter Va1 = 1.8
alter Va2 = 1.8
alter Va3 = 1.8
alter Vb0 = 0.0
alter Vb1 = 1.8
alter Vb2 = 1.8
alter Vb3 = 1.8
alter Vc0 = 0.0
op
print i(VDD) >> dc_current.txt
alter Va0 = 0.0
alter Va1 = 1.8
alter Va2 = 1.8
alter Va3 = 1.8
alter Vb0 = 0.0
alter Vb1 = 1.8
alter Vb2 = 1.8
alter Vb3 = 0.0
alter Vc0 = 1.8
op
print i(VDD) >> dc_current.txt
alter Va0 = 0.0
alter Va1 = 1.8
alter Va2 = 1.8
alter Va3 = 1.8
alter Vb0 = 0.0
alter Vb1 = 1.8
alter Vb2 = 1.8
alter Vb3 = 0.0
alter Vc0 = 0.0
op
print i(VDD) >> dc_current.txt
alter Va0 = 0.0
alter Va1 = 1.8
alter Va2 = 1.8
alter Va3 = 1.8
alter Vb0 = 0.0
alter Vb1 = 1.8
alter Vb2 = 0.0
alter Vb3 = 1.8
alter Vc0 = 1.8
op
print i(VDD) >> dc_current.txt
alter Va0 = 0.0
alter Va1 = 1.8
alter Va2 = 1.8
alter Va3 = 1.8
alter Vb0 = 0.0
alter Vb1 = 1.8
alter Vb2 = 0.0
alter Vb3 = 1.8
alter Vc0 = 0.0
op
print i(VDD) >> dc_current.txt
alter Va0 = 0.0
alter Va1 = 1.8
alter Va2 = 1.8
alter Va3 = 1.8
alter Vb0 = 0.0
alter Vb1 = 1.8
alter Vb2 = 0.0
alter Vb3 = 0.0
alter Vc0 = 1.8
op
print i(VDD) >> dc_current.txt
alter Va0 = 0.0
alter Va1 = 1.8
alter Va2 = 1.8
alter Va3 = 1.8
alter Vb0 = 0.0
alter Vb1 = 1.8
alter Vb2 = 0.0
alter Vb3 = 0.0
alter Vc0 = 0.0
op
print i(VDD) >> dc_current.txt
alter Va0 = 0.0
alter Va1 = 1.8
alter Va2 = 1.8
alter Va3 = 1.8
alter Vb0 = 0.0
alter Vb1 = 0.0
alter Vb2 = 1.8
alter Vb3 = 1.8
alter Vc0 = 1.8
op
print i(VDD) >> dc_current.txt
alter Va0 = 0.0
alter Va1 = 1.8
alter Va2 = 1.8
alter Va3 = 1.8
alter Vb0 = 0.0
alter Vb1 = 0.0
alter Vb2 = 1.8
alter Vb3 = 1.8
alter Vc0 = 0.0
op
print i(VDD) >> dc_current.txt
alter Va0 = 0.0
alter Va1 = 1.8
alter Va2 = 1.8
alter Va3 = 1.8
alter Vb0 = 0.0
alter Vb1 = 0.0
alter Vb2 = 1.8
alter Vb3 = 0.0
alter Vc0 = 1.8
op
print i(VDD) >> dc_current.txt
alter Va0 = 0.0
alter Va1 = 1.8
alter Va2 = 1.8
alter Va3 = 1.8
alter Vb0 = 0.0
alter Vb1 = 0.0
alter Vb2 = 1.8
alter Vb3 = 0.0
alter Vc0 = 0.0
op
print i(VDD) >> dc_current.txt
alter Va0 = 0.0
alter Va1 = 1.8
alter Va2 = 1.8
alter Va3 = 1.8
alter Vb0 = 0.0
alter Vb1 = 0.0
alter Vb2 = 0.0
alter Vb3 = 1.8
alter Vc0 = 1.8
op
print i(VDD) >> dc_current.txt
alter Va0 = 0.0
alter Va1 = 1.8
alter Va2 = 1.8
alter Va3 = 1.8
alter Vb0 = 0.0
alter Vb1 = 0.0
alter Vb2 = 0.0
alter Vb3 = 1.8
alter Vc0 = 0.0
op
print i(VDD) >> dc_current.txt
alter Va0 = 0.0
alter Va1 = 1.8
alter Va2 = 1.8
alter Va3 = 1.8
alter Vb0 = 0.0
alter Vb1 = 0.0
alter Vb2 = 0.0
alter Vb3 = 0.0
alter Vc0 = 1.8
op
print i(VDD) >> dc_current.txt
alter Va0 = 0.0
alter Va1 = 1.8
alter Va2 = 1.8
alter Va3 = 1.8
alter Vb0 = 0.0
alter Vb1 = 0.0
alter Vb2 = 0.0
alter Vb3 = 0.0
alter Vc0 = 0.0
op
print i(VDD) >> dc_current.txt
alter Va0 = 0.0
alter Va1 = 1.8
alter Va2 = 1.8
alter Va3 = 0.0
alter Vb0 = 1.8
alter Vb1 = 1.8
alter Vb2 = 1.8
alter Vb3 = 1.8
alter Vc0 = 1.8
op
print i(VDD) >> dc_current.txt
alter Va0 = 0.0
alter Va1 = 1.8
alter Va2 = 1.8
alter Va3 = 0.0
alter Vb0 = 1.8
alter Vb1 = 1.8
alter Vb2 = 1.8
alter Vb3 = 1.8
alter Vc0 = 0.0
op
print i(VDD) >> dc_current.txt
alter Va0 = 0.0
alter Va1 = 1.8
alter Va2 = 1.8
alter Va3 = 0.0
alter Vb0 = 1.8
alter Vb1 = 1.8
alter Vb2 = 1.8
alter Vb3 = 0.0
alter Vc0 = 1.8
op
print i(VDD) >> dc_current.txt
alter Va0 = 0.0
alter Va1 = 1.8
alter Va2 = 1.8
alter Va3 = 0.0
alter Vb0 = 1.8
alter Vb1 = 1.8
alter Vb2 = 1.8
alter Vb3 = 0.0
alter Vc0 = 0.0
op
print i(VDD) >> dc_current.txt
alter Va0 = 0.0
alter Va1 = 1.8
alter Va2 = 1.8
alter Va3 = 0.0
alter Vb0 = 1.8
alter Vb1 = 1.8
alter Vb2 = 0.0
alter Vb3 = 1.8
alter Vc0 = 1.8
op
print i(VDD) >> dc_current.txt
alter Va0 = 0.0
alter Va1 = 1.8
alter Va2 = 1.8
alter Va3 = 0.0
alter Vb0 = 1.8
alter Vb1 = 1.8
alter Vb2 = 0.0
alter Vb3 = 1.8
alter Vc0 = 0.0
op
print i(VDD) >> dc_current.txt
alter Va0 = 0.0
alter Va1 = 1.8
alter Va2 = 1.8
alter Va3 = 0.0
alter Vb0 = 1.8
alter Vb1 = 1.8
alter Vb2 = 0.0
alter Vb3 = 0.0
alter Vc0 = 1.8
op
print i(VDD) >> dc_current.txt
alter Va0 = 0.0
alter Va1 = 1.8
alter Va2 = 1.8
alter Va3 = 0.0
alter Vb0 = 1.8
alter Vb1 = 1.8
alter Vb2 = 0.0
alter Vb3 = 0.0
alter Vc0 = 0.0
op
print i(VDD) >> dc_current.txt
alter Va0 = 0.0
alter Va1 = 1.8
alter Va2 = 1.8
alter Va3 = 0.0
alter Vb0 = 1.8
alter Vb1 = 0.0
alter Vb2 = 1.8
alter Vb3 = 1.8
alter Vc0 = 1.8
op
print i(VDD) >> dc_current.txt
alter Va0 = 0.0
alter Va1 = 1.8
alter Va2 = 1.8
alter Va3 = 0.0
alter Vb0 = 1.8
alter Vb1 = 0.0
alter Vb2 = 1.8
alter Vb3 = 1.8
alter Vc0 = 0.0
op
print i(VDD) >> dc_current.txt
alter Va0 = 0.0
alter Va1 = 1.8
alter Va2 = 1.8
alter Va3 = 0.0
alter Vb0 = 1.8
alter Vb1 = 0.0
alter Vb2 = 1.8
alter Vb3 = 0.0
alter Vc0 = 1.8
op
print i(VDD) >> dc_current.txt
alter Va0 = 0.0
alter Va1 = 1.8
alter Va2 = 1.8
alter Va3 = 0.0
alter Vb0 = 1.8
alter Vb1 = 0.0
alter Vb2 = 1.8
alter Vb3 = 0.0
alter Vc0 = 0.0
op
print i(VDD) >> dc_current.txt
alter Va0 = 0.0
alter Va1 = 1.8
alter Va2 = 1.8
alter Va3 = 0.0
alter Vb0 = 1.8
alter Vb1 = 0.0
alter Vb2 = 0.0
alter Vb3 = 1.8
alter Vc0 = 1.8
op
print i(VDD) >> dc_current.txt
alter Va0 = 0.0
alter Va1 = 1.8
alter Va2 = 1.8
alter Va3 = 0.0
alter Vb0 = 1.8
alter Vb1 = 0.0
alter Vb2 = 0.0
alter Vb3 = 1.8
alter Vc0 = 0.0
op
print i(VDD) >> dc_current.txt
alter Va0 = 0.0
alter Va1 = 1.8
alter Va2 = 1.8
alter Va3 = 0.0
alter Vb0 = 1.8
alter Vb1 = 0.0
alter Vb2 = 0.0
alter Vb3 = 0.0
alter Vc0 = 1.8
op
print i(VDD) >> dc_current.txt
alter Va0 = 0.0
alter Va1 = 1.8
alter Va2 = 1.8
alter Va3 = 0.0
alter Vb0 = 1.8
alter Vb1 = 0.0
alter Vb2 = 0.0
alter Vb3 = 0.0
alter Vc0 = 0.0
op
print i(VDD) >> dc_current.txt
alter Va0 = 0.0
alter Va1 = 1.8
alter Va2 = 1.8
alter Va3 = 0.0
alter Vb0 = 0.0
alter Vb1 = 1.8
alter Vb2 = 1.8
alter Vb3 = 1.8
alter Vc0 = 1.8
op
print i(VDD) >> dc_current.txt
alter Va0 = 0.0
alter Va1 = 1.8
alter Va2 = 1.8
alter Va3 = 0.0
alter Vb0 = 0.0
alter Vb1 = 1.8
alter Vb2 = 1.8
alter Vb3 = 1.8
alter Vc0 = 0.0
op
print i(VDD) >> dc_current.txt
alter Va0 = 0.0
alter Va1 = 1.8
alter Va2 = 1.8
alter Va3 = 0.0
alter Vb0 = 0.0
alter Vb1 = 1.8
alter Vb2 = 1.8
alter Vb3 = 0.0
alter Vc0 = 1.8
op
print i(VDD) >> dc_current.txt
alter Va0 = 0.0
alter Va1 = 1.8
alter Va2 = 1.8
alter Va3 = 0.0
alter Vb0 = 0.0
alter Vb1 = 1.8
alter Vb2 = 1.8
alter Vb3 = 0.0
alter Vc0 = 0.0
op
print i(VDD) >> dc_current.txt
alter Va0 = 0.0
alter Va1 = 1.8
alter Va2 = 1.8
alter Va3 = 0.0
alter Vb0 = 0.0
alter Vb1 = 1.8
alter Vb2 = 0.0
alter Vb3 = 1.8
alter Vc0 = 1.8
op
print i(VDD) >> dc_current.txt
alter Va0 = 0.0
alter Va1 = 1.8
alter Va2 = 1.8
alter Va3 = 0.0
alter Vb0 = 0.0
alter Vb1 = 1.8
alter Vb2 = 0.0
alter Vb3 = 1.8
alter Vc0 = 0.0
op
print i(VDD) >> dc_current.txt
alter Va0 = 0.0
alter Va1 = 1.8
alter Va2 = 1.8
alter Va3 = 0.0
alter Vb0 = 0.0
alter Vb1 = 1.8
alter Vb2 = 0.0
alter Vb3 = 0.0
alter Vc0 = 1.8
op
print i(VDD) >> dc_current.txt
alter Va0 = 0.0
alter Va1 = 1.8
alter Va2 = 1.8
alter Va3 = 0.0
alter Vb0 = 0.0
alter Vb1 = 1.8
alter Vb2 = 0.0
alter Vb3 = 0.0
alter Vc0 = 0.0
op
print i(VDD) >> dc_current.txt
alter Va0 = 0.0
alter Va1 = 1.8
alter Va2 = 1.8
alter Va3 = 0.0
alter Vb0 = 0.0
alter Vb1 = 0.0
alter Vb2 = 1.8
alter Vb3 = 1.8
alter Vc0 = 1.8
op
print i(VDD) >> dc_current.txt
alter Va0 = 0.0
alter Va1 = 1.8
alter Va2 = 1.8
alter Va3 = 0.0
alter Vb0 = 0.0
alter Vb1 = 0.0
alter Vb2 = 1.8
alter Vb3 = 1.8
alter Vc0 = 0.0
op
print i(VDD) >> dc_current.txt
alter Va0 = 0.0
alter Va1 = 1.8
alter Va2 = 1.8
alter Va3 = 0.0
alter Vb0 = 0.0
alter Vb1 = 0.0
alter Vb2 = 1.8
alter Vb3 = 0.0
alter Vc0 = 1.8
op
print i(VDD) >> dc_current.txt
alter Va0 = 0.0
alter Va1 = 1.8
alter Va2 = 1.8
alter Va3 = 0.0
alter Vb0 = 0.0
alter Vb1 = 0.0
alter Vb2 = 1.8
alter Vb3 = 0.0
alter Vc0 = 0.0
op
print i(VDD) >> dc_current.txt
alter Va0 = 0.0
alter Va1 = 1.8
alter Va2 = 1.8
alter Va3 = 0.0
alter Vb0 = 0.0
alter Vb1 = 0.0
alter Vb2 = 0.0
alter Vb3 = 1.8
alter Vc0 = 1.8
op
print i(VDD) >> dc_current.txt
alter Va0 = 0.0
alter Va1 = 1.8
alter Va2 = 1.8
alter Va3 = 0.0
alter Vb0 = 0.0
alter Vb1 = 0.0
alter Vb2 = 0.0
alter Vb3 = 1.8
alter Vc0 = 0.0
op
print i(VDD) >> dc_current.txt
alter Va0 = 0.0
alter Va1 = 1.8
alter Va2 = 1.8
alter Va3 = 0.0
alter Vb0 = 0.0
alter Vb1 = 0.0
alter Vb2 = 0.0
alter Vb3 = 0.0
alter Vc0 = 1.8
op
print i(VDD) >> dc_current.txt
alter Va0 = 0.0
alter Va1 = 1.8
alter Va2 = 1.8
alter Va3 = 0.0
alter Vb0 = 0.0
alter Vb1 = 0.0
alter Vb2 = 0.0
alter Vb3 = 0.0
alter Vc0 = 0.0
op
print i(VDD) >> dc_current.txt
alter Va0 = 0.0
alter Va1 = 1.8
alter Va2 = 0.0
alter Va3 = 1.8
alter Vb0 = 1.8
alter Vb1 = 1.8
alter Vb2 = 1.8
alter Vb3 = 1.8
alter Vc0 = 1.8
op
print i(VDD) >> dc_current.txt
alter Va0 = 0.0
alter Va1 = 1.8
alter Va2 = 0.0
alter Va3 = 1.8
alter Vb0 = 1.8
alter Vb1 = 1.8
alter Vb2 = 1.8
alter Vb3 = 1.8
alter Vc0 = 0.0
op
print i(VDD) >> dc_current.txt
alter Va0 = 0.0
alter Va1 = 1.8
alter Va2 = 0.0
alter Va3 = 1.8
alter Vb0 = 1.8
alter Vb1 = 1.8
alter Vb2 = 1.8
alter Vb3 = 0.0
alter Vc0 = 1.8
op
print i(VDD) >> dc_current.txt
alter Va0 = 0.0
alter Va1 = 1.8
alter Va2 = 0.0
alter Va3 = 1.8
alter Vb0 = 1.8
alter Vb1 = 1.8
alter Vb2 = 1.8
alter Vb3 = 0.0
alter Vc0 = 0.0
op
print i(VDD) >> dc_current.txt
alter Va0 = 0.0
alter Va1 = 1.8
alter Va2 = 0.0
alter Va3 = 1.8
alter Vb0 = 1.8
alter Vb1 = 1.8
alter Vb2 = 0.0
alter Vb3 = 1.8
alter Vc0 = 1.8
op
print i(VDD) >> dc_current.txt
alter Va0 = 0.0
alter Va1 = 1.8
alter Va2 = 0.0
alter Va3 = 1.8
alter Vb0 = 1.8
alter Vb1 = 1.8
alter Vb2 = 0.0
alter Vb3 = 1.8
alter Vc0 = 0.0
op
print i(VDD) >> dc_current.txt
alter Va0 = 0.0
alter Va1 = 1.8
alter Va2 = 0.0
alter Va3 = 1.8
alter Vb0 = 1.8
alter Vb1 = 1.8
alter Vb2 = 0.0
alter Vb3 = 0.0
alter Vc0 = 1.8
op
print i(VDD) >> dc_current.txt
alter Va0 = 0.0
alter Va1 = 1.8
alter Va2 = 0.0
alter Va3 = 1.8
alter Vb0 = 1.8
alter Vb1 = 1.8
alter Vb2 = 0.0
alter Vb3 = 0.0
alter Vc0 = 0.0
op
print i(VDD) >> dc_current.txt
alter Va0 = 0.0
alter Va1 = 1.8
alter Va2 = 0.0
alter Va3 = 1.8
alter Vb0 = 1.8
alter Vb1 = 0.0
alter Vb2 = 1.8
alter Vb3 = 1.8
alter Vc0 = 1.8
op
print i(VDD) >> dc_current.txt
alter Va0 = 0.0
alter Va1 = 1.8
alter Va2 = 0.0
alter Va3 = 1.8
alter Vb0 = 1.8
alter Vb1 = 0.0
alter Vb2 = 1.8
alter Vb3 = 1.8
alter Vc0 = 0.0
op
print i(VDD) >> dc_current.txt
alter Va0 = 0.0
alter Va1 = 1.8
alter Va2 = 0.0
alter Va3 = 1.8
alter Vb0 = 1.8
alter Vb1 = 0.0
alter Vb2 = 1.8
alter Vb3 = 0.0
alter Vc0 = 1.8
op
print i(VDD) >> dc_current.txt
alter Va0 = 0.0
alter Va1 = 1.8
alter Va2 = 0.0
alter Va3 = 1.8
alter Vb0 = 1.8
alter Vb1 = 0.0
alter Vb2 = 1.8
alter Vb3 = 0.0
alter Vc0 = 0.0
op
print i(VDD) >> dc_current.txt
alter Va0 = 0.0
alter Va1 = 1.8
alter Va2 = 0.0
alter Va3 = 1.8
alter Vb0 = 1.8
alter Vb1 = 0.0
alter Vb2 = 0.0
alter Vb3 = 1.8
alter Vc0 = 1.8
op
print i(VDD) >> dc_current.txt
alter Va0 = 0.0
alter Va1 = 1.8
alter Va2 = 0.0
alter Va3 = 1.8
alter Vb0 = 1.8
alter Vb1 = 0.0
alter Vb2 = 0.0
alter Vb3 = 1.8
alter Vc0 = 0.0
op
print i(VDD) >> dc_current.txt
alter Va0 = 0.0
alter Va1 = 1.8
alter Va2 = 0.0
alter Va3 = 1.8
alter Vb0 = 1.8
alter Vb1 = 0.0
alter Vb2 = 0.0
alter Vb3 = 0.0
alter Vc0 = 1.8
op
print i(VDD) >> dc_current.txt
alter Va0 = 0.0
alter Va1 = 1.8
alter Va2 = 0.0
alter Va3 = 1.8
alter Vb0 = 1.8
alter Vb1 = 0.0
alter Vb2 = 0.0
alter Vb3 = 0.0
alter Vc0 = 0.0
op
print i(VDD) >> dc_current.txt
alter Va0 = 0.0
alter Va1 = 1.8
alter Va2 = 0.0
alter Va3 = 1.8
alter Vb0 = 0.0
alter Vb1 = 1.8
alter Vb2 = 1.8
alter Vb3 = 1.8
alter Vc0 = 1.8
op
print i(VDD) >> dc_current.txt
alter Va0 = 0.0
alter Va1 = 1.8
alter Va2 = 0.0
alter Va3 = 1.8
alter Vb0 = 0.0
alter Vb1 = 1.8
alter Vb2 = 1.8
alter Vb3 = 1.8
alter Vc0 = 0.0
op
print i(VDD) >> dc_current.txt
alter Va0 = 0.0
alter Va1 = 1.8
alter Va2 = 0.0
alter Va3 = 1.8
alter Vb0 = 0.0
alter Vb1 = 1.8
alter Vb2 = 1.8
alter Vb3 = 0.0
alter Vc0 = 1.8
op
print i(VDD) >> dc_current.txt
alter Va0 = 0.0
alter Va1 = 1.8
alter Va2 = 0.0
alter Va3 = 1.8
alter Vb0 = 0.0
alter Vb1 = 1.8
alter Vb2 = 1.8
alter Vb3 = 0.0
alter Vc0 = 0.0
op
print i(VDD) >> dc_current.txt
alter Va0 = 0.0
alter Va1 = 1.8
alter Va2 = 0.0
alter Va3 = 1.8
alter Vb0 = 0.0
alter Vb1 = 1.8
alter Vb2 = 0.0
alter Vb3 = 1.8
alter Vc0 = 1.8
op
print i(VDD) >> dc_current.txt
alter Va0 = 0.0
alter Va1 = 1.8
alter Va2 = 0.0
alter Va3 = 1.8
alter Vb0 = 0.0
alter Vb1 = 1.8
alter Vb2 = 0.0
alter Vb3 = 1.8
alter Vc0 = 0.0
op
print i(VDD) >> dc_current.txt
alter Va0 = 0.0
alter Va1 = 1.8
alter Va2 = 0.0
alter Va3 = 1.8
alter Vb0 = 0.0
alter Vb1 = 1.8
alter Vb2 = 0.0
alter Vb3 = 0.0
alter Vc0 = 1.8
op
print i(VDD) >> dc_current.txt
alter Va0 = 0.0
alter Va1 = 1.8
alter Va2 = 0.0
alter Va3 = 1.8
alter Vb0 = 0.0
alter Vb1 = 1.8
alter Vb2 = 0.0
alter Vb3 = 0.0
alter Vc0 = 0.0
op
print i(VDD) >> dc_current.txt
alter Va0 = 0.0
alter Va1 = 1.8
alter Va2 = 0.0
alter Va3 = 1.8
alter Vb0 = 0.0
alter Vb1 = 0.0
alter Vb2 = 1.8
alter Vb3 = 1.8
alter Vc0 = 1.8
op
print i(VDD) >> dc_current.txt
alter Va0 = 0.0
alter Va1 = 1.8
alter Va2 = 0.0
alter Va3 = 1.8
alter Vb0 = 0.0
alter Vb1 = 0.0
alter Vb2 = 1.8
alter Vb3 = 1.8
alter Vc0 = 0.0
op
print i(VDD) >> dc_current.txt
alter Va0 = 0.0
alter Va1 = 1.8
alter Va2 = 0.0
alter Va3 = 1.8
alter Vb0 = 0.0
alter Vb1 = 0.0
alter Vb2 = 1.8
alter Vb3 = 0.0
alter Vc0 = 1.8
op
print i(VDD) >> dc_current.txt
alter Va0 = 0.0
alter Va1 = 1.8
alter Va2 = 0.0
alter Va3 = 1.8
alter Vb0 = 0.0
alter Vb1 = 0.0
alter Vb2 = 1.8
alter Vb3 = 0.0
alter Vc0 = 0.0
op
print i(VDD) >> dc_current.txt
alter Va0 = 0.0
alter Va1 = 1.8
alter Va2 = 0.0
alter Va3 = 1.8
alter Vb0 = 0.0
alter Vb1 = 0.0
alter Vb2 = 0.0
alter Vb3 = 1.8
alter Vc0 = 1.8
op
print i(VDD) >> dc_current.txt
alter Va0 = 0.0
alter Va1 = 1.8
alter Va2 = 0.0
alter Va3 = 1.8
alter Vb0 = 0.0
alter Vb1 = 0.0
alter Vb2 = 0.0
alter Vb3 = 1.8
alter Vc0 = 0.0
op
print i(VDD) >> dc_current.txt
alter Va0 = 0.0
alter Va1 = 1.8
alter Va2 = 0.0
alter Va3 = 1.8
alter Vb0 = 0.0
alter Vb1 = 0.0
alter Vb2 = 0.0
alter Vb3 = 0.0
alter Vc0 = 1.8
op
print i(VDD) >> dc_current.txt
alter Va0 = 0.0
alter Va1 = 1.8
alter Va2 = 0.0
alter Va3 = 1.8
alter Vb0 = 0.0
alter Vb1 = 0.0
alter Vb2 = 0.0
alter Vb3 = 0.0
alter Vc0 = 0.0
op
print i(VDD) >> dc_current.txt
alter Va0 = 0.0
alter Va1 = 1.8
alter Va2 = 0.0
alter Va3 = 0.0
alter Vb0 = 1.8
alter Vb1 = 1.8
alter Vb2 = 1.8
alter Vb3 = 1.8
alter Vc0 = 1.8
op
print i(VDD) >> dc_current.txt
alter Va0 = 0.0
alter Va1 = 1.8
alter Va2 = 0.0
alter Va3 = 0.0
alter Vb0 = 1.8
alter Vb1 = 1.8
alter Vb2 = 1.8
alter Vb3 = 1.8
alter Vc0 = 0.0
op
print i(VDD) >> dc_current.txt
alter Va0 = 0.0
alter Va1 = 1.8
alter Va2 = 0.0
alter Va3 = 0.0
alter Vb0 = 1.8
alter Vb1 = 1.8
alter Vb2 = 1.8
alter Vb3 = 0.0
alter Vc0 = 1.8
op
print i(VDD) >> dc_current.txt
alter Va0 = 0.0
alter Va1 = 1.8
alter Va2 = 0.0
alter Va3 = 0.0
alter Vb0 = 1.8
alter Vb1 = 1.8
alter Vb2 = 1.8
alter Vb3 = 0.0
alter Vc0 = 0.0
op
print i(VDD) >> dc_current.txt
alter Va0 = 0.0
alter Va1 = 1.8
alter Va2 = 0.0
alter Va3 = 0.0
alter Vb0 = 1.8
alter Vb1 = 1.8
alter Vb2 = 0.0
alter Vb3 = 1.8
alter Vc0 = 1.8
op
print i(VDD) >> dc_current.txt
alter Va0 = 0.0
alter Va1 = 1.8
alter Va2 = 0.0
alter Va3 = 0.0
alter Vb0 = 1.8
alter Vb1 = 1.8
alter Vb2 = 0.0
alter Vb3 = 1.8
alter Vc0 = 0.0
op
print i(VDD) >> dc_current.txt
alter Va0 = 0.0
alter Va1 = 1.8
alter Va2 = 0.0
alter Va3 = 0.0
alter Vb0 = 1.8
alter Vb1 = 1.8
alter Vb2 = 0.0
alter Vb3 = 0.0
alter Vc0 = 1.8
op
print i(VDD) >> dc_current.txt
alter Va0 = 0.0
alter Va1 = 1.8
alter Va2 = 0.0
alter Va3 = 0.0
alter Vb0 = 1.8
alter Vb1 = 1.8
alter Vb2 = 0.0
alter Vb3 = 0.0
alter Vc0 = 0.0
op
print i(VDD) >> dc_current.txt
alter Va0 = 0.0
alter Va1 = 1.8
alter Va2 = 0.0
alter Va3 = 0.0
alter Vb0 = 1.8
alter Vb1 = 0.0
alter Vb2 = 1.8
alter Vb3 = 1.8
alter Vc0 = 1.8
op
print i(VDD) >> dc_current.txt
alter Va0 = 0.0
alter Va1 = 1.8
alter Va2 = 0.0
alter Va3 = 0.0
alter Vb0 = 1.8
alter Vb1 = 0.0
alter Vb2 = 1.8
alter Vb3 = 1.8
alter Vc0 = 0.0
op
print i(VDD) >> dc_current.txt
alter Va0 = 0.0
alter Va1 = 1.8
alter Va2 = 0.0
alter Va3 = 0.0
alter Vb0 = 1.8
alter Vb1 = 0.0
alter Vb2 = 1.8
alter Vb3 = 0.0
alter Vc0 = 1.8
op
print i(VDD) >> dc_current.txt
alter Va0 = 0.0
alter Va1 = 1.8
alter Va2 = 0.0
alter Va3 = 0.0
alter Vb0 = 1.8
alter Vb1 = 0.0
alter Vb2 = 1.8
alter Vb3 = 0.0
alter Vc0 = 0.0
op
print i(VDD) >> dc_current.txt
alter Va0 = 0.0
alter Va1 = 1.8
alter Va2 = 0.0
alter Va3 = 0.0
alter Vb0 = 1.8
alter Vb1 = 0.0
alter Vb2 = 0.0
alter Vb3 = 1.8
alter Vc0 = 1.8
op
print i(VDD) >> dc_current.txt
alter Va0 = 0.0
alter Va1 = 1.8
alter Va2 = 0.0
alter Va3 = 0.0
alter Vb0 = 1.8
alter Vb1 = 0.0
alter Vb2 = 0.0
alter Vb3 = 1.8
alter Vc0 = 0.0
op
print i(VDD) >> dc_current.txt
alter Va0 = 0.0
alter Va1 = 1.8
alter Va2 = 0.0
alter Va3 = 0.0
alter Vb0 = 1.8
alter Vb1 = 0.0
alter Vb2 = 0.0
alter Vb3 = 0.0
alter Vc0 = 1.8
op
print i(VDD) >> dc_current.txt
alter Va0 = 0.0
alter Va1 = 1.8
alter Va2 = 0.0
alter Va3 = 0.0
alter Vb0 = 1.8
alter Vb1 = 0.0
alter Vb2 = 0.0
alter Vb3 = 0.0
alter Vc0 = 0.0
op
print i(VDD) >> dc_current.txt
alter Va0 = 0.0
alter Va1 = 1.8
alter Va2 = 0.0
alter Va3 = 0.0
alter Vb0 = 0.0
alter Vb1 = 1.8
alter Vb2 = 1.8
alter Vb3 = 1.8
alter Vc0 = 1.8
op
print i(VDD) >> dc_current.txt
alter Va0 = 0.0
alter Va1 = 1.8
alter Va2 = 0.0
alter Va3 = 0.0
alter Vb0 = 0.0
alter Vb1 = 1.8
alter Vb2 = 1.8
alter Vb3 = 1.8
alter Vc0 = 0.0
op
print i(VDD) >> dc_current.txt
alter Va0 = 0.0
alter Va1 = 1.8
alter Va2 = 0.0
alter Va3 = 0.0
alter Vb0 = 0.0
alter Vb1 = 1.8
alter Vb2 = 1.8
alter Vb3 = 0.0
alter Vc0 = 1.8
op
print i(VDD) >> dc_current.txt
alter Va0 = 0.0
alter Va1 = 1.8
alter Va2 = 0.0
alter Va3 = 0.0
alter Vb0 = 0.0
alter Vb1 = 1.8
alter Vb2 = 1.8
alter Vb3 = 0.0
alter Vc0 = 0.0
op
print i(VDD) >> dc_current.txt
alter Va0 = 0.0
alter Va1 = 1.8
alter Va2 = 0.0
alter Va3 = 0.0
alter Vb0 = 0.0
alter Vb1 = 1.8
alter Vb2 = 0.0
alter Vb3 = 1.8
alter Vc0 = 1.8
op
print i(VDD) >> dc_current.txt
alter Va0 = 0.0
alter Va1 = 1.8
alter Va2 = 0.0
alter Va3 = 0.0
alter Vb0 = 0.0
alter Vb1 = 1.8
alter Vb2 = 0.0
alter Vb3 = 1.8
alter Vc0 = 0.0
op
print i(VDD) >> dc_current.txt
alter Va0 = 0.0
alter Va1 = 1.8
alter Va2 = 0.0
alter Va3 = 0.0
alter Vb0 = 0.0
alter Vb1 = 1.8
alter Vb2 = 0.0
alter Vb3 = 0.0
alter Vc0 = 1.8
op
print i(VDD) >> dc_current.txt
alter Va0 = 0.0
alter Va1 = 1.8
alter Va2 = 0.0
alter Va3 = 0.0
alter Vb0 = 0.0
alter Vb1 = 1.8
alter Vb2 = 0.0
alter Vb3 = 0.0
alter Vc0 = 0.0
op
print i(VDD) >> dc_current.txt
alter Va0 = 0.0
alter Va1 = 1.8
alter Va2 = 0.0
alter Va3 = 0.0
alter Vb0 = 0.0
alter Vb1 = 0.0
alter Vb2 = 1.8
alter Vb3 = 1.8
alter Vc0 = 1.8
op
print i(VDD) >> dc_current.txt
alter Va0 = 0.0
alter Va1 = 1.8
alter Va2 = 0.0
alter Va3 = 0.0
alter Vb0 = 0.0
alter Vb1 = 0.0
alter Vb2 = 1.8
alter Vb3 = 1.8
alter Vc0 = 0.0
op
print i(VDD) >> dc_current.txt
alter Va0 = 0.0
alter Va1 = 1.8
alter Va2 = 0.0
alter Va3 = 0.0
alter Vb0 = 0.0
alter Vb1 = 0.0
alter Vb2 = 1.8
alter Vb3 = 0.0
alter Vc0 = 1.8
op
print i(VDD) >> dc_current.txt
alter Va0 = 0.0
alter Va1 = 1.8
alter Va2 = 0.0
alter Va3 = 0.0
alter Vb0 = 0.0
alter Vb1 = 0.0
alter Vb2 = 1.8
alter Vb3 = 0.0
alter Vc0 = 0.0
op
print i(VDD) >> dc_current.txt
alter Va0 = 0.0
alter Va1 = 1.8
alter Va2 = 0.0
alter Va3 = 0.0
alter Vb0 = 0.0
alter Vb1 = 0.0
alter Vb2 = 0.0
alter Vb3 = 1.8
alter Vc0 = 1.8
op
print i(VDD) >> dc_current.txt
alter Va0 = 0.0
alter Va1 = 1.8
alter Va2 = 0.0
alter Va3 = 0.0
alter Vb0 = 0.0
alter Vb1 = 0.0
alter Vb2 = 0.0
alter Vb3 = 1.8
alter Vc0 = 0.0
op
print i(VDD) >> dc_current.txt
alter Va0 = 0.0
alter Va1 = 1.8
alter Va2 = 0.0
alter Va3 = 0.0
alter Vb0 = 0.0
alter Vb1 = 0.0
alter Vb2 = 0.0
alter Vb3 = 0.0
alter Vc0 = 1.8
op
print i(VDD) >> dc_current.txt
alter Va0 = 0.0
alter Va1 = 1.8
alter Va2 = 0.0
alter Va3 = 0.0
alter Vb0 = 0.0
alter Vb1 = 0.0
alter Vb2 = 0.0
alter Vb3 = 0.0
alter Vc0 = 0.0
op
print i(VDD) >> dc_current.txt
alter Va0 = 0.0
alter Va1 = 0.0
alter Va2 = 1.8
alter Va3 = 1.8
alter Vb0 = 1.8
alter Vb1 = 1.8
alter Vb2 = 1.8
alter Vb3 = 1.8
alter Vc0 = 1.8
op
print i(VDD) >> dc_current.txt
alter Va0 = 0.0
alter Va1 = 0.0
alter Va2 = 1.8
alter Va3 = 1.8
alter Vb0 = 1.8
alter Vb1 = 1.8
alter Vb2 = 1.8
alter Vb3 = 1.8
alter Vc0 = 0.0
op
print i(VDD) >> dc_current.txt
alter Va0 = 0.0
alter Va1 = 0.0
alter Va2 = 1.8
alter Va3 = 1.8
alter Vb0 = 1.8
alter Vb1 = 1.8
alter Vb2 = 1.8
alter Vb3 = 0.0
alter Vc0 = 1.8
op
print i(VDD) >> dc_current.txt
alter Va0 = 0.0
alter Va1 = 0.0
alter Va2 = 1.8
alter Va3 = 1.8
alter Vb0 = 1.8
alter Vb1 = 1.8
alter Vb2 = 1.8
alter Vb3 = 0.0
alter Vc0 = 0.0
op
print i(VDD) >> dc_current.txt
alter Va0 = 0.0
alter Va1 = 0.0
alter Va2 = 1.8
alter Va3 = 1.8
alter Vb0 = 1.8
alter Vb1 = 1.8
alter Vb2 = 0.0
alter Vb3 = 1.8
alter Vc0 = 1.8
op
print i(VDD) >> dc_current.txt
alter Va0 = 0.0
alter Va1 = 0.0
alter Va2 = 1.8
alter Va3 = 1.8
alter Vb0 = 1.8
alter Vb1 = 1.8
alter Vb2 = 0.0
alter Vb3 = 1.8
alter Vc0 = 0.0
op
print i(VDD) >> dc_current.txt
alter Va0 = 0.0
alter Va1 = 0.0
alter Va2 = 1.8
alter Va3 = 1.8
alter Vb0 = 1.8
alter Vb1 = 1.8
alter Vb2 = 0.0
alter Vb3 = 0.0
alter Vc0 = 1.8
op
print i(VDD) >> dc_current.txt
alter Va0 = 0.0
alter Va1 = 0.0
alter Va2 = 1.8
alter Va3 = 1.8
alter Vb0 = 1.8
alter Vb1 = 1.8
alter Vb2 = 0.0
alter Vb3 = 0.0
alter Vc0 = 0.0
op
print i(VDD) >> dc_current.txt
alter Va0 = 0.0
alter Va1 = 0.0
alter Va2 = 1.8
alter Va3 = 1.8
alter Vb0 = 1.8
alter Vb1 = 0.0
alter Vb2 = 1.8
alter Vb3 = 1.8
alter Vc0 = 1.8
op
print i(VDD) >> dc_current.txt
alter Va0 = 0.0
alter Va1 = 0.0
alter Va2 = 1.8
alter Va3 = 1.8
alter Vb0 = 1.8
alter Vb1 = 0.0
alter Vb2 = 1.8
alter Vb3 = 1.8
alter Vc0 = 0.0
op
print i(VDD) >> dc_current.txt
alter Va0 = 0.0
alter Va1 = 0.0
alter Va2 = 1.8
alter Va3 = 1.8
alter Vb0 = 1.8
alter Vb1 = 0.0
alter Vb2 = 1.8
alter Vb3 = 0.0
alter Vc0 = 1.8
op
print i(VDD) >> dc_current.txt
alter Va0 = 0.0
alter Va1 = 0.0
alter Va2 = 1.8
alter Va3 = 1.8
alter Vb0 = 1.8
alter Vb1 = 0.0
alter Vb2 = 1.8
alter Vb3 = 0.0
alter Vc0 = 0.0
op
print i(VDD) >> dc_current.txt
alter Va0 = 0.0
alter Va1 = 0.0
alter Va2 = 1.8
alter Va3 = 1.8
alter Vb0 = 1.8
alter Vb1 = 0.0
alter Vb2 = 0.0
alter Vb3 = 1.8
alter Vc0 = 1.8
op
print i(VDD) >> dc_current.txt
alter Va0 = 0.0
alter Va1 = 0.0
alter Va2 = 1.8
alter Va3 = 1.8
alter Vb0 = 1.8
alter Vb1 = 0.0
alter Vb2 = 0.0
alter Vb3 = 1.8
alter Vc0 = 0.0
op
print i(VDD) >> dc_current.txt
alter Va0 = 0.0
alter Va1 = 0.0
alter Va2 = 1.8
alter Va3 = 1.8
alter Vb0 = 1.8
alter Vb1 = 0.0
alter Vb2 = 0.0
alter Vb3 = 0.0
alter Vc0 = 1.8
op
print i(VDD) >> dc_current.txt
alter Va0 = 0.0
alter Va1 = 0.0
alter Va2 = 1.8
alter Va3 = 1.8
alter Vb0 = 1.8
alter Vb1 = 0.0
alter Vb2 = 0.0
alter Vb3 = 0.0
alter Vc0 = 0.0
op
print i(VDD) >> dc_current.txt
alter Va0 = 0.0
alter Va1 = 0.0
alter Va2 = 1.8
alter Va3 = 1.8
alter Vb0 = 0.0
alter Vb1 = 1.8
alter Vb2 = 1.8
alter Vb3 = 1.8
alter Vc0 = 1.8
op
print i(VDD) >> dc_current.txt
alter Va0 = 0.0
alter Va1 = 0.0
alter Va2 = 1.8
alter Va3 = 1.8
alter Vb0 = 0.0
alter Vb1 = 1.8
alter Vb2 = 1.8
alter Vb3 = 1.8
alter Vc0 = 0.0
op
print i(VDD) >> dc_current.txt
alter Va0 = 0.0
alter Va1 = 0.0
alter Va2 = 1.8
alter Va3 = 1.8
alter Vb0 = 0.0
alter Vb1 = 1.8
alter Vb2 = 1.8
alter Vb3 = 0.0
alter Vc0 = 1.8
op
print i(VDD) >> dc_current.txt
alter Va0 = 0.0
alter Va1 = 0.0
alter Va2 = 1.8
alter Va3 = 1.8
alter Vb0 = 0.0
alter Vb1 = 1.8
alter Vb2 = 1.8
alter Vb3 = 0.0
alter Vc0 = 0.0
op
print i(VDD) >> dc_current.txt
alter Va0 = 0.0
alter Va1 = 0.0
alter Va2 = 1.8
alter Va3 = 1.8
alter Vb0 = 0.0
alter Vb1 = 1.8
alter Vb2 = 0.0
alter Vb3 = 1.8
alter Vc0 = 1.8
op
print i(VDD) >> dc_current.txt
alter Va0 = 0.0
alter Va1 = 0.0
alter Va2 = 1.8
alter Va3 = 1.8
alter Vb0 = 0.0
alter Vb1 = 1.8
alter Vb2 = 0.0
alter Vb3 = 1.8
alter Vc0 = 0.0
op
print i(VDD) >> dc_current.txt
alter Va0 = 0.0
alter Va1 = 0.0
alter Va2 = 1.8
alter Va3 = 1.8
alter Vb0 = 0.0
alter Vb1 = 1.8
alter Vb2 = 0.0
alter Vb3 = 0.0
alter Vc0 = 1.8
op
print i(VDD) >> dc_current.txt
alter Va0 = 0.0
alter Va1 = 0.0
alter Va2 = 1.8
alter Va3 = 1.8
alter Vb0 = 0.0
alter Vb1 = 1.8
alter Vb2 = 0.0
alter Vb3 = 0.0
alter Vc0 = 0.0
op
print i(VDD) >> dc_current.txt
alter Va0 = 0.0
alter Va1 = 0.0
alter Va2 = 1.8
alter Va3 = 1.8
alter Vb0 = 0.0
alter Vb1 = 0.0
alter Vb2 = 1.8
alter Vb3 = 1.8
alter Vc0 = 1.8
op
print i(VDD) >> dc_current.txt
alter Va0 = 0.0
alter Va1 = 0.0
alter Va2 = 1.8
alter Va3 = 1.8
alter Vb0 = 0.0
alter Vb1 = 0.0
alter Vb2 = 1.8
alter Vb3 = 1.8
alter Vc0 = 0.0
op
print i(VDD) >> dc_current.txt
alter Va0 = 0.0
alter Va1 = 0.0
alter Va2 = 1.8
alter Va3 = 1.8
alter Vb0 = 0.0
alter Vb1 = 0.0
alter Vb2 = 1.8
alter Vb3 = 0.0
alter Vc0 = 1.8
op
print i(VDD) >> dc_current.txt
alter Va0 = 0.0
alter Va1 = 0.0
alter Va2 = 1.8
alter Va3 = 1.8
alter Vb0 = 0.0
alter Vb1 = 0.0
alter Vb2 = 1.8
alter Vb3 = 0.0
alter Vc0 = 0.0
op
print i(VDD) >> dc_current.txt
alter Va0 = 0.0
alter Va1 = 0.0
alter Va2 = 1.8
alter Va3 = 1.8
alter Vb0 = 0.0
alter Vb1 = 0.0
alter Vb2 = 0.0
alter Vb3 = 1.8
alter Vc0 = 1.8
op
print i(VDD) >> dc_current.txt
alter Va0 = 0.0
alter Va1 = 0.0
alter Va2 = 1.8
alter Va3 = 1.8
alter Vb0 = 0.0
alter Vb1 = 0.0
alter Vb2 = 0.0
alter Vb3 = 1.8
alter Vc0 = 0.0
op
print i(VDD) >> dc_current.txt
alter Va0 = 0.0
alter Va1 = 0.0
alter Va2 = 1.8
alter Va3 = 1.8
alter Vb0 = 0.0
alter Vb1 = 0.0
alter Vb2 = 0.0
alter Vb3 = 0.0
alter Vc0 = 1.8
op
print i(VDD) >> dc_current.txt
alter Va0 = 0.0
alter Va1 = 0.0
alter Va2 = 1.8
alter Va3 = 1.8
alter Vb0 = 0.0
alter Vb1 = 0.0
alter Vb2 = 0.0
alter Vb3 = 0.0
alter Vc0 = 0.0
op
print i(VDD) >> dc_current.txt
alter Va0 = 0.0
alter Va1 = 0.0
alter Va2 = 1.8
alter Va3 = 0.0
alter Vb0 = 1.8
alter Vb1 = 1.8
alter Vb2 = 1.8
alter Vb3 = 1.8
alter Vc0 = 1.8
op
print i(VDD) >> dc_current.txt
alter Va0 = 0.0
alter Va1 = 0.0
alter Va2 = 1.8
alter Va3 = 0.0
alter Vb0 = 1.8
alter Vb1 = 1.8
alter Vb2 = 1.8
alter Vb3 = 1.8
alter Vc0 = 0.0
op
print i(VDD) >> dc_current.txt
alter Va0 = 0.0
alter Va1 = 0.0
alter Va2 = 1.8
alter Va3 = 0.0
alter Vb0 = 1.8
alter Vb1 = 1.8
alter Vb2 = 1.8
alter Vb3 = 0.0
alter Vc0 = 1.8
op
print i(VDD) >> dc_current.txt
alter Va0 = 0.0
alter Va1 = 0.0
alter Va2 = 1.8
alter Va3 = 0.0
alter Vb0 = 1.8
alter Vb1 = 1.8
alter Vb2 = 1.8
alter Vb3 = 0.0
alter Vc0 = 0.0
op
print i(VDD) >> dc_current.txt
alter Va0 = 0.0
alter Va1 = 0.0
alter Va2 = 1.8
alter Va3 = 0.0
alter Vb0 = 1.8
alter Vb1 = 1.8
alter Vb2 = 0.0
alter Vb3 = 1.8
alter Vc0 = 1.8
op
print i(VDD) >> dc_current.txt
alter Va0 = 0.0
alter Va1 = 0.0
alter Va2 = 1.8
alter Va3 = 0.0
alter Vb0 = 1.8
alter Vb1 = 1.8
alter Vb2 = 0.0
alter Vb3 = 1.8
alter Vc0 = 0.0
op
print i(VDD) >> dc_current.txt
alter Va0 = 0.0
alter Va1 = 0.0
alter Va2 = 1.8
alter Va3 = 0.0
alter Vb0 = 1.8
alter Vb1 = 1.8
alter Vb2 = 0.0
alter Vb3 = 0.0
alter Vc0 = 1.8
op
print i(VDD) >> dc_current.txt
alter Va0 = 0.0
alter Va1 = 0.0
alter Va2 = 1.8
alter Va3 = 0.0
alter Vb0 = 1.8
alter Vb1 = 1.8
alter Vb2 = 0.0
alter Vb3 = 0.0
alter Vc0 = 0.0
op
print i(VDD) >> dc_current.txt
alter Va0 = 0.0
alter Va1 = 0.0
alter Va2 = 1.8
alter Va3 = 0.0
alter Vb0 = 1.8
alter Vb1 = 0.0
alter Vb2 = 1.8
alter Vb3 = 1.8
alter Vc0 = 1.8
op
print i(VDD) >> dc_current.txt
alter Va0 = 0.0
alter Va1 = 0.0
alter Va2 = 1.8
alter Va3 = 0.0
alter Vb0 = 1.8
alter Vb1 = 0.0
alter Vb2 = 1.8
alter Vb3 = 1.8
alter Vc0 = 0.0
op
print i(VDD) >> dc_current.txt
alter Va0 = 0.0
alter Va1 = 0.0
alter Va2 = 1.8
alter Va3 = 0.0
alter Vb0 = 1.8
alter Vb1 = 0.0
alter Vb2 = 1.8
alter Vb3 = 0.0
alter Vc0 = 1.8
op
print i(VDD) >> dc_current.txt
alter Va0 = 0.0
alter Va1 = 0.0
alter Va2 = 1.8
alter Va3 = 0.0
alter Vb0 = 1.8
alter Vb1 = 0.0
alter Vb2 = 1.8
alter Vb3 = 0.0
alter Vc0 = 0.0
op
print i(VDD) >> dc_current.txt
alter Va0 = 0.0
alter Va1 = 0.0
alter Va2 = 1.8
alter Va3 = 0.0
alter Vb0 = 1.8
alter Vb1 = 0.0
alter Vb2 = 0.0
alter Vb3 = 1.8
alter Vc0 = 1.8
op
print i(VDD) >> dc_current.txt
alter Va0 = 0.0
alter Va1 = 0.0
alter Va2 = 1.8
alter Va3 = 0.0
alter Vb0 = 1.8
alter Vb1 = 0.0
alter Vb2 = 0.0
alter Vb3 = 1.8
alter Vc0 = 0.0
op
print i(VDD) >> dc_current.txt
alter Va0 = 0.0
alter Va1 = 0.0
alter Va2 = 1.8
alter Va3 = 0.0
alter Vb0 = 1.8
alter Vb1 = 0.0
alter Vb2 = 0.0
alter Vb3 = 0.0
alter Vc0 = 1.8
op
print i(VDD) >> dc_current.txt
alter Va0 = 0.0
alter Va1 = 0.0
alter Va2 = 1.8
alter Va3 = 0.0
alter Vb0 = 1.8
alter Vb1 = 0.0
alter Vb2 = 0.0
alter Vb3 = 0.0
alter Vc0 = 0.0
op
print i(VDD) >> dc_current.txt
alter Va0 = 0.0
alter Va1 = 0.0
alter Va2 = 1.8
alter Va3 = 0.0
alter Vb0 = 0.0
alter Vb1 = 1.8
alter Vb2 = 1.8
alter Vb3 = 1.8
alter Vc0 = 1.8
op
print i(VDD) >> dc_current.txt
alter Va0 = 0.0
alter Va1 = 0.0
alter Va2 = 1.8
alter Va3 = 0.0
alter Vb0 = 0.0
alter Vb1 = 1.8
alter Vb2 = 1.8
alter Vb3 = 1.8
alter Vc0 = 0.0
op
print i(VDD) >> dc_current.txt
alter Va0 = 0.0
alter Va1 = 0.0
alter Va2 = 1.8
alter Va3 = 0.0
alter Vb0 = 0.0
alter Vb1 = 1.8
alter Vb2 = 1.8
alter Vb3 = 0.0
alter Vc0 = 1.8
op
print i(VDD) >> dc_current.txt
alter Va0 = 0.0
alter Va1 = 0.0
alter Va2 = 1.8
alter Va3 = 0.0
alter Vb0 = 0.0
alter Vb1 = 1.8
alter Vb2 = 1.8
alter Vb3 = 0.0
alter Vc0 = 0.0
op
print i(VDD) >> dc_current.txt
alter Va0 = 0.0
alter Va1 = 0.0
alter Va2 = 1.8
alter Va3 = 0.0
alter Vb0 = 0.0
alter Vb1 = 1.8
alter Vb2 = 0.0
alter Vb3 = 1.8
alter Vc0 = 1.8
op
print i(VDD) >> dc_current.txt
alter Va0 = 0.0
alter Va1 = 0.0
alter Va2 = 1.8
alter Va3 = 0.0
alter Vb0 = 0.0
alter Vb1 = 1.8
alter Vb2 = 0.0
alter Vb3 = 1.8
alter Vc0 = 0.0
op
print i(VDD) >> dc_current.txt
alter Va0 = 0.0
alter Va1 = 0.0
alter Va2 = 1.8
alter Va3 = 0.0
alter Vb0 = 0.0
alter Vb1 = 1.8
alter Vb2 = 0.0
alter Vb3 = 0.0
alter Vc0 = 1.8
op
print i(VDD) >> dc_current.txt
alter Va0 = 0.0
alter Va1 = 0.0
alter Va2 = 1.8
alter Va3 = 0.0
alter Vb0 = 0.0
alter Vb1 = 1.8
alter Vb2 = 0.0
alter Vb3 = 0.0
alter Vc0 = 0.0
op
print i(VDD) >> dc_current.txt
alter Va0 = 0.0
alter Va1 = 0.0
alter Va2 = 1.8
alter Va3 = 0.0
alter Vb0 = 0.0
alter Vb1 = 0.0
alter Vb2 = 1.8
alter Vb3 = 1.8
alter Vc0 = 1.8
op
print i(VDD) >> dc_current.txt
alter Va0 = 0.0
alter Va1 = 0.0
alter Va2 = 1.8
alter Va3 = 0.0
alter Vb0 = 0.0
alter Vb1 = 0.0
alter Vb2 = 1.8
alter Vb3 = 1.8
alter Vc0 = 0.0
op
print i(VDD) >> dc_current.txt
alter Va0 = 0.0
alter Va1 = 0.0
alter Va2 = 1.8
alter Va3 = 0.0
alter Vb0 = 0.0
alter Vb1 = 0.0
alter Vb2 = 1.8
alter Vb3 = 0.0
alter Vc0 = 1.8
op
print i(VDD) >> dc_current.txt
alter Va0 = 0.0
alter Va1 = 0.0
alter Va2 = 1.8
alter Va3 = 0.0
alter Vb0 = 0.0
alter Vb1 = 0.0
alter Vb2 = 1.8
alter Vb3 = 0.0
alter Vc0 = 0.0
op
print i(VDD) >> dc_current.txt
alter Va0 = 0.0
alter Va1 = 0.0
alter Va2 = 1.8
alter Va3 = 0.0
alter Vb0 = 0.0
alter Vb1 = 0.0
alter Vb2 = 0.0
alter Vb3 = 1.8
alter Vc0 = 1.8
op
print i(VDD) >> dc_current.txt
alter Va0 = 0.0
alter Va1 = 0.0
alter Va2 = 1.8
alter Va3 = 0.0
alter Vb0 = 0.0
alter Vb1 = 0.0
alter Vb2 = 0.0
alter Vb3 = 1.8
alter Vc0 = 0.0
op
print i(VDD) >> dc_current.txt
alter Va0 = 0.0
alter Va1 = 0.0
alter Va2 = 1.8
alter Va3 = 0.0
alter Vb0 = 0.0
alter Vb1 = 0.0
alter Vb2 = 0.0
alter Vb3 = 0.0
alter Vc0 = 1.8
op
print i(VDD) >> dc_current.txt
alter Va0 = 0.0
alter Va1 = 0.0
alter Va2 = 1.8
alter Va3 = 0.0
alter Vb0 = 0.0
alter Vb1 = 0.0
alter Vb2 = 0.0
alter Vb3 = 0.0
alter Vc0 = 0.0
op
print i(VDD) >> dc_current.txt
alter Va0 = 0.0
alter Va1 = 0.0
alter Va2 = 0.0
alter Va3 = 1.8
alter Vb0 = 1.8
alter Vb1 = 1.8
alter Vb2 = 1.8
alter Vb3 = 1.8
alter Vc0 = 1.8
op
print i(VDD) >> dc_current.txt
alter Va0 = 0.0
alter Va1 = 0.0
alter Va2 = 0.0
alter Va3 = 1.8
alter Vb0 = 1.8
alter Vb1 = 1.8
alter Vb2 = 1.8
alter Vb3 = 1.8
alter Vc0 = 0.0
op
print i(VDD) >> dc_current.txt
alter Va0 = 0.0
alter Va1 = 0.0
alter Va2 = 0.0
alter Va3 = 1.8
alter Vb0 = 1.8
alter Vb1 = 1.8
alter Vb2 = 1.8
alter Vb3 = 0.0
alter Vc0 = 1.8
op
print i(VDD) >> dc_current.txt
alter Va0 = 0.0
alter Va1 = 0.0
alter Va2 = 0.0
alter Va3 = 1.8
alter Vb0 = 1.8
alter Vb1 = 1.8
alter Vb2 = 1.8
alter Vb3 = 0.0
alter Vc0 = 0.0
op
print i(VDD) >> dc_current.txt
alter Va0 = 0.0
alter Va1 = 0.0
alter Va2 = 0.0
alter Va3 = 1.8
alter Vb0 = 1.8
alter Vb1 = 1.8
alter Vb2 = 0.0
alter Vb3 = 1.8
alter Vc0 = 1.8
op
print i(VDD) >> dc_current.txt
alter Va0 = 0.0
alter Va1 = 0.0
alter Va2 = 0.0
alter Va3 = 1.8
alter Vb0 = 1.8
alter Vb1 = 1.8
alter Vb2 = 0.0
alter Vb3 = 1.8
alter Vc0 = 0.0
op
print i(VDD) >> dc_current.txt
alter Va0 = 0.0
alter Va1 = 0.0
alter Va2 = 0.0
alter Va3 = 1.8
alter Vb0 = 1.8
alter Vb1 = 1.8
alter Vb2 = 0.0
alter Vb3 = 0.0
alter Vc0 = 1.8
op
print i(VDD) >> dc_current.txt
alter Va0 = 0.0
alter Va1 = 0.0
alter Va2 = 0.0
alter Va3 = 1.8
alter Vb0 = 1.8
alter Vb1 = 1.8
alter Vb2 = 0.0
alter Vb3 = 0.0
alter Vc0 = 0.0
op
print i(VDD) >> dc_current.txt
alter Va0 = 0.0
alter Va1 = 0.0
alter Va2 = 0.0
alter Va3 = 1.8
alter Vb0 = 1.8
alter Vb1 = 0.0
alter Vb2 = 1.8
alter Vb3 = 1.8
alter Vc0 = 1.8
op
print i(VDD) >> dc_current.txt
alter Va0 = 0.0
alter Va1 = 0.0
alter Va2 = 0.0
alter Va3 = 1.8
alter Vb0 = 1.8
alter Vb1 = 0.0
alter Vb2 = 1.8
alter Vb3 = 1.8
alter Vc0 = 0.0
op
print i(VDD) >> dc_current.txt
alter Va0 = 0.0
alter Va1 = 0.0
alter Va2 = 0.0
alter Va3 = 1.8
alter Vb0 = 1.8
alter Vb1 = 0.0
alter Vb2 = 1.8
alter Vb3 = 0.0
alter Vc0 = 1.8
op
print i(VDD) >> dc_current.txt
alter Va0 = 0.0
alter Va1 = 0.0
alter Va2 = 0.0
alter Va3 = 1.8
alter Vb0 = 1.8
alter Vb1 = 0.0
alter Vb2 = 1.8
alter Vb3 = 0.0
alter Vc0 = 0.0
op
print i(VDD) >> dc_current.txt
alter Va0 = 0.0
alter Va1 = 0.0
alter Va2 = 0.0
alter Va3 = 1.8
alter Vb0 = 1.8
alter Vb1 = 0.0
alter Vb2 = 0.0
alter Vb3 = 1.8
alter Vc0 = 1.8
op
print i(VDD) >> dc_current.txt
alter Va0 = 0.0
alter Va1 = 0.0
alter Va2 = 0.0
alter Va3 = 1.8
alter Vb0 = 1.8
alter Vb1 = 0.0
alter Vb2 = 0.0
alter Vb3 = 1.8
alter Vc0 = 0.0
op
print i(VDD) >> dc_current.txt
alter Va0 = 0.0
alter Va1 = 0.0
alter Va2 = 0.0
alter Va3 = 1.8
alter Vb0 = 1.8
alter Vb1 = 0.0
alter Vb2 = 0.0
alter Vb3 = 0.0
alter Vc0 = 1.8
op
print i(VDD) >> dc_current.txt
alter Va0 = 0.0
alter Va1 = 0.0
alter Va2 = 0.0
alter Va3 = 1.8
alter Vb0 = 1.8
alter Vb1 = 0.0
alter Vb2 = 0.0
alter Vb3 = 0.0
alter Vc0 = 0.0
op
print i(VDD) >> dc_current.txt
alter Va0 = 0.0
alter Va1 = 0.0
alter Va2 = 0.0
alter Va3 = 1.8
alter Vb0 = 0.0
alter Vb1 = 1.8
alter Vb2 = 1.8
alter Vb3 = 1.8
alter Vc0 = 1.8
op
print i(VDD) >> dc_current.txt
alter Va0 = 0.0
alter Va1 = 0.0
alter Va2 = 0.0
alter Va3 = 1.8
alter Vb0 = 0.0
alter Vb1 = 1.8
alter Vb2 = 1.8
alter Vb3 = 1.8
alter Vc0 = 0.0
op
print i(VDD) >> dc_current.txt
alter Va0 = 0.0
alter Va1 = 0.0
alter Va2 = 0.0
alter Va3 = 1.8
alter Vb0 = 0.0
alter Vb1 = 1.8
alter Vb2 = 1.8
alter Vb3 = 0.0
alter Vc0 = 1.8
op
print i(VDD) >> dc_current.txt
alter Va0 = 0.0
alter Va1 = 0.0
alter Va2 = 0.0
alter Va3 = 1.8
alter Vb0 = 0.0
alter Vb1 = 1.8
alter Vb2 = 1.8
alter Vb3 = 0.0
alter Vc0 = 0.0
op
print i(VDD) >> dc_current.txt
alter Va0 = 0.0
alter Va1 = 0.0
alter Va2 = 0.0
alter Va3 = 1.8
alter Vb0 = 0.0
alter Vb1 = 1.8
alter Vb2 = 0.0
alter Vb3 = 1.8
alter Vc0 = 1.8
op
print i(VDD) >> dc_current.txt
alter Va0 = 0.0
alter Va1 = 0.0
alter Va2 = 0.0
alter Va3 = 1.8
alter Vb0 = 0.0
alter Vb1 = 1.8
alter Vb2 = 0.0
alter Vb3 = 1.8
alter Vc0 = 0.0
op
print i(VDD) >> dc_current.txt
alter Va0 = 0.0
alter Va1 = 0.0
alter Va2 = 0.0
alter Va3 = 1.8
alter Vb0 = 0.0
alter Vb1 = 1.8
alter Vb2 = 0.0
alter Vb3 = 0.0
alter Vc0 = 1.8
op
print i(VDD) >> dc_current.txt
alter Va0 = 0.0
alter Va1 = 0.0
alter Va2 = 0.0
alter Va3 = 1.8
alter Vb0 = 0.0
alter Vb1 = 1.8
alter Vb2 = 0.0
alter Vb3 = 0.0
alter Vc0 = 0.0
op
print i(VDD) >> dc_current.txt
alter Va0 = 0.0
alter Va1 = 0.0
alter Va2 = 0.0
alter Va3 = 1.8
alter Vb0 = 0.0
alter Vb1 = 0.0
alter Vb2 = 1.8
alter Vb3 = 1.8
alter Vc0 = 1.8
op
print i(VDD) >> dc_current.txt
alter Va0 = 0.0
alter Va1 = 0.0
alter Va2 = 0.0
alter Va3 = 1.8
alter Vb0 = 0.0
alter Vb1 = 0.0
alter Vb2 = 1.8
alter Vb3 = 1.8
alter Vc0 = 0.0
op
print i(VDD) >> dc_current.txt
alter Va0 = 0.0
alter Va1 = 0.0
alter Va2 = 0.0
alter Va3 = 1.8
alter Vb0 = 0.0
alter Vb1 = 0.0
alter Vb2 = 1.8
alter Vb3 = 0.0
alter Vc0 = 1.8
op
print i(VDD) >> dc_current.txt
alter Va0 = 0.0
alter Va1 = 0.0
alter Va2 = 0.0
alter Va3 = 1.8
alter Vb0 = 0.0
alter Vb1 = 0.0
alter Vb2 = 1.8
alter Vb3 = 0.0
alter Vc0 = 0.0
op
print i(VDD) >> dc_current.txt
alter Va0 = 0.0
alter Va1 = 0.0
alter Va2 = 0.0
alter Va3 = 1.8
alter Vb0 = 0.0
alter Vb1 = 0.0
alter Vb2 = 0.0
alter Vb3 = 1.8
alter Vc0 = 1.8
op
print i(VDD) >> dc_current.txt
alter Va0 = 0.0
alter Va1 = 0.0
alter Va2 = 0.0
alter Va3 = 1.8
alter Vb0 = 0.0
alter Vb1 = 0.0
alter Vb2 = 0.0
alter Vb3 = 1.8
alter Vc0 = 0.0
op
print i(VDD) >> dc_current.txt
alter Va0 = 0.0
alter Va1 = 0.0
alter Va2 = 0.0
alter Va3 = 1.8
alter Vb0 = 0.0
alter Vb1 = 0.0
alter Vb2 = 0.0
alter Vb3 = 0.0
alter Vc0 = 1.8
op
print i(VDD) >> dc_current.txt
alter Va0 = 0.0
alter Va1 = 0.0
alter Va2 = 0.0
alter Va3 = 1.8
alter Vb0 = 0.0
alter Vb1 = 0.0
alter Vb2 = 0.0
alter Vb3 = 0.0
alter Vc0 = 0.0
op
print i(VDD) >> dc_current.txt
alter Va0 = 0.0
alter Va1 = 0.0
alter Va2 = 0.0
alter Va3 = 0.0
alter Vb0 = 1.8
alter Vb1 = 1.8
alter Vb2 = 1.8
alter Vb3 = 1.8
alter Vc0 = 1.8
op
print i(VDD) >> dc_current.txt
alter Va0 = 0.0
alter Va1 = 0.0
alter Va2 = 0.0
alter Va3 = 0.0
alter Vb0 = 1.8
alter Vb1 = 1.8
alter Vb2 = 1.8
alter Vb3 = 1.8
alter Vc0 = 0.0
op
print i(VDD) >> dc_current.txt
alter Va0 = 0.0
alter Va1 = 0.0
alter Va2 = 0.0
alter Va3 = 0.0
alter Vb0 = 1.8
alter Vb1 = 1.8
alter Vb2 = 1.8
alter Vb3 = 0.0
alter Vc0 = 1.8
op
print i(VDD) >> dc_current.txt
alter Va0 = 0.0
alter Va1 = 0.0
alter Va2 = 0.0
alter Va3 = 0.0
alter Vb0 = 1.8
alter Vb1 = 1.8
alter Vb2 = 1.8
alter Vb3 = 0.0
alter Vc0 = 0.0
op
print i(VDD) >> dc_current.txt
alter Va0 = 0.0
alter Va1 = 0.0
alter Va2 = 0.0
alter Va3 = 0.0
alter Vb0 = 1.8
alter Vb1 = 1.8
alter Vb2 = 0.0
alter Vb3 = 1.8
alter Vc0 = 1.8
op
print i(VDD) >> dc_current.txt
alter Va0 = 0.0
alter Va1 = 0.0
alter Va2 = 0.0
alter Va3 = 0.0
alter Vb0 = 1.8
alter Vb1 = 1.8
alter Vb2 = 0.0
alter Vb3 = 1.8
alter Vc0 = 0.0
op
print i(VDD) >> dc_current.txt
alter Va0 = 0.0
alter Va1 = 0.0
alter Va2 = 0.0
alter Va3 = 0.0
alter Vb0 = 1.8
alter Vb1 = 1.8
alter Vb2 = 0.0
alter Vb3 = 0.0
alter Vc0 = 1.8
op
print i(VDD) >> dc_current.txt
alter Va0 = 0.0
alter Va1 = 0.0
alter Va2 = 0.0
alter Va3 = 0.0
alter Vb0 = 1.8
alter Vb1 = 1.8
alter Vb2 = 0.0
alter Vb3 = 0.0
alter Vc0 = 0.0
op
print i(VDD) >> dc_current.txt
alter Va0 = 0.0
alter Va1 = 0.0
alter Va2 = 0.0
alter Va3 = 0.0
alter Vb0 = 1.8
alter Vb1 = 0.0
alter Vb2 = 1.8
alter Vb3 = 1.8
alter Vc0 = 1.8
op
print i(VDD) >> dc_current.txt
alter Va0 = 0.0
alter Va1 = 0.0
alter Va2 = 0.0
alter Va3 = 0.0
alter Vb0 = 1.8
alter Vb1 = 0.0
alter Vb2 = 1.8
alter Vb3 = 1.8
alter Vc0 = 0.0
op
print i(VDD) >> dc_current.txt
alter Va0 = 0.0
alter Va1 = 0.0
alter Va2 = 0.0
alter Va3 = 0.0
alter Vb0 = 1.8
alter Vb1 = 0.0
alter Vb2 = 1.8
alter Vb3 = 0.0
alter Vc0 = 1.8
op
print i(VDD) >> dc_current.txt
alter Va0 = 0.0
alter Va1 = 0.0
alter Va2 = 0.0
alter Va3 = 0.0
alter Vb0 = 1.8
alter Vb1 = 0.0
alter Vb2 = 1.8
alter Vb3 = 0.0
alter Vc0 = 0.0
op
print i(VDD) >> dc_current.txt
alter Va0 = 0.0
alter Va1 = 0.0
alter Va2 = 0.0
alter Va3 = 0.0
alter Vb0 = 1.8
alter Vb1 = 0.0
alter Vb2 = 0.0
alter Vb3 = 1.8
alter Vc0 = 1.8
op
print i(VDD) >> dc_current.txt
alter Va0 = 0.0
alter Va1 = 0.0
alter Va2 = 0.0
alter Va3 = 0.0
alter Vb0 = 1.8
alter Vb1 = 0.0
alter Vb2 = 0.0
alter Vb3 = 1.8
alter Vc0 = 0.0
op
print i(VDD) >> dc_current.txt
alter Va0 = 0.0
alter Va1 = 0.0
alter Va2 = 0.0
alter Va3 = 0.0
alter Vb0 = 1.8
alter Vb1 = 0.0
alter Vb2 = 0.0
alter Vb3 = 0.0
alter Vc0 = 1.8
op
print i(VDD) >> dc_current.txt
alter Va0 = 0.0
alter Va1 = 0.0
alter Va2 = 0.0
alter Va3 = 0.0
alter Vb0 = 1.8
alter Vb1 = 0.0
alter Vb2 = 0.0
alter Vb3 = 0.0
alter Vc0 = 0.0
op
print i(VDD) >> dc_current.txt
alter Va0 = 0.0
alter Va1 = 0.0
alter Va2 = 0.0
alter Va3 = 0.0
alter Vb0 = 0.0
alter Vb1 = 1.8
alter Vb2 = 1.8
alter Vb3 = 1.8
alter Vc0 = 1.8
op
print i(VDD) >> dc_current.txt
alter Va0 = 0.0
alter Va1 = 0.0
alter Va2 = 0.0
alter Va3 = 0.0
alter Vb0 = 0.0
alter Vb1 = 1.8
alter Vb2 = 1.8
alter Vb3 = 1.8
alter Vc0 = 0.0
op
print i(VDD) >> dc_current.txt
alter Va0 = 0.0
alter Va1 = 0.0
alter Va2 = 0.0
alter Va3 = 0.0
alter Vb0 = 0.0
alter Vb1 = 1.8
alter Vb2 = 1.8
alter Vb3 = 0.0
alter Vc0 = 1.8
op
print i(VDD) >> dc_current.txt
alter Va0 = 0.0
alter Va1 = 0.0
alter Va2 = 0.0
alter Va3 = 0.0
alter Vb0 = 0.0
alter Vb1 = 1.8
alter Vb2 = 1.8
alter Vb3 = 0.0
alter Vc0 = 0.0
op
print i(VDD) >> dc_current.txt
alter Va0 = 0.0
alter Va1 = 0.0
alter Va2 = 0.0
alter Va3 = 0.0
alter Vb0 = 0.0
alter Vb1 = 1.8
alter Vb2 = 0.0
alter Vb3 = 1.8
alter Vc0 = 1.8
op
print i(VDD) >> dc_current.txt
alter Va0 = 0.0
alter Va1 = 0.0
alter Va2 = 0.0
alter Va3 = 0.0
alter Vb0 = 0.0
alter Vb1 = 1.8
alter Vb2 = 0.0
alter Vb3 = 1.8
alter Vc0 = 0.0
op
print i(VDD) >> dc_current.txt
alter Va0 = 0.0
alter Va1 = 0.0
alter Va2 = 0.0
alter Va3 = 0.0
alter Vb0 = 0.0
alter Vb1 = 1.8
alter Vb2 = 0.0
alter Vb3 = 0.0
alter Vc0 = 1.8
op
print i(VDD) >> dc_current.txt
alter Va0 = 0.0
alter Va1 = 0.0
alter Va2 = 0.0
alter Va3 = 0.0
alter Vb0 = 0.0
alter Vb1 = 1.8
alter Vb2 = 0.0
alter Vb3 = 0.0
alter Vc0 = 0.0
op
print i(VDD) >> dc_current.txt
alter Va0 = 0.0
alter Va1 = 0.0
alter Va2 = 0.0
alter Va3 = 0.0
alter Vb0 = 0.0
alter Vb1 = 0.0
alter Vb2 = 1.8
alter Vb3 = 1.8
alter Vc0 = 1.8
op
print i(VDD) >> dc_current.txt
alter Va0 = 0.0
alter Va1 = 0.0
alter Va2 = 0.0
alter Va3 = 0.0
alter Vb0 = 0.0
alter Vb1 = 0.0
alter Vb2 = 1.8
alter Vb3 = 1.8
alter Vc0 = 0.0
op
print i(VDD) >> dc_current.txt
alter Va0 = 0.0
alter Va1 = 0.0
alter Va2 = 0.0
alter Va3 = 0.0
alter Vb0 = 0.0
alter Vb1 = 0.0
alter Vb2 = 1.8
alter Vb3 = 0.0
alter Vc0 = 1.8
op
print i(VDD) >> dc_current.txt
alter Va0 = 0.0
alter Va1 = 0.0
alter Va2 = 0.0
alter Va3 = 0.0
alter Vb0 = 0.0
alter Vb1 = 0.0
alter Vb2 = 1.8
alter Vb3 = 0.0
alter Vc0 = 0.0
op
print i(VDD) >> dc_current.txt
alter Va0 = 0.0
alter Va1 = 0.0
alter Va2 = 0.0
alter Va3 = 0.0
alter Vb0 = 0.0
alter Vb1 = 0.0
alter Vb2 = 0.0
alter Vb3 = 1.8
alter Vc0 = 1.8
op
print i(VDD) >> dc_current.txt
alter Va0 = 0.0
alter Va1 = 0.0
alter Va2 = 0.0
alter Va3 = 0.0
alter Vb0 = 0.0
alter Vb1 = 0.0
alter Vb2 = 0.0
alter Vb3 = 1.8
alter Vc0 = 0.0
op
print i(VDD) >> dc_current.txt
alter Va0 = 0.0
alter Va1 = 0.0
alter Va2 = 0.0
alter Va3 = 0.0
alter Vb0 = 0.0
alter Vb1 = 0.0
alter Vb2 = 0.0
alter Vb3 = 0.0
alter Vc0 = 1.8
op
print i(VDD) >> dc_current.txt
alter Va0 = 0.0
alter Va1 = 0.0
alter Va2 = 0.0
alter Va3 = 0.0
alter Vb0 = 0.0
alter Vb1 = 0.0
alter Vb2 = 0.0
alter Vb3 = 0.0
alter Vc0 = 0.0
op
print i(VDD) >> dc_current.txt
quit
.endc
.end
