* NGSPICE file created from carry_gate_n1_i2.ext - technology: scmos

.global Vdd Gnd

.subckt carry_gate_n1_i2 cin_hi cout_lo mode vdd gnd
M1000 gn modeb vdd vdd pfet w=1.8u l=0.18u
+  ad=0.81p pd=4.5u as=0.567p ps=2.43u
M1001 gnd gn cin_hi Gnd nfet w=1.8u l=0.18u
+  ad=0.81p pd=4.5u as=0.972p ps=4.68u
M1002 gnd modeb a_34_10# Gnd nfet w=1.8u l=0.18u
+  ad=0.81p pd=4.5u as=0.567p ps=2.43u
M1003 gnd mode modeb Gnd nfet w=0.9u l=0.18u
+  ad=0.405p pd=2.7u as=0.486p ps=2.88u
M1004 vdd mode modeb vdd pfet w=1.8u l=0.18u
+  ad=0.81p pd=4.5u as=0.972p ps=4.68u
M1005 vdd cout_lo gn vdd pfet w=1.8u l=0.18u
+  ad=0.567p pd=2.43u as=0.972p ps=4.68u
M1006 vdd gn cin_hi vdd pfet w=3.6u l=0.18u
+  ad=1.62p pd=8.1u as=1.944p ps=8.28u
M1007 a_34_10# cout_lo gn Gnd nfet w=1.8u l=0.18u
+  ad=0.567p pd=2.43u as=0.972p ps=4.68u
C0 vdd cout_lo 0.02227f
C1 modeb gnd 0.08604f
C2 gn cout_lo 0.43448f
C3 modeb mode 0.35567f
C4 gn a_34_10# 0
C5 cout_lo gnd 0.00105f
C6 a_34_10# gnd 0
C7 vdd cin_hi 0.38429f
C8 mode cout_lo 0.00894f
C9 modeb cout_lo 0.20481f
C10 gn cin_hi 0.30097f
C11 gn vdd 0.54273f
C12 cin_hi gnd 0.37153f
C13 mode cin_hi 0.06144f
C14 vdd mode 0.02136f
C15 gn gnd 0.20963f
C16 modeb vdd 0.19844f
C17 gn mode 0.40142f
C18 gn modeb 0.09068f
C19 cout_lo cin_hi 0.07805f
C20 mode gnd 0.00153f
.ends
