* pg0_post-layout
.include ../../part1/spice/models/TSMC_180nm.txt
.options reltol=1e-4
VDD vdd gnd 1.8
* NGSPICE file created from pg0_b.ext - technology: scmos

.subckt pg0_b a0 b0 g0b p0 p0b t0b vdd gnd
M1000 a_106_103# a0 vdd vdd CMOSP w=1.44u l=0.18u
+  ad=0.4536p pd=2.07u as=0.7776p ps=3.96u
M1001 a_43_103# a0 vdd vdd CMOSP w=5.58u l=0.18u
+  ad=1.7577p pd=6.21u as=3.0132p ps=12.24u
M1002 vdd g0b p0b vdd CMOSP w=0.72u l=0.18u
+  ad=0.324p pd=2.34u as=0.3888p ps=2.07u
M1003 oai0_xn1 b0 p0b Gnd CMOSN w=0.72u l=0.18u
+  ad=0.2268p pd=1.35u as=0.2268p ps=1.35u
M1004 gnd a0 t0b Gnd CMOSN w=1.44u l=0.18u
+  ad=0.4536p pd=2.07u as=0.7776p ps=3.96u
M1005 gnd g0b oai0_xn1 Gnd CMOSN w=0.72u l=0.18u
+  ad=0.324p pd=2.34u as=0.2268p ps=1.35u
M1006 a_70_27# a0 p0 Gnd CMOSN w=0.72u l=0.18u
+  ad=0.2268p pd=1.35u as=0.3888p ps=2.52u
M1007 vdd a0 g0b vdd CMOSP w=2.25u l=0.18u
+  ad=0.7047p pd=2.88u as=1.215p ps=5.58u
M1008 aoi0_xp1 b0 vdd vdd CMOSP w=1.44u l=0.18u
+  ad=0.4536p pd=2.07u as=0.4536p ps=2.07u
M1009 t0b b0 gnd Gnd CMOSN w=1.44u l=0.18u
+  ad=0.648p pd=3.78u as=0.4536p ps=2.07u
M1010 p0 t0b gnd Gnd CMOSN w=0.36u l=0.18u
+  ad=0.162p pd=1.62u as=0.1944p ps=1.35u
M1011 p0b b0 a_106_103# vdd CMOSP w=1.44u l=0.18u
+  ad=0.3888p pd=2.07u as=0.4536p ps=2.07u
M1012 a_16_10# a0 g0b Gnd CMOSN w=2.25u l=0.18u
+  ad=0.7047p pd=2.88u as=1.215p ps=5.58u
M1013 gnd b0 a_70_27# Gnd CMOSN w=0.72u l=0.18u
+  ad=0.1944p pd=1.35u as=0.2268p ps=1.35u
M1014 t0b b0 a_43_103# vdd CMOSP w=5.58u l=0.18u
+  ad=2.511p pd=12.06u as=1.7577p ps=6.21u
M1015 gnd b0 a_16_10# Gnd CMOSN w=2.25u l=0.18u
+  ad=1.0125p pd=5.4u as=0.7047p ps=2.88u
M1016 vdd a0 aoi0_xp1 vdd CMOSP w=1.44u l=0.18u
+  ad=0.4536p pd=2.07u as=0.7776p ps=3.96u
M1017 p0b a0 oai0_xn1 Gnd CMOSN w=0.72u l=0.18u
+  ad=0.2268p pd=1.35u as=0.3888p ps=2.52u
M1018 g0b b0 vdd vdd CMOSP w=2.25u l=0.18u
+  ad=1.0125p pd=5.4u as=0.7047p ps=2.88u
M1019 p0 t0b aoi0_xp1 vdd CMOSP w=1.44u l=0.18u
+  ad=0.648p pd=3.78u as=0.4536p ps=2.07u
C0 a_70_27# gnd 0
C1 vdd p0 0.14324f
C2 oai0_xn1 p0b 0.62747f
C3 a0 t0b 0.04859f
C4 b0 g0b 0.28588f
C5 vdd b0 0.0808f
C6 a_106_103# p0b 0
C7 oai0_xn1 g0b 0.15985f
C8 aoi0_xp1 t0b 0.23065f
C9 aoi0_xp1 a0 0.01183f
C10 a_106_103# vdd 0
C11 p0 gnd 0.03306f
C12 b0 gnd 0.00719f
C13 t0b p0 0.56955f
C14 g0b p0b 0.08267f
C15 b0 t0b 0.88497f
C16 vdd p0b 0.14385f
C17 oai0_xn1 gnd 0.06612f
C18 a0 p0 0.02977f
C19 a_70_27# p0 0
C20 a0 b0 1.92212f
C21 vdd g0b 0.66386f
C22 oai0_xn1 a0 0.02027f
C23 a_16_10# g0b 0
C24 aoi0_xp1 p0 0.4769f
C25 aoi0_xp1 b0 0.01183f
C26 a_43_103# vdd 0.00156f
C27 g0b gnd 0.04266f
C28 a0 p0b 0.00644f
C29 b0 p0 0.02787f
C30 g0b t0b 0.24926f
C31 a_16_10# gnd 0
C32 vdd t0b 0.07446f
C33 oai0_xn1 p0 0.19757f
C34 a0 g0b 1.06204f
C35 oai0_xn1 b0 0.21867f
C36 vdd a0 0.08888f
C37 a_43_103# t0b 0.00176f
C38 aoi0_xp1 vdd 0.28719f
C39 t0b gnd 0.39748f
C40 a0 gnd 0.00307f
C41 b0 p0b 0.02342f
C42 g0b p0 0.1561f
.ends

.subckt pg0x_post a0 b0 g0b p0 p0b t0b vdd gnd
X0 a0 b0 g0b p0 p0b t0b vdd gnd pg0_b
.ends
.subckt tb_x1 a y vdd gnd
mp y a vdd vdd CMOSP W=1.8e-06 L=1.8e-07 AS=9.72e-13 PS=4.68e-06 AD=9.72e-13 PD=4.68e-06
mn y a gnd gnd CMOSN W=9.0e-07 L=1.8e-07 AS=4.86e-13 PS=2.88e-06 AD=4.86e-13 PD=2.88e-06
.ends
.subckt tb_x2 a y vdd gnd
mp y a vdd vdd CMOSP W=3.6e-06 L=1.8e-07 AS=1.944e-12 PS=8.28e-06 AD=1.944e-12 PD=8.28e-06
mn y a gnd gnd CMOSN W=1.8e-06 L=1.8e-07 AS=9.72e-13 PS=4.68e-06 AD=9.72e-13 PD=4.68e-06
.ends
Va0 src_a0 gnd PWL(
+ 0.00000e+00 0.000 1.00000e-09 0.000 1.02000e-09 1.800 2.00000e-09 1.800 2.02000e-09 0.000 4.00000e-09 0.000
+ 4.02000e-09 1.800 7.00000e-09 1.800 7.02000e-09 0.000 9.00000e-09 0.000
+ )
Xs_a0 src_a0 drv_a0 vdd gnd tb_x1
Xd_a0 drv_a0 a0 vdd gnd tb_x2
Vb0 src_b0 gnd PWL(
+ 0.00000e+00 0.000 3.00000e-09 0.000 3.02000e-09 1.800 5.00000e-09 1.800 5.02000e-09 0.000 6.00000e-09 0.000
+ 6.02000e-09 1.800 8.00000e-09 1.800 8.02000e-09 0.000 9.00000e-09 0.000
+ )
Xs_b0 src_b0 drv_b0 vdd gnd tb_x1
Xd_b0 drv_b0 b0 vdd gnd tb_x2
Xl_g0b g0b lo_g0b vdd gnd tb_x1
Xl_p0 p0 lo_p0 vdd gnd tb_x1
Xl_p0b p0b lo_p0b vdd gnd tb_x1
Xl_t0b t0b lo_t0b vdd gnd tb_x1
X0 a0 b0 g0b p0 p0b t0b vdd gnd pg0x_post
.tran 5p 9.00000e-09
.control
set wr_singlescale
set wr_vecnames
run
wrdata pg0_post-layout.txt v(a0) v(b0) v(g0b) v(p0) v(p0b) v(t0b)
quit
.endc
.end
