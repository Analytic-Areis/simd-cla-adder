* NGSPICE file created from flow_inv.ext - technology: scmos

.global Vdd Gnd

.subckt flow_inv in out vdd gnd
M1000 out in gnd Gnd nfet w=0.9u l=0.18u
+  ad=0.486p pd=2.88u as=0.486p ps=2.88u
M1001 out in vdd vdd pfet w=1.8u l=0.18u
+  ad=0.972p pd=4.68u as=0.972p ps=4.68u
C0 out gnd 0.09647f
C1 vdd out 0.17436f
C2 in out 0.04753f
C3 in gnd 0.03553f
C4 vdd in 0.04656f
.ends
