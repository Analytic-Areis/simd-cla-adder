* block timing sum3_post
.include ../../../spice/models/TSMC_180nm.txt
.options reltol=1e-4
VDD vdd gnd 1.8
* NGSPICE file created from sum3_b.ext - technology: scmos

.subckt sum3_b c3 p3 p3b s3 vdd gnd
M1000 vdd c3 x3_s1xp1 vdd CMOSP w=1.8u l=0.18u
+  ad=0.81p pd=4.5u as=0.567p ps=2.43u
M1001 vdd c3 x3_cb vdd CMOSP w=1.8u l=0.18u
+  ad=0.567p pd=2.43u as=0.972p ps=4.68u
M1002 gnd x3_cb a_34_10# Gnd CMOSN w=0.9u l=0.18u
+  ad=0.2835p pd=1.53u as=0.2835p ps=1.53u
M1003 x3_s1xp1 p3 vdd vdd CMOSP w=1.8u l=0.18u
+  ad=0.567p pd=2.43u as=0.567p ps=2.43u
M1004 x3_cb c3 gnd Gnd CMOSN w=0.9u l=0.18u
+  ad=0.405p pd=2.7u as=0.2835p ps=1.53u
M1005 s3 p3b x3_s1xp1 vdd CMOSP w=1.8u l=0.18u
+  ad=0.567p pd=2.43u as=0.567p ps=2.43u
M1006 a_16_10# c3 gnd Gnd CMOSN w=0.9u l=0.18u
+  ad=0.2835p pd=1.53u as=0.486p ps=2.88u
M1007 x3_s1xp1 x3_cb s3 vdd CMOSP w=1.8u l=0.18u
+  ad=0.567p pd=2.43u as=0.567p ps=2.43u
M1008 s3 p3 a_16_10# Gnd CMOSN w=0.9u l=0.18u
+  ad=0.2835p pd=1.53u as=0.2835p ps=1.53u
M1009 a_34_10# p3b s3 Gnd CMOSN w=0.9u l=0.18u
+  ad=0.2835p pd=1.53u as=0.2835p ps=1.53u
C0 p3 gnd 0.00105f
C1 p3b s3 0.09187f
C2 a_34_10# gnd 0
C3 vdd s3 0.05237f
C4 c3 p3b 0.01832f
C5 vdd c3 0.04444f
C6 x3_s1xp1 s3 0.73152f
C7 x3_cb gnd 0.12649f
C8 x3_s1xp1 c3 0.00492f
C9 x3_cb p3 0.01812f
C10 p3b gnd 0.00105f
C11 c3 s3 0.0228f
C12 p3 p3b 0.2539f
C13 a_16_10# s3 0
C14 vdd p3 0.02202f
C15 x3_s1xp1 p3 0.00494f
C16 x3_cb p3b 0.26268f
C17 x3_cb vdd 0.23817f
C18 x3_cb x3_s1xp1 0.01217f
C19 s3 gnd 0.04131f
C20 c3 gnd 0.00516f
C21 p3 s3 0.15839f
C22 a_34_10# s3 0
C23 a_16_10# gnd 0
C24 c3 p3 0.59372f
C25 vdd p3b 0.02078f
C26 x3_s1xp1 p3b 0.27667f
C27 x3_cb s3 0.08337f
C28 x3_s1xp1 vdd 0.43592f
C29 x3_cb c3 0.71543f
.ends

.subckt sum3x_post c3 p3 p3b s3 vdd gnd
X0 c3 p3 p3b s3 vdd gnd sum3_b
.ends
.subckt tb_x1 a y vdd gnd
mp y a vdd vdd CMOSP W=1.8e-06 L=1.8e-07 AS=9.72e-13 PS=4.68e-06 AD=9.72e-13 PD=4.68e-06
mn y a gnd gnd CMOSN W=9.0e-07 L=1.8e-07 AS=4.86e-13 PS=2.88e-06 AD=4.86e-13 PD=2.88e-06
.ends
Vc3 src_c3 gnd PWL(
+ 0.00000e+00 1.800 2.00000e-09 1.800 2.02000e-09 0.000 4.00000e-09 0.000 4.02000e-09 1.800 8.00000e-09 1.800
+ 8.02000e-09 0.000 1.40000e-08 0.000 1.40200e-08 1.800 1.80000e-08 1.800
+ )
Xd_c3 src_c3 c3 vdd gnd tb_x1
Vp3 src_p3 gnd PWL(
+ 0.00000e+00 1.800 6.00000e-09 1.800 6.02000e-09 0.000 1.00000e-08 0.000 1.00200e-08 1.800 1.20000e-08 1.800
+ 1.20200e-08 0.000 1.60000e-08 0.000 1.60200e-08 1.800 1.80000e-08 1.800
+ )
Xd_p3 src_p3 p3 vdd gnd tb_x1
Vp3b src_p3b gnd PWL(
+ 0.00000e+00 0.000 6.00000e-09 0.000 6.02000e-09 1.800 1.00000e-08 1.800 1.00200e-08 0.000 1.20000e-08 0.000
+ 1.20200e-08 1.800 1.60000e-08 1.800 1.60200e-08 0.000 1.80000e-08 0.000
+ )
Xd_p3b src_p3b p3b vdd gnd tb_x1
Xl_s3 s3 lo_s3 vdd gnd tb_x1
X0 c3 p3 p3b s3 vdd gnd sum3x_post
.tran 20p 1.80000e-08
.control
set wr_singlescale
set wr_vecnames
run
wrdata sum3_post.txt v(c3) v(p3) v(p3b) v(s3)
quit
.endc
.end
