* NGSPICE file created from aoi21_x1.ext - technology: scmos

.global Vdd Gnd

.subckt aoi21_x1 a b c y vdd gnd
M1000 vdd a a_8_89# vdd pfet w=3.6u l=0.18u
+  ad=1.134p pd=4.23u as=1.944p ps=8.28u
M1001 a_16_10# a y Gnd nfet w=1.8u l=0.18u
+  ad=0.567p pd=2.43u as=0.972p ps=4.68u
M1002 a_8_89# b vdd vdd pfet w=3.6u l=0.18u
+  ad=1.134p pd=4.23u as=1.134p ps=4.23u
M1003 y c gnd Gnd nfet w=0.9u l=0.18u
+  ad=0.405p pd=2.7u as=0.486p ps=2.43u
M1004 gnd b a_16_10# Gnd nfet w=1.8u l=0.18u
+  ad=0.486p pd=2.43u as=0.567p ps=2.43u
M1005 y c a_8_89# vdd pfet w=3.6u l=0.18u
+  ad=1.62p pd=8.1u as=1.134p ps=4.23u
C0 a_8_89# vdd 0.76889f
C1 c gnd 0.00153f
C2 a y 0.03495f
C3 b c 0.49441f
C4 a_8_89# y 0.74572f
C5 vdd b 0.02364f
C6 a_8_89# a 0.2101f
C7 y gnd 0.12393f
C8 a gnd 0.00105f
C9 b y 0.01847f
C10 a_16_10# y 0
C11 a b 0.50392f
C12 vdd c 0.02098f
C13 a_8_89# b 0.02294f
C14 b gnd 0.00339f
C15 c y 0.09472f
C16 a_16_10# gnd 0
C17 vdd y 0.05392f
C18 a c 0.00926f
C19 vdd a 0.02383f
C20 a_8_89# c 0.00745f
.ends
