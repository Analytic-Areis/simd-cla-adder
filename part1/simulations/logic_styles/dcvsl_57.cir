* DCVSL {'k': 3, 'r': 1, 'buf': 2}
.include ../../spice/models/TSMC_180nm.txt
.options reltol=1e-4
VDD vdd_core gnd 1.8
Vsense vdd_core vdd 0
VTB vtb gnd 1.8
Vg g gnd 0
Vt t gnd 1.8
Vgb gb gnd 1.8
Vtbar tb gnd 0
Vp p gnd 1.8
Vpb pb gnd 0
Va a gnd 1.8
Vab ab gnd 0
Vs s gnd PWL(0 0 1n 0 1.015n 1.8 3n 1.8 3.015n 0 5n 0 5.015n 1.8 7n 1.8 7.015n 0 9n 0)
Vsb sb gnd PWL(0 1.8 1n 1.8 1.015n 0 3n 0 3.015n 1.8 5n 1.8 5.015n 0 7n 0 7.015n 1.8 9n 1.8)
MD0 s1 s vtb vtb CMOSP W=1.800u L=0.18u AS=0.8100p AD=0.8100p PS=4.500u PD=4.500u
MD1 s1 s gnd gnd CMOSN W=0.900u L=0.18u AS=0.4050p AD=0.4050p PS=2.700u PD=2.700u
MD2 c0 s1 vtb vtb CMOSP W=3.600u L=0.18u AS=1.6200p AD=1.6200p PS=8.100u PD=8.100u
MD3 c0 s1 gnd gnd CMOSN W=1.800u L=0.18u AS=0.8100p AD=0.8100p PS=4.500u PD=4.500u
MD4 sb1 sb vtb vtb CMOSP W=1.800u L=0.18u AS=0.8100p AD=0.8100p PS=4.500u PD=4.500u
MD5 sb1 sb gnd gnd CMOSN W=0.900u L=0.18u AS=0.4050p AD=0.4050p PS=2.700u PD=2.700u
MD6 c0b sb1 vtb vtb CMOSP W=3.600u L=0.18u AS=1.6200p AD=1.6200p PS=8.100u PD=8.100u
MD7 c0b sb1 gnd gnd CMOSN W=1.800u L=0.18u AS=0.8100p AD=0.8100p PS=4.500u PD=4.500u
MD8 ld0_0 c1 vtb vtb CMOSP W=1.800u L=0.18u AS=0.8100p AD=0.8100p PS=4.500u PD=4.500u
MD9 ld0_0 c1 gnd gnd CMOSN W=0.900u L=0.18u AS=0.4050p AD=0.4050p PS=2.700u PD=2.700u
MD10 ldb0_0 c1b vtb vtb CMOSP W=1.800u L=0.18u AS=0.8100p AD=0.8100p PS=4.500u PD=4.500u
MD11 ldb0_0 c1b gnd gnd CMOSN W=0.900u L=0.18u AS=0.4050p AD=0.4050p PS=2.700u PD=2.700u
MD12 ld1_0 c2 vtb vtb CMOSP W=1.800u L=0.18u AS=0.8100p AD=0.8100p PS=4.500u PD=4.500u
MD13 ld1_0 c2 gnd gnd CMOSN W=0.900u L=0.18u AS=0.4050p AD=0.4050p PS=2.700u PD=2.700u
MD14 ldb1_0 c2b vtb vtb CMOSP W=1.800u L=0.18u AS=0.8100p AD=0.8100p PS=4.500u PD=4.500u
MD15 ldb1_0 c2b gnd gnd CMOSN W=0.900u L=0.18u AS=0.4050p AD=0.4050p PS=2.700u PD=2.700u
MD16 ld2_0 c3 vtb vtb CMOSP W=1.800u L=0.18u AS=0.8100p AD=0.8100p PS=4.500u PD=4.500u
MD17 ld2_0 c3 gnd gnd CMOSN W=0.900u L=0.18u AS=0.4050p AD=0.4050p PS=2.700u PD=2.700u
MD18 ldb2_0 c3b vtb vtb CMOSP W=1.800u L=0.18u AS=0.8100p AD=0.8100p PS=4.500u PD=4.500u
MD19 ldb2_0 c3b gnd gnd CMOSN W=0.900u L=0.18u AS=0.4050p AD=0.4050p PS=2.700u PD=2.700u
MD20 ld3_0 c4 vtb vtb CMOSP W=1.800u L=0.18u AS=0.8100p AD=0.8100p PS=4.500u PD=4.500u
MD21 ld3_0 c4 gnd gnd CMOSN W=0.900u L=0.18u AS=0.4050p AD=0.4050p PS=2.700u PD=2.700u
MD22 ldb3_0 c4b vtb vtb CMOSP W=1.800u L=0.18u AS=0.8100p AD=0.8100p PS=4.500u PD=4.500u
MD23 ldb3_0 c4b gnd gnd CMOSN W=0.900u L=0.18u AS=0.4050p AD=0.4050p PS=2.700u PD=2.700u
MD24 ld3_1 c4 vtb vtb CMOSP W=1.800u L=0.18u AS=0.8100p AD=0.8100p PS=4.500u PD=4.500u
MD25 ld3_1 c4 gnd gnd CMOSN W=0.900u L=0.18u AS=0.4050p AD=0.4050p PS=2.700u PD=2.700u
MD26 ldb3_1 c4b vtb vtb CMOSP W=1.800u L=0.18u AS=0.8100p AD=0.8100p PS=4.500u PD=4.500u
MD27 ldb3_1 c4b gnd gnd CMOSN W=0.900u L=0.18u AS=0.4050p AD=0.4050p PS=2.700u PD=2.700u
MD28 ld3_2 c4 vtb vtb CMOSP W=1.800u L=0.18u AS=0.8100p AD=0.8100p PS=4.500u PD=4.500u
MD29 ld3_2 c4 gnd gnd CMOSN W=0.900u L=0.18u AS=0.4050p AD=0.4050p PS=2.700u PD=2.700u
MD30 ldb3_2 c4b vtb vtb CMOSP W=1.800u L=0.18u AS=0.8100p AD=0.8100p PS=4.500u PD=4.500u
MD31 ldb3_2 c4b gnd gnd CMOSN W=0.900u L=0.18u AS=0.4050p AD=0.4050p PS=2.700u PD=2.700u
MD32 ld3_3 c4 vtb vtb CMOSP W=1.800u L=0.18u AS=0.8100p AD=0.8100p PS=4.500u PD=4.500u
MD33 ld3_3 c4 gnd gnd CMOSN W=0.900u L=0.18u AS=0.4050p AD=0.4050p PS=2.700u PD=2.700u
MD34 ldb3_3 c4b vtb vtb CMOSP W=1.800u L=0.18u AS=0.8100p AD=0.8100p PS=4.500u PD=4.500u
MD35 ldb3_3 c4b gnd gnd CMOSN W=0.900u L=0.18u AS=0.4050p AD=0.4050p PS=2.700u PD=2.700u
M0 d1b g gnd gnd CMOSN W=2.700u L=0.18u AS=1.2150p AD=1.2150p PS=6.300u PD=6.300u
M1 d1b c0 x0 gnd CMOSN W=5.400u L=0.18u AS=2.4300p AD=2.4300p PS=11.700u PD=11.700u
M2 x0 t gnd gnd CMOSN W=5.400u L=0.18u AS=2.4300p AD=2.4300p PS=11.700u PD=11.700u
M3 d1 c0b w0 gnd CMOSN W=5.400u L=0.18u AS=2.4300p AD=2.4300p PS=11.700u PD=11.700u
M4 d1 tb w0 gnd CMOSN W=5.400u L=0.18u AS=2.4300p AD=2.4300p PS=11.700u PD=11.700u
M5 w0 gb gnd gnd CMOSN W=5.400u L=0.18u AS=2.4300p AD=2.4300p PS=11.700u PD=11.700u
M6 d1 d1b vdd vdd CMOSP W=5.400u L=0.18u AS=2.4300p AD=2.4300p PS=11.700u PD=11.700u
M7 d1b d1 vdd vdd CMOSP W=5.400u L=0.18u AS=2.4300p AD=2.4300p PS=11.700u PD=11.700u
M8 c1 d1b vdd vdd CMOSP W=3.600u L=0.18u AS=1.6200p AD=1.6200p PS=8.100u PD=8.100u
M9 c1 d1b gnd gnd CMOSN W=1.800u L=0.18u AS=0.8100p AD=0.8100p PS=4.500u PD=4.500u
M10 c1b d1 vdd vdd CMOSP W=3.600u L=0.18u AS=1.6200p AD=1.6200p PS=8.100u PD=8.100u
M11 c1b d1 gnd gnd CMOSN W=1.800u L=0.18u AS=0.8100p AD=0.8100p PS=4.500u PD=4.500u
M12 d2b g gnd gnd CMOSN W=2.700u L=0.18u AS=1.2150p AD=1.2150p PS=6.300u PD=6.300u
M13 d2b c1 x1 gnd CMOSN W=5.400u L=0.18u AS=2.4300p AD=2.4300p PS=11.700u PD=11.700u
M14 x1 t gnd gnd CMOSN W=5.400u L=0.18u AS=2.4300p AD=2.4300p PS=11.700u PD=11.700u
M15 d2 c1b w1 gnd CMOSN W=5.400u L=0.18u AS=2.4300p AD=2.4300p PS=11.700u PD=11.700u
M16 d2 tb w1 gnd CMOSN W=5.400u L=0.18u AS=2.4300p AD=2.4300p PS=11.700u PD=11.700u
M17 w1 gb gnd gnd CMOSN W=5.400u L=0.18u AS=2.4300p AD=2.4300p PS=11.700u PD=11.700u
M18 d2 d2b vdd vdd CMOSP W=5.400u L=0.18u AS=2.4300p AD=2.4300p PS=11.700u PD=11.700u
M19 d2b d2 vdd vdd CMOSP W=5.400u L=0.18u AS=2.4300p AD=2.4300p PS=11.700u PD=11.700u
M20 c2 d2b vdd vdd CMOSP W=3.600u L=0.18u AS=1.6200p AD=1.6200p PS=8.100u PD=8.100u
M21 c2 d2b gnd gnd CMOSN W=1.800u L=0.18u AS=0.8100p AD=0.8100p PS=4.500u PD=4.500u
M22 c2b d2 vdd vdd CMOSP W=3.600u L=0.18u AS=1.6200p AD=1.6200p PS=8.100u PD=8.100u
M23 c2b d2 gnd gnd CMOSN W=1.800u L=0.18u AS=0.8100p AD=0.8100p PS=4.500u PD=4.500u
M24 d3b g gnd gnd CMOSN W=2.700u L=0.18u AS=1.2150p AD=1.2150p PS=6.300u PD=6.300u
M25 d3b c2 x2 gnd CMOSN W=5.400u L=0.18u AS=2.4300p AD=2.4300p PS=11.700u PD=11.700u
M26 x2 t gnd gnd CMOSN W=5.400u L=0.18u AS=2.4300p AD=2.4300p PS=11.700u PD=11.700u
M27 d3 c2b w2 gnd CMOSN W=5.400u L=0.18u AS=2.4300p AD=2.4300p PS=11.700u PD=11.700u
M28 d3 tb w2 gnd CMOSN W=5.400u L=0.18u AS=2.4300p AD=2.4300p PS=11.700u PD=11.700u
M29 w2 gb gnd gnd CMOSN W=5.400u L=0.18u AS=2.4300p AD=2.4300p PS=11.700u PD=11.700u
M30 d3 d3b vdd vdd CMOSP W=5.400u L=0.18u AS=2.4300p AD=2.4300p PS=11.700u PD=11.700u
M31 d3b d3 vdd vdd CMOSP W=5.400u L=0.18u AS=2.4300p AD=2.4300p PS=11.700u PD=11.700u
M32 c3 d3b vdd vdd CMOSP W=3.600u L=0.18u AS=1.6200p AD=1.6200p PS=8.100u PD=8.100u
M33 c3 d3b gnd gnd CMOSN W=1.800u L=0.18u AS=0.8100p AD=0.8100p PS=4.500u PD=4.500u
M34 c3b d3 vdd vdd CMOSP W=3.600u L=0.18u AS=1.6200p AD=1.6200p PS=8.100u PD=8.100u
M35 c3b d3 gnd gnd CMOSN W=1.800u L=0.18u AS=0.8100p AD=0.8100p PS=4.500u PD=4.500u
M36 d4b g gnd gnd CMOSN W=2.700u L=0.18u AS=1.2150p AD=1.2150p PS=6.300u PD=6.300u
M37 d4b c3 x3 gnd CMOSN W=5.400u L=0.18u AS=2.4300p AD=2.4300p PS=11.700u PD=11.700u
M38 x3 t gnd gnd CMOSN W=5.400u L=0.18u AS=2.4300p AD=2.4300p PS=11.700u PD=11.700u
M39 d4 c3b w3 gnd CMOSN W=5.400u L=0.18u AS=2.4300p AD=2.4300p PS=11.700u PD=11.700u
M40 d4 tb w3 gnd CMOSN W=5.400u L=0.18u AS=2.4300p AD=2.4300p PS=11.700u PD=11.700u
M41 w3 gb gnd gnd CMOSN W=5.400u L=0.18u AS=2.4300p AD=2.4300p PS=11.700u PD=11.700u
M42 d4 d4b vdd vdd CMOSP W=5.400u L=0.18u AS=2.4300p AD=2.4300p PS=11.700u PD=11.700u
M43 d4b d4 vdd vdd CMOSP W=5.400u L=0.18u AS=2.4300p AD=2.4300p PS=11.700u PD=11.700u
M44 c4 d4b vdd vdd CMOSP W=3.600u L=0.18u AS=1.6200p AD=1.6200p PS=8.100u PD=8.100u
M45 c4 d4b gnd gnd CMOSN W=1.800u L=0.18u AS=0.8100p AD=0.8100p PS=4.500u PD=4.500u
M46 c4b d4 vdd vdd CMOSP W=3.600u L=0.18u AS=1.6200p AD=1.6200p PS=8.100u PD=8.100u
M47 c4b d4 gnd gnd CMOSN W=1.800u L=0.18u AS=0.8100p AD=0.8100p PS=4.500u PD=4.500u
.tran 2p 9n
.meas tran tpr TRIG v(c0) VAL=0.9 RISE=1 TARG v(c4) VAL=0.9 RISE=1
.meas tran pavg AVG i(Vsense) FROM=0.5n TO=8.5n
.meas tran tpf TRIG v(c0) VAL=0.9 FALL=1 TARG v(c4) VAL=0.9 FALL=1
.meas tran vlo FIND v(c4) AT=0.95n
.meas tran vhi FIND v(c4) AT=2.95n
.meas tran vlo2 FIND v(c4) AT=4.95n
.end
