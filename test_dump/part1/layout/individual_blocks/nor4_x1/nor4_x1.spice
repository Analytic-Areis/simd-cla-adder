* NGSPICE file created from nor4_x1.ext - technology: scmos

.global Vdd Gnd

.subckt nor4_x1 i0 i1 i2 i3 y vdd gnd
M1000 a_25_79# i1 a_16_79# vdd pfet w=7.2u l=0.18u
+  ad=2.268p pd=7.83u as=2.268p ps=7.83u
M1001 y i3 gnd Gnd nfet w=0.9u l=0.18u
+  ad=0.405p pd=2.7u as=0.2835p ps=1.53u
M1002 a_34_79# i2 a_25_79# vdd pfet w=7.2u l=0.18u
+  ad=2.268p pd=7.83u as=2.268p ps=7.83u
M1003 y i3 a_34_79# vdd pfet w=7.2u l=0.18u
+  ad=3.24p pd=15.3u as=2.268p ps=7.83u
M1004 gnd i0 y Gnd nfet w=0.9u l=0.18u
+  ad=0.2835p pd=1.53u as=0.486p ps=2.88u
M1005 a_16_79# i0 vdd vdd pfet w=7.2u l=0.18u
+  ad=2.268p pd=7.83u as=3.888p ps=15.48u
M1006 y i1 gnd Gnd nfet w=0.9u l=0.18u
+  ad=0.2835p pd=1.53u as=0.2835p ps=1.53u
M1007 gnd i2 y Gnd nfet w=0.9u l=0.18u
+  ad=0.2835p pd=1.53u as=0.2835p ps=1.53u
C0 vdd i1 0.01968f
C1 a_34_79# vdd 0
C2 i2 gnd 0.00258f
C3 i3 y 0.09761f
C4 i0 y 0.40609f
C5 i1 i3 0.00894f
C6 i0 i1 0.59671f
C7 vdd i2 0.01968f
C8 a_16_79# vdd 0.00197f
C9 i3 gnd 0.00258f
C10 i2 i3 0.59691f
C11 i0 gnd 0.00258f
C12 i1 y 0.02134f
C13 a_34_79# y 0.00227f
C14 i0 i2 0.00874f
C15 vdd i3 0.02116f
C16 vdd i0 0.02706f
C17 a_25_79# vdd 0
C18 y gnd 0.45443f
C19 i1 gnd 0.00258f
C20 i2 y 0.02134f
C21 vdd y 0.05728f
C22 i0 i3 0.00894f
C23 i1 i2 0.59671f
.ends
