* Truth table of c4_x1: inputs through unit inverters, outputs load 20L/10L inverter
.include ../../../../spice/models/TSMC_180nm.txt
.options reltol=1e-3
VDD vdd gnd 1.8
* c4_x1: C4 complex gate, stack 5
* GENERATED from part1/cells/library.py. Do not edit by hand.
.subckt c4_x1 g0b t0b g1b t1b g2b t2b g3b t3b c0b c4 vdd gnd
Mp1 c4 g3b vdd vdd CMOSP W=1.8000e-06 L=1.8000e-07 AS=9.7200e-13 PS=4.6800e-06 AD=9.7200e-13 PD=4.6800e-06
Mp2 xp1 t3b vdd vdd CMOSP W=9.0000e-06 L=1.8000e-07 AS=4.8600e-12 PS=1.9080e-05 AD=4.8600e-12 PD=1.9080e-05
Mp3 c4 g2b xp1 vdd CMOSP W=3.6000e-06 L=1.8000e-07 AS=1.9440e-12 PS=8.2800e-06 AD=1.9440e-12 PD=8.2800e-06
Mp4 xp2 t2b xp1 vdd CMOSP W=9.0000e-06 L=1.8000e-07 AS=4.8600e-12 PS=1.9080e-05 AD=4.8600e-12 PD=1.9080e-05
Mp5 c4 g1b xp2 vdd CMOSP W=5.4000e-06 L=1.8000e-07 AS=2.9160e-12 PS=1.1880e-05 AD=2.9160e-12 PD=1.1880e-05
Mp6 xp3 t1b xp2 vdd CMOSP W=9.0000e-06 L=1.8000e-07 AS=4.8600e-12 PS=1.9080e-05 AD=4.8600e-12 PD=1.9080e-05
Mp7 c4 g0b xp3 vdd CMOSP W=7.2000e-06 L=1.8000e-07 AS=3.8880e-12 PS=1.5480e-05 AD=3.8880e-12 PD=1.5480e-05
Mp8 xp4 t0b xp3 vdd CMOSP W=9.0000e-06 L=1.8000e-07 AS=4.8600e-12 PS=1.9080e-05 AD=2.4300e-12 PD=1.8540e-05
Mp9 c4 c0b xp4 vdd CMOSP W=9.0000e-06 L=1.8000e-07 AS=2.4300e-12 PS=1.8540e-05 AD=4.8600e-12 PD=1.9080e-05
Mn1 c4 g3b xn1 gnd CMOSN W=4.5000e-06 L=1.8000e-07 AS=2.4300e-12 PS=1.0080e-05 AD=2.4300e-12 PD=1.0080e-05
Mn2 xn1 t3b gnd gnd CMOSN W=1.8000e-06 L=1.8000e-07 AS=9.7200e-13 PS=4.6800e-06 AD=9.7200e-13 PD=4.6800e-06
Mn3 xn1 g2b xn2 gnd CMOSN W=4.5000e-06 L=1.8000e-07 AS=2.4300e-12 PS=1.0080e-05 AD=2.4300e-12 PD=1.0080e-05
Mn4 xn2 t2b gnd gnd CMOSN W=2.7000e-06 L=1.8000e-07 AS=1.4580e-12 PS=6.4800e-06 AD=1.4580e-12 PD=6.4800e-06
Mn5 xn2 g1b xn3 gnd CMOSN W=4.5000e-06 L=1.8000e-07 AS=2.4300e-12 PS=1.0080e-05 AD=2.4300e-12 PD=1.0080e-05
Mn6 xn3 t1b gnd gnd CMOSN W=3.6000e-06 L=1.8000e-07 AS=1.9440e-12 PS=8.2800e-06 AD=1.9440e-12 PD=8.2800e-06
Mn7 xn3 g0b xn4 gnd CMOSN W=4.5000e-06 L=1.8000e-07 AS=2.4300e-12 PS=1.0080e-05 AD=2.4300e-12 PD=1.0080e-05
Mn8 xn4 t0b gnd gnd CMOSN W=4.5000e-06 L=1.8000e-07 AS=2.4300e-12 PS=1.0080e-05 AD=2.4300e-12 PD=1.0080e-05
Mn9 xn4 c0b gnd gnd CMOSN W=4.5000e-06 L=1.8000e-07 AS=2.4300e-12 PS=1.0080e-05 AD=2.4300e-12 PD=1.0080e-05
.ends c4_x1
.subckt tb_inv a y vdd gnd
mp y a vdd vdd CMOSP W=1.8e-06 L=1.8e-07 AS=9.72e-13 PS=4.68e-06 AD=9.72e-13 PD=4.68e-06
mn y a gnd gnd CMOSN W=9.0e-07 L=1.8e-07 AS=4.86e-13 PS=2.88e-06 AD=4.86e-13 PD=2.88e-06
.ends
Vg0b src_g0b gnd PWL(
+ 0.00000e+00 1.800 2.56000e-07 1.800 2.56050e-07 0.000 5.14000e-07 0.000 5.14050e-07 1.800 5.15000e-07 1.800
+ 5.15050e-07 0.000 5.16000e-07 0.000 5.16050e-07 1.800 5.18000e-07 1.800 5.18050e-07 0.000 5.22000e-07 0.000
+ 5.22050e-07 1.800 5.23000e-07 1.800 5.23050e-07 0.000 5.24000e-07 0.000 5.24050e-07 1.800 5.27000e-07 1.800
+ 5.27050e-07 0.000 5.28000e-07 0.000 5.28050e-07 1.800 5.30000e-07 1.800 5.30050e-07 0.000 5.31000e-07 0.000
+ 5.31050e-07 1.800 5.36000e-07 1.800 5.36050e-07 0.000 5.37000e-07 0.000 5.37050e-07 1.800 5.39000e-07 1.800
+ 5.39050e-07 0.000 5.41000e-07 0.000 5.41050e-07 1.800 5.42000e-07 1.800 5.42050e-07 0.000 5.44000e-07 0.000
+ 5.44050e-07 1.800 5.45000e-07 1.800 5.45050e-07 0.000 5.46000e-07 0.000 5.46050e-07 1.800 5.47000e-07 1.800
+ 5.47050e-07 0.000 5.49000e-07 0.000 5.49050e-07 1.800 5.50000e-07 1.800 5.50050e-07 0.000 5.52000e-07 0.000
+ 5.52050e-07 1.800 5.53000e-07 1.800 5.53050e-07 0.000 5.54000e-07 0.000 5.54050e-07 1.800 5.62000e-07 1.800
+ 5.62050e-07 0.000 5.63000e-07 0.000 5.63050e-07 1.800 5.64000e-07 1.800 5.64050e-07 0.000 5.65000e-07 0.000
+ 5.65050e-07 1.800 5.70000e-07 1.800 5.70050e-07 0.000 5.71000e-07 0.000 5.71050e-07 1.800 5.72000e-07 1.800
+ 5.72050e-07 0.000 5.74000e-07 0.000 5.74050e-07 1.800 5.76000e-07 1.800 5.76050e-07 0.000 5.77000e-07 0.000
+ 5.77050e-07 1.800 5.79000e-07 1.800 5.79050e-07 0.000 5.80000e-07 0.000 5.80050e-07 1.800 5.81000e-07 1.800
+ 5.81050e-07 0.000 5.82000e-07 0.000 5.82050e-07 1.800 5.83000e-07 1.800 5.83050e-07 0.000 5.84000e-07 0.000
+ 5.84050e-07 1.800 5.85000e-07 1.800 5.85050e-07 0.000 5.89000e-07 0.000 5.89050e-07 1.800 5.90000e-07 1.800
+ 5.90050e-07 0.000 5.91000e-07 0.000 5.91050e-07 1.800 5.92000e-07 1.800 5.92050e-07 0.000 5.94000e-07 0.000
+ 5.94050e-07 1.800 5.95000e-07 1.800 5.95050e-07 0.000 5.97000e-07 0.000 5.97050e-07 1.800 5.98000e-07 1.800
+ 5.98050e-07 0.000 5.99000e-07 0.000 5.99050e-07 1.800 6.01000e-07 1.800 6.01050e-07 0.000 6.03000e-07 0.000
+ 6.03050e-07 1.800 6.07000e-07 1.800 6.07050e-07 0.000 6.08000e-07 0.000 6.08050e-07 1.800 6.09000e-07 1.800
+ 6.09050e-07 0.000 6.10000e-07 0.000 6.10050e-07 1.800 6.11000e-07 1.800 6.11050e-07 0.000 6.12000e-07 0.000
+ 6.12050e-07 1.800 6.16000e-07 1.800 6.16050e-07 0.000 6.18000e-07 0.000 6.18050e-07 1.800 6.19000e-07 1.800
+ 6.19050e-07 0.000 6.20000e-07 0.000 6.20050e-07 1.800 6.21000e-07 1.800 6.21050e-07 0.000 6.24000e-07 0.000
+ 6.24050e-07 1.800 6.27000e-07 1.800 6.27050e-07 0.000 6.33000e-07 0.000 6.33050e-07 1.800 6.34000e-07 1.800
+ 6.34050e-07 0.000 6.35000e-07 0.000 6.35050e-07 1.800 6.36000e-07 1.800 6.36050e-07 0.000 6.37000e-07 0.000
+ 6.37050e-07 1.800 6.38000e-07 1.800 6.38050e-07 0.000 6.39000e-07 0.000 6.39050e-07 1.800 6.40000e-07 1.800
+ 6.40050e-07 0.000 6.44000e-07 0.000 6.44050e-07 1.800 6.45000e-07 1.800 6.45050e-07 0.000 6.46000e-07 0.000
+ 6.46050e-07 1.800 6.50000e-07 1.800 6.50050e-07 0.000 6.51000e-07 0.000 6.51050e-07 1.800 6.54000e-07 1.800
+ 6.54050e-07 0.000 6.56000e-07 0.000 6.56050e-07 1.800 6.60000e-07 1.800 6.60050e-07 0.000 6.61000e-07 0.000
+ 6.61050e-07 1.800 6.62000e-07 1.800 6.62050e-07 0.000 6.64000e-07 0.000 6.64050e-07 1.800 6.66000e-07 1.800
+ 6.66050e-07 0.000 6.67000e-07 0.000 6.67050e-07 1.800 6.69000e-07 1.800 6.69050e-07 0.000 6.70000e-07 0.000
+ 6.70050e-07 1.800 6.71000e-07 1.800 6.71050e-07 0.000 6.73000e-07 0.000 6.73050e-07 1.800 6.74000e-07 1.800
+ 6.74050e-07 0.000 6.76000e-07 0.000 6.76050e-07 1.800 6.78000e-07 1.800 6.78050e-07 0.000 6.79000e-07 0.000
+ 6.79050e-07 1.800 6.83000e-07 1.800 6.83050e-07 0.000 6.84000e-07 0.000 6.84050e-07 1.800 6.85000e-07 1.800
+ 6.85050e-07 0.000 6.88000e-07 0.000 6.88050e-07 1.800 6.89000e-07 1.800 6.89050e-07 0.000 6.90000e-07 0.000
+ 6.90050e-07 1.800 6.91000e-07 1.800 6.91050e-07 0.000 6.92000e-07 0.000 6.92050e-07 1.800 6.93000e-07 1.800
+ 6.93050e-07 0.000 6.97000e-07 0.000 6.97050e-07 1.800 6.99000e-07 1.800 6.99050e-07 0.000 7.00000e-07 0.000
+ 7.00050e-07 1.800 7.01000e-07 1.800 7.01050e-07 0.000 7.03000e-07 0.000 7.03050e-07 1.800 7.04000e-07 1.800
+ 7.04050e-07 0.000 7.08000e-07 0.000 7.08050e-07 1.800 7.09000e-07 1.800 7.09050e-07 0.000 7.11000e-07 0.000
+ 7.11050e-07 1.800 7.15000e-07 1.800 7.15050e-07 0.000 7.16000e-07 0.000 7.16050e-07 1.800 7.19000e-07 1.800
+ 7.19050e-07 0.000 7.22000e-07 0.000 7.22050e-07 1.800 7.23000e-07 1.800 7.23050e-07 0.000 7.24000e-07 0.000
+ 7.24050e-07 1.800 7.25000e-07 1.800 7.25050e-07 0.000 7.31000e-07 0.000 7.31050e-07 1.800 7.33000e-07 1.800
+ 7.33050e-07 0.000 7.34000e-07 0.000 7.34050e-07 1.800 7.37000e-07 1.800 7.37050e-07 0.000 7.39000e-07 0.000
+ 7.39050e-07 1.800 7.41000e-07 1.800 7.41050e-07 0.000 7.42000e-07 0.000 7.42050e-07 1.800 7.43000e-07 1.800
+ 7.43050e-07 0.000 7.52000e-07 0.000 7.52050e-07 1.800 7.53000e-07 1.800 7.53050e-07 0.000 7.54000e-07 0.000
+ 7.54050e-07 1.800 7.55000e-07 1.800 7.55050e-07 0.000 7.59000e-07 0.000 7.59050e-07 1.800 7.60000e-07 1.800
+ 7.60050e-07 0.000 7.62000e-07 0.000 7.62050e-07 1.800 7.63000e-07 1.800 7.63050e-07 0.000 7.66000e-07 0.000
+ 7.66050e-07 1.800 7.67000e-07 1.800 7.67050e-07 0.000 7.71000e-07 0.000 7.71050e-07 1.800 7.73000e-07 1.800
+ 7.73050e-07 0.000 7.74000e-07 0.000 7.74050e-07 1.800 7.80000e-07 1.800 7.80050e-07 0.000 7.82000e-07 0.000
+ 7.82050e-07 1.800 7.83000e-07 1.800 7.83050e-07 0.000 7.85000e-07 0.000 7.85050e-07 1.800 7.86000e-07 1.800
+ 7.86050e-07 0.000 7.92000e-07 0.000 7.92050e-07 1.800 7.99000e-07 1.800 7.99050e-07 0.000 8.02000e-07 0.000
+ 8.02050e-07 1.800 8.03000e-07 1.800 8.03050e-07 0.000 8.04000e-07 0.000 8.04050e-07 1.800 8.18000e-07 1.800
+ 8.18050e-07 0.000 8.21000e-07 0.000 8.21050e-07 1.800 8.24000e-07 1.800 8.24050e-07 0.000 8.26000e-07 0.000
+ 8.26050e-07 1.800 8.28000e-07 1.800 8.28050e-07 0.000 8.29000e-07 0.000 8.29050e-07 1.800 8.37000e-07 1.800
+ 8.37050e-07 0.000 8.39000e-07 0.000 8.39050e-07 1.800 8.41000e-07 1.800 8.41050e-07 0.000 8.43000e-07 0.000
+ 8.43050e-07 1.800 8.44000e-07 1.800 8.44050e-07 0.000 8.48000e-07 0.000 8.48050e-07 1.800 8.50000e-07 1.800
+ 8.50050e-07 0.000 8.54000e-07 0.000 8.54050e-07 1.800 8.56000e-07 1.800 8.56050e-07 0.000 8.57000e-07 0.000
+ 8.57050e-07 1.800 8.60000e-07 1.800 8.60050e-07 0.000 8.64000e-07 0.000 8.64050e-07 1.800 8.69000e-07 1.800
+ 8.69050e-07 0.000 8.71000e-07 0.000 8.71050e-07 1.800 8.72000e-07 1.800 8.72050e-07 0.000 8.73000e-07 0.000
+ 8.73050e-07 1.800 8.75000e-07 1.800 8.75050e-07 0.000 8.80000e-07 0.000 8.80050e-07 1.800 8.81000e-07 1.800
+ 8.81050e-07 0.000 8.84000e-07 0.000 8.84050e-07 1.800 8.85000e-07 1.800 8.85050e-07 0.000 8.88000e-07 0.000
+ 8.88050e-07 1.800 8.91000e-07 1.800 8.91050e-07 0.000 8.92000e-07 0.000 8.92050e-07 1.800 8.94000e-07 1.800
+ 8.94050e-07 0.000 9.00000e-07 0.000 9.00050e-07 1.800 9.03000e-07 1.800 9.03050e-07 0.000 9.05000e-07 0.000
+ 9.05050e-07 1.800 9.07000e-07 1.800 9.07050e-07 0.000 9.09000e-07 0.000 9.09050e-07 1.800 9.10000e-07 1.800
+ 9.10050e-07 0.000 9.11000e-07 0.000 9.11050e-07 1.800 9.12000e-07 1.800 9.12050e-07 0.000 9.15000e-07 0.000
+ 9.15050e-07 1.800 9.17000e-07 1.800 9.17050e-07 0.000 9.22000e-07 0.000 9.22050e-07 1.800 9.24000e-07 1.800
+ 9.24050e-07 0.000 9.25000e-07 0.000 9.25050e-07 1.800 9.27000e-07 1.800 9.27050e-07 0.000 9.29000e-07 0.000
+ 9.29050e-07 1.800 9.32000e-07 1.800 9.32050e-07 0.000 9.33000e-07 0.000 9.33050e-07 1.800 9.34000e-07 1.800
+ 9.34050e-07 0.000 9.35000e-07 0.000 9.35050e-07 1.800 9.36000e-07 1.800 9.36050e-07 0.000 9.37000e-07 0.000
+ 9.37050e-07 1.800 9.40000e-07 1.800 9.40050e-07 0.000 9.47000e-07 0.000 9.47050e-07 1.800 9.48000e-07 1.800
+ 9.48050e-07 0.000 9.49000e-07 0.000 9.49050e-07 1.800 9.51000e-07 1.800 9.51050e-07 0.000 9.53000e-07 0.000
+ 9.53050e-07 1.800 9.55000e-07 1.800 9.55050e-07 0.000 9.58000e-07 0.000 9.58050e-07 1.800 9.59000e-07 1.800
+ 9.59050e-07 0.000 9.60000e-07 0.000 9.60050e-07 1.800 9.62000e-07 1.800 9.62050e-07 0.000 9.63000e-07 0.000
+ 9.63050e-07 1.800 9.64000e-07 1.800 9.64050e-07 0.000 9.65000e-07 0.000 9.65050e-07 1.800 9.68000e-07 1.800
+ 9.68050e-07 0.000 9.70000e-07 0.000 9.70050e-07 1.800 9.71000e-07 1.800 9.71050e-07 0.000 9.72000e-07 0.000
+ 9.72050e-07 1.800 9.73000e-07 1.800 9.73050e-07 0.000 9.76000e-07 0.000 9.76050e-07 1.800 9.78000e-07 1.800
+ 9.78050e-07 0.000 9.79000e-07 0.000 9.79050e-07 1.800 9.80000e-07 1.800 9.80050e-07 0.000 9.81000e-07 0.000
+ 9.81050e-07 1.800 9.82000e-07 1.800 9.82050e-07 0.000 9.84000e-07 0.000 9.84050e-07 1.800 9.88000e-07 1.800
+ 9.88050e-07 0.000 9.89000e-07 0.000 9.89050e-07 1.800 9.90000e-07 1.800 9.90050e-07 0.000 9.91000e-07 0.000
+ 9.91050e-07 1.800 9.92000e-07 1.800 9.92050e-07 0.000 9.94000e-07 0.000 9.94050e-07 1.800 9.96000e-07 1.800
+ 9.96050e-07 0.000 9.97000e-07 0.000 9.97050e-07 1.800 9.98000e-07 1.800 9.98050e-07 0.000 1.00100e-06 0.000
+ 1.00105e-06 1.800 1.00300e-06 1.800 1.00305e-06 0.000 1.00500e-06 0.000 1.00505e-06 1.800 1.00900e-06 1.800
+ 1.00905e-06 0.000 1.01000e-06 0.000 1.01005e-06 1.800 1.01100e-06 1.800 1.01105e-06 0.000 1.01200e-06 0.000
+ 1.01205e-06 1.800 1.01400e-06 1.800 1.01405e-06 0.000 1.01500e-06 0.000 1.01505e-06 1.800 1.01900e-06 1.800
+ 1.01905e-06 0.000 1.02300e-06 0.000 1.02305e-06 1.800 1.02400e-06 1.800
+ )
Xd_g0b src_g0b g0b vdd gnd tb_inv
Vt0b src_t0b gnd PWL(
+ 0.00000e+00 1.800 1.28000e-07 1.800 1.28050e-07 0.000 2.56000e-07 0.000 2.56050e-07 1.800 3.84000e-07 1.800
+ 3.84050e-07 0.000 5.12000e-07 0.000 5.12050e-07 1.800 5.14000e-07 1.800 5.14050e-07 0.000 5.16000e-07 0.000
+ 5.16050e-07 1.800 5.18000e-07 1.800 5.18050e-07 0.000 5.19000e-07 0.000 5.19050e-07 1.800 5.20000e-07 1.800
+ 5.20050e-07 0.000 5.21000e-07 0.000 5.21050e-07 1.800 5.25000e-07 1.800 5.25050e-07 0.000 5.26000e-07 0.000
+ 5.26050e-07 1.800 5.30000e-07 1.800 5.30050e-07 0.000 5.31000e-07 0.000 5.31050e-07 1.800 5.32000e-07 1.800
+ 5.32050e-07 0.000 5.34000e-07 0.000 5.34050e-07 1.800 5.35000e-07 1.800 5.35050e-07 0.000 5.37000e-07 0.000
+ 5.37050e-07 1.800 5.42000e-07 1.800 5.42050e-07 0.000 5.45000e-07 0.000 5.45050e-07 1.800 5.46000e-07 1.800
+ 5.46050e-07 0.000 5.47000e-07 0.000 5.47050e-07 1.800 5.50000e-07 1.800 5.50050e-07 0.000 5.52000e-07 0.000
+ 5.52050e-07 1.800 5.53000e-07 1.800 5.53050e-07 0.000 5.57000e-07 0.000 5.57050e-07 1.800 5.59000e-07 1.800
+ 5.59050e-07 0.000 5.64000e-07 0.000 5.64050e-07 1.800 5.67000e-07 1.800 5.67050e-07 0.000 5.69000e-07 0.000
+ 5.69050e-07 1.800 5.70000e-07 1.800 5.70050e-07 0.000 5.71000e-07 0.000 5.71050e-07 1.800 5.72000e-07 1.800
+ 5.72050e-07 0.000 5.73000e-07 0.000 5.73050e-07 1.800 5.74000e-07 1.800 5.74050e-07 0.000 5.76000e-07 0.000
+ 5.76050e-07 1.800 5.77000e-07 1.800 5.77050e-07 0.000 5.81000e-07 0.000 5.81050e-07 1.800 5.82000e-07 1.800
+ 5.82050e-07 0.000 5.83000e-07 0.000 5.83050e-07 1.800 5.85000e-07 1.800 5.85050e-07 0.000 5.88000e-07 0.000
+ 5.88050e-07 1.800 5.89000e-07 1.800 5.89050e-07 0.000 5.91000e-07 0.000 5.91050e-07 1.800 5.93000e-07 1.800
+ 5.93050e-07 0.000 5.94000e-07 0.000 5.94050e-07 1.800 5.97000e-07 1.800 5.97050e-07 0.000 5.98000e-07 0.000
+ 5.98050e-07 1.800 5.99000e-07 1.800 5.99050e-07 0.000 6.01000e-07 0.000 6.01050e-07 1.800 6.03000e-07 1.800
+ 6.03050e-07 0.000 6.04000e-07 0.000 6.04050e-07 1.800 6.06000e-07 1.800 6.06050e-07 0.000 6.08000e-07 0.000
+ 6.08050e-07 1.800 6.09000e-07 1.800 6.09050e-07 0.000 6.10000e-07 0.000 6.10050e-07 1.800 6.11000e-07 1.800
+ 6.11050e-07 0.000 6.13000e-07 0.000 6.13050e-07 1.800 6.15000e-07 1.800 6.15050e-07 0.000 6.16000e-07 0.000
+ 6.16050e-07 1.800 6.18000e-07 1.800 6.18050e-07 0.000 6.20000e-07 0.000 6.20050e-07 1.800 6.21000e-07 1.800
+ 6.21050e-07 0.000 6.22000e-07 0.000 6.22050e-07 1.800 6.24000e-07 1.800 6.24050e-07 0.000 6.25000e-07 0.000
+ 6.25050e-07 1.800 6.30000e-07 1.800 6.30050e-07 0.000 6.31000e-07 0.000 6.31050e-07 1.800 6.32000e-07 1.800
+ 6.32050e-07 0.000 6.34000e-07 0.000 6.34050e-07 1.800 6.35000e-07 1.800 6.35050e-07 0.000 6.36000e-07 0.000
+ 6.36050e-07 1.800 6.37000e-07 1.800 6.37050e-07 0.000 6.38000e-07 0.000 6.38050e-07 1.800 6.41000e-07 1.800
+ 6.41050e-07 0.000 6.46000e-07 0.000 6.46050e-07 1.800 6.47000e-07 1.800 6.47050e-07 0.000 6.48000e-07 0.000
+ 6.48050e-07 1.800 6.49000e-07 1.800 6.49050e-07 0.000 6.51000e-07 0.000 6.51050e-07 1.800 6.53000e-07 1.800
+ 6.53050e-07 0.000 6.57000e-07 0.000 6.57050e-07 1.800 6.58000e-07 1.800 6.58050e-07 0.000 6.59000e-07 0.000
+ 6.59050e-07 1.800 6.60000e-07 1.800 6.60050e-07 0.000 6.61000e-07 0.000 6.61050e-07 1.800 6.65000e-07 1.800
+ 6.65050e-07 0.000 6.66000e-07 0.000 6.66050e-07 1.800 6.67000e-07 1.800 6.67050e-07 0.000 6.70000e-07 0.000
+ 6.70050e-07 1.800 6.71000e-07 1.800 6.71050e-07 0.000 6.72000e-07 0.000 6.72050e-07 1.800 6.74000e-07 1.800
+ 6.74050e-07 0.000 6.78000e-07 0.000 6.78050e-07 1.800 6.79000e-07 1.800 6.79050e-07 0.000 6.80000e-07 0.000
+ 6.80050e-07 1.800 6.81000e-07 1.800 6.81050e-07 0.000 6.83000e-07 0.000 6.83050e-07 1.800 6.87000e-07 1.800
+ 6.87050e-07 0.000 6.88000e-07 0.000 6.88050e-07 1.800 6.90000e-07 1.800 6.90050e-07 0.000 6.91000e-07 0.000
+ 6.91050e-07 1.800 6.92000e-07 1.800 6.92050e-07 0.000 6.93000e-07 0.000 6.93050e-07 1.800 6.95000e-07 1.800
+ 6.95050e-07 0.000 6.98000e-07 0.000 6.98050e-07 1.800 7.00000e-07 1.800 7.00050e-07 0.000 7.01000e-07 0.000
+ 7.01050e-07 1.800 7.02000e-07 1.800 7.02050e-07 0.000 7.07000e-07 0.000 7.07050e-07 1.800 7.08000e-07 1.800
+ 7.08050e-07 0.000 7.12000e-07 0.000 7.12050e-07 1.800 7.17000e-07 1.800 7.17050e-07 0.000 7.19000e-07 0.000
+ 7.19050e-07 1.800 7.21000e-07 1.800 7.21050e-07 0.000 7.22000e-07 0.000 7.22050e-07 1.800 7.23000e-07 1.800
+ 7.23050e-07 0.000 7.24000e-07 0.000 7.24050e-07 1.800 7.26000e-07 1.800 7.26050e-07 0.000 7.29000e-07 0.000
+ 7.29050e-07 1.800 7.30000e-07 1.800 7.30050e-07 0.000 7.31000e-07 0.000 7.31050e-07 1.800 7.33000e-07 1.800
+ 7.33050e-07 0.000 7.34000e-07 0.000 7.34050e-07 1.800 7.37000e-07 1.800 7.37050e-07 0.000 7.42000e-07 0.000
+ 7.42050e-07 1.800 7.43000e-07 1.800 7.43050e-07 0.000 7.45000e-07 0.000 7.45050e-07 1.800 7.46000e-07 1.800
+ 7.46050e-07 0.000 7.47000e-07 0.000 7.47050e-07 1.800 7.50000e-07 1.800 7.50050e-07 0.000 7.53000e-07 0.000
+ 7.53050e-07 1.800 7.55000e-07 1.800 7.55050e-07 0.000 7.57000e-07 0.000 7.57050e-07 1.800 7.58000e-07 1.800
+ 7.58050e-07 0.000 7.64000e-07 0.000 7.64050e-07 1.800 7.68000e-07 1.800 7.68050e-07 0.000 7.69000e-07 0.000
+ 7.69050e-07 1.800 7.70000e-07 1.800 7.70050e-07 0.000 7.72000e-07 0.000 7.72050e-07 1.800 7.74000e-07 1.800
+ 7.74050e-07 0.000 7.75000e-07 0.000 7.75050e-07 1.800 7.78000e-07 1.800 7.78050e-07 0.000 7.79000e-07 0.000
+ 7.79050e-07 1.800 7.80000e-07 1.800 7.80050e-07 0.000 7.84000e-07 0.000 7.84050e-07 1.800 7.86000e-07 1.800
+ 7.86050e-07 0.000 7.87000e-07 0.000 7.87050e-07 1.800 7.88000e-07 1.800 7.88050e-07 0.000 7.89000e-07 0.000
+ 7.89050e-07 1.800 7.90000e-07 1.800 7.90050e-07 0.000 7.92000e-07 0.000 7.92050e-07 1.800 7.95000e-07 1.800
+ 7.95050e-07 0.000 7.96000e-07 0.000 7.96050e-07 1.800 7.99000e-07 1.800 7.99050e-07 0.000 8.01000e-07 0.000
+ 8.01050e-07 1.800 8.02000e-07 1.800 8.02050e-07 0.000 8.05000e-07 0.000 8.05050e-07 1.800 8.06000e-07 1.800
+ 8.06050e-07 0.000 8.10000e-07 0.000 8.10050e-07 1.800 8.12000e-07 1.800 8.12050e-07 0.000 8.21000e-07 0.000
+ 8.21050e-07 1.800 8.24000e-07 1.800 8.24050e-07 0.000 8.26000e-07 0.000 8.26050e-07 1.800 8.30000e-07 1.800
+ 8.30050e-07 0.000 8.31000e-07 0.000 8.31050e-07 1.800 8.32000e-07 1.800 8.32050e-07 0.000 8.33000e-07 0.000
+ 8.33050e-07 1.800 8.37000e-07 1.800 8.37050e-07 0.000 8.38000e-07 0.000 8.38050e-07 1.800 8.45000e-07 1.800
+ 8.45050e-07 0.000 8.47000e-07 0.000 8.47050e-07 1.800 8.48000e-07 1.800 8.48050e-07 0.000 8.50000e-07 0.000
+ 8.50050e-07 1.800 8.52000e-07 1.800 8.52050e-07 0.000 8.53000e-07 0.000 8.53050e-07 1.800 8.55000e-07 1.800
+ 8.55050e-07 0.000 8.61000e-07 0.000 8.61050e-07 1.800 8.62000e-07 1.800 8.62050e-07 0.000 8.66000e-07 0.000
+ 8.66050e-07 1.800 8.67000e-07 1.800 8.67050e-07 0.000 8.68000e-07 0.000 8.68050e-07 1.800 8.73000e-07 1.800
+ 8.73050e-07 0.000 8.74000e-07 0.000 8.74050e-07 1.800 8.75000e-07 1.800 8.75050e-07 0.000 8.76000e-07 0.000
+ 8.76050e-07 1.800 8.78000e-07 1.800 8.78050e-07 0.000 8.81000e-07 0.000 8.81050e-07 1.800 8.82000e-07 1.800
+ 8.82050e-07 0.000 8.83000e-07 0.000 8.83050e-07 1.800 8.84000e-07 1.800 8.84050e-07 0.000 8.87000e-07 0.000
+ 8.87050e-07 1.800 8.95000e-07 1.800 8.95050e-07 0.000 8.96000e-07 0.000 8.96050e-07 1.800 9.00000e-07 1.800
+ 9.00050e-07 0.000 9.01000e-07 0.000 9.01050e-07 1.800 9.02000e-07 1.800 9.02050e-07 0.000 9.04000e-07 0.000
+ 9.04050e-07 1.800 9.05000e-07 1.800 9.05050e-07 0.000 9.08000e-07 0.000 9.08050e-07 1.800 9.10000e-07 1.800
+ 9.10050e-07 0.000 9.11000e-07 0.000 9.11050e-07 1.800 9.14000e-07 1.800 9.14050e-07 0.000 9.15000e-07 0.000
+ 9.15050e-07 1.800 9.16000e-07 1.800 9.16050e-07 0.000 9.17000e-07 0.000 9.17050e-07 1.800 9.19000e-07 1.800
+ 9.19050e-07 0.000 9.20000e-07 0.000 9.20050e-07 1.800 9.22000e-07 1.800 9.22050e-07 0.000 9.23000e-07 0.000
+ 9.23050e-07 1.800 9.25000e-07 1.800 9.25050e-07 0.000 9.29000e-07 0.000 9.29050e-07 1.800 9.30000e-07 1.800
+ 9.30050e-07 0.000 9.31000e-07 0.000 9.31050e-07 1.800 9.33000e-07 1.800 9.33050e-07 0.000 9.34000e-07 0.000
+ 9.34050e-07 1.800 9.35000e-07 1.800 9.35050e-07 0.000 9.36000e-07 0.000 9.36050e-07 1.800 9.37000e-07 1.800
+ 9.37050e-07 0.000 9.39000e-07 0.000 9.39050e-07 1.800 9.41000e-07 1.800 9.41050e-07 0.000 9.42000e-07 0.000
+ 9.42050e-07 1.800 9.43000e-07 1.800 9.43050e-07 0.000 9.44000e-07 0.000 9.44050e-07 1.800 9.46000e-07 1.800
+ 9.46050e-07 0.000 9.48000e-07 0.000 9.48050e-07 1.800 9.50000e-07 1.800 9.50050e-07 0.000 9.51000e-07 0.000
+ 9.51050e-07 1.800 9.57000e-07 1.800 9.57050e-07 0.000 9.63000e-07 0.000 9.63050e-07 1.800 9.66000e-07 1.800
+ 9.66050e-07 0.000 9.67000e-07 0.000 9.67050e-07 1.800 9.69000e-07 1.800 9.69050e-07 0.000 9.72000e-07 0.000
+ 9.72050e-07 1.800 9.74000e-07 1.800 9.74050e-07 0.000 9.75000e-07 0.000 9.75050e-07 1.800 9.76000e-07 1.800
+ 9.76050e-07 0.000 9.77000e-07 0.000 9.77050e-07 1.800 9.79000e-07 1.800 9.79050e-07 0.000 9.81000e-07 0.000
+ 9.81050e-07 1.800 9.87000e-07 1.800 9.87050e-07 0.000 9.89000e-07 0.000 9.89050e-07 1.800 9.92000e-07 1.800
+ 9.92050e-07 0.000 9.93000e-07 0.000 9.93050e-07 1.800 9.94000e-07 1.800 9.94050e-07 0.000 9.96000e-07 0.000
+ 9.96050e-07 1.800 9.98000e-07 1.800 9.98050e-07 0.000 1.00000e-06 0.000 1.00005e-06 1.800 1.00100e-06 1.800
+ 1.00105e-06 0.000 1.00500e-06 0.000 1.00505e-06 1.800 1.00600e-06 1.800 1.00605e-06 0.000 1.00700e-06 0.000
+ 1.00705e-06 1.800 1.00900e-06 1.800 1.00905e-06 0.000 1.01100e-06 0.000 1.01105e-06 1.800 1.01200e-06 1.800
+ 1.01205e-06 0.000 1.01600e-06 0.000 1.01605e-06 1.800 1.01700e-06 1.800 1.01705e-06 0.000 1.01800e-06 0.000
+ 1.01805e-06 1.800 1.01900e-06 1.800 1.01905e-06 0.000 1.02200e-06 0.000 1.02205e-06 1.800 1.02300e-06 1.800
+ 1.02305e-06 0.000 1.02400e-06 0.000
+ )
Xd_t0b src_t0b t0b vdd gnd tb_inv
Vg1b src_g1b gnd PWL(
+ 0.00000e+00 1.800 6.40000e-08 1.800 6.40500e-08 0.000 1.28000e-07 0.000 1.28050e-07 1.800 1.92000e-07 1.800
+ 1.92050e-07 0.000 2.56000e-07 0.000 2.56050e-07 1.800 3.20000e-07 1.800 3.20050e-07 0.000 3.84000e-07 0.000
+ 3.84050e-07 1.800 4.48000e-07 1.800 4.48050e-07 0.000 5.13000e-07 0.000 5.13050e-07 1.800 5.16000e-07 1.800
+ 5.16050e-07 0.000 5.17000e-07 0.000 5.17050e-07 1.800 5.18000e-07 1.800 5.18050e-07 0.000 5.25000e-07 0.000
+ 5.25050e-07 1.800 5.27000e-07 1.800 5.27050e-07 0.000 5.30000e-07 0.000 5.30050e-07 1.800 5.31000e-07 1.800
+ 5.31050e-07 0.000 5.32000e-07 0.000 5.32050e-07 1.800 5.33000e-07 1.800 5.33050e-07 0.000 5.36000e-07 0.000
+ 5.36050e-07 1.800 5.37000e-07 1.800 5.37050e-07 0.000 5.38000e-07 0.000 5.38050e-07 1.800 5.39000e-07 1.800
+ 5.39050e-07 0.000 5.40000e-07 0.000 5.40050e-07 1.800 5.41000e-07 1.800 5.41050e-07 0.000 5.42000e-07 0.000
+ 5.42050e-07 1.800 5.43000e-07 1.800 5.43050e-07 0.000 5.44000e-07 0.000 5.44050e-07 1.800 5.45000e-07 1.800
+ 5.45050e-07 0.000 5.46000e-07 0.000 5.46050e-07 1.800 5.49000e-07 1.800 5.49050e-07 0.000 5.50000e-07 0.000
+ 5.50050e-07 1.800 5.51000e-07 1.800 5.51050e-07 0.000 5.55000e-07 0.000 5.55050e-07 1.800 5.56000e-07 1.800
+ 5.56050e-07 0.000 5.58000e-07 0.000 5.58050e-07 1.800 5.63000e-07 1.800 5.63050e-07 0.000 5.64000e-07 0.000
+ 5.64050e-07 1.800 5.66000e-07 1.800 5.66050e-07 0.000 5.67000e-07 0.000 5.67050e-07 1.800 5.68000e-07 1.800
+ 5.68050e-07 0.000 5.69000e-07 0.000 5.69050e-07 1.800 5.71000e-07 1.800 5.71050e-07 0.000 5.74000e-07 0.000
+ 5.74050e-07 1.800 5.75000e-07 1.800 5.75050e-07 0.000 5.76000e-07 0.000 5.76050e-07 1.800 5.78000e-07 1.800
+ 5.78050e-07 0.000 5.80000e-07 0.000 5.80050e-07 1.800 5.81000e-07 1.800 5.81050e-07 0.000 5.82000e-07 0.000
+ 5.82050e-07 1.800 5.83000e-07 1.800 5.83050e-07 0.000 5.84000e-07 0.000 5.84050e-07 1.800 5.88000e-07 1.800
+ 5.88050e-07 0.000 5.89000e-07 0.000 5.89050e-07 1.800 5.92000e-07 1.800 5.92050e-07 0.000 5.95000e-07 0.000
+ 5.95050e-07 1.800 5.96000e-07 1.800 5.96050e-07 0.000 5.99000e-07 0.000 5.99050e-07 1.800 6.00000e-07 1.800
+ 6.00050e-07 0.000 6.05000e-07 0.000 6.05050e-07 1.800 6.08000e-07 1.800 6.08050e-07 0.000 6.09000e-07 0.000
+ 6.09050e-07 1.800 6.10000e-07 1.800 6.10050e-07 0.000 6.12000e-07 0.000 6.12050e-07 1.800 6.14000e-07 1.800
+ 6.14050e-07 0.000 6.16000e-07 0.000 6.16050e-07 1.800 6.18000e-07 1.800 6.18050e-07 0.000 6.19000e-07 0.000
+ 6.19050e-07 1.800 6.20000e-07 1.800 6.20050e-07 0.000 6.21000e-07 0.000 6.21050e-07 1.800 6.22000e-07 1.800
+ 6.22050e-07 0.000 6.23000e-07 0.000 6.23050e-07 1.800 6.25000e-07 1.800 6.25050e-07 0.000 6.32000e-07 0.000
+ 6.32050e-07 1.800 6.35000e-07 1.800 6.35050e-07 0.000 6.37000e-07 0.000 6.37050e-07 1.800 6.38000e-07 1.800
+ 6.38050e-07 0.000 6.39000e-07 0.000 6.39050e-07 1.800 6.42000e-07 1.800 6.42050e-07 0.000 6.44000e-07 0.000
+ 6.44050e-07 1.800 6.45000e-07 1.800 6.45050e-07 0.000 6.46000e-07 0.000 6.46050e-07 1.800 6.47000e-07 1.800
+ 6.47050e-07 0.000 6.48000e-07 0.000 6.48050e-07 1.800 6.52000e-07 1.800 6.52050e-07 0.000 6.54000e-07 0.000
+ 6.54050e-07 1.800 6.56000e-07 1.800 6.56050e-07 0.000 6.59000e-07 0.000 6.59050e-07 1.800 6.62000e-07 1.800
+ 6.62050e-07 0.000 6.63000e-07 0.000 6.63050e-07 1.800 6.65000e-07 1.800 6.65050e-07 0.000 6.66000e-07 0.000
+ 6.66050e-07 1.800 6.67000e-07 1.800 6.67050e-07 0.000 6.68000e-07 0.000 6.68050e-07 1.800 6.69000e-07 1.800
+ 6.69050e-07 0.000 6.70000e-07 0.000 6.70050e-07 1.800 6.72000e-07 1.800 6.72050e-07 0.000 6.77000e-07 0.000
+ 6.77050e-07 1.800 6.80000e-07 1.800 6.80050e-07 0.000 6.81000e-07 0.000 6.81050e-07 1.800 6.83000e-07 1.800
+ 6.83050e-07 0.000 6.84000e-07 0.000 6.84050e-07 1.800 6.85000e-07 1.800 6.85050e-07 0.000 6.87000e-07 0.000
+ 6.87050e-07 1.800 6.88000e-07 1.800 6.88050e-07 0.000 6.89000e-07 0.000 6.89050e-07 1.800 6.92000e-07 1.800
+ 6.92050e-07 0.000 6.94000e-07 0.000 6.94050e-07 1.800 6.97000e-07 1.800 6.97050e-07 0.000 6.98000e-07 0.000
+ 6.98050e-07 1.800 7.01000e-07 1.800 7.01050e-07 0.000 7.04000e-07 0.000 7.04050e-07 1.800 7.05000e-07 1.800
+ 7.05050e-07 0.000 7.06000e-07 0.000 7.06050e-07 1.800 7.07000e-07 1.800 7.07050e-07 0.000 7.08000e-07 0.000
+ 7.08050e-07 1.800 7.09000e-07 1.800 7.09050e-07 0.000 7.13000e-07 0.000 7.13050e-07 1.800 7.14000e-07 1.800
+ 7.14050e-07 0.000 7.15000e-07 0.000 7.15050e-07 1.800 7.17000e-07 1.800 7.17050e-07 0.000 7.18000e-07 0.000
+ 7.18050e-07 1.800 7.19000e-07 1.800 7.19050e-07 0.000 7.20000e-07 0.000 7.20050e-07 1.800 7.24000e-07 1.800
+ 7.24050e-07 0.000 7.26000e-07 0.000 7.26050e-07 1.800 7.28000e-07 1.800 7.28050e-07 0.000 7.29000e-07 0.000
+ 7.29050e-07 1.800 7.31000e-07 1.800 7.31050e-07 0.000 7.33000e-07 0.000 7.33050e-07 1.800 7.35000e-07 1.800
+ 7.35050e-07 0.000 7.36000e-07 0.000 7.36050e-07 1.800 7.37000e-07 1.800 7.37050e-07 0.000 7.39000e-07 0.000
+ 7.39050e-07 1.800 7.41000e-07 1.800 7.41050e-07 0.000 7.42000e-07 0.000 7.42050e-07 1.800 7.46000e-07 1.800
+ 7.46050e-07 0.000 7.47000e-07 0.000 7.47050e-07 1.800 7.49000e-07 1.800 7.49050e-07 0.000 7.54000e-07 0.000
+ 7.54050e-07 1.800 7.55000e-07 1.800 7.55050e-07 0.000 7.56000e-07 0.000 7.56050e-07 1.800 7.58000e-07 1.800
+ 7.58050e-07 0.000 7.60000e-07 0.000 7.60050e-07 1.800 7.62000e-07 1.800 7.62050e-07 0.000 7.63000e-07 0.000
+ 7.63050e-07 1.800 7.65000e-07 1.800 7.65050e-07 0.000 7.66000e-07 0.000 7.66050e-07 1.800 7.73000e-07 1.800
+ 7.73050e-07 0.000 7.74000e-07 0.000 7.74050e-07 1.800 7.76000e-07 1.800 7.76050e-07 0.000 7.78000e-07 0.000
+ 7.78050e-07 1.800 7.80000e-07 1.800 7.80050e-07 0.000 7.84000e-07 0.000 7.84050e-07 1.800 7.85000e-07 1.800
+ 7.85050e-07 0.000 7.87000e-07 0.000 7.87050e-07 1.800 7.88000e-07 1.800 7.88050e-07 0.000 7.90000e-07 0.000
+ 7.90050e-07 1.800 7.91000e-07 1.800 7.91050e-07 0.000 7.93000e-07 0.000 7.93050e-07 1.800 7.94000e-07 1.800
+ 7.94050e-07 0.000 7.96000e-07 0.000 7.96050e-07 1.800 7.97000e-07 1.800 7.97050e-07 0.000 7.98000e-07 0.000
+ 7.98050e-07 1.800 7.99000e-07 1.800 7.99050e-07 0.000 8.01000e-07 0.000 8.01050e-07 1.800 8.05000e-07 1.800
+ 8.05050e-07 0.000 8.07000e-07 0.000 8.07050e-07 1.800 8.08000e-07 1.800 8.08050e-07 0.000 8.09000e-07 0.000
+ 8.09050e-07 1.800 8.12000e-07 1.800 8.12050e-07 0.000 8.14000e-07 0.000 8.14050e-07 1.800 8.15000e-07 1.800
+ 8.15050e-07 0.000 8.16000e-07 0.000 8.16050e-07 1.800 8.19000e-07 1.800 8.19050e-07 0.000 8.23000e-07 0.000
+ 8.23050e-07 1.800 8.24000e-07 1.800 8.24050e-07 0.000 8.25000e-07 0.000 8.25050e-07 1.800 8.26000e-07 1.800
+ 8.26050e-07 0.000 8.27000e-07 0.000 8.27050e-07 1.800 8.28000e-07 1.800 8.28050e-07 0.000 8.30000e-07 0.000
+ 8.30050e-07 1.800 8.32000e-07 1.800 8.32050e-07 0.000 8.33000e-07 0.000 8.33050e-07 1.800 8.37000e-07 1.800
+ 8.37050e-07 0.000 8.38000e-07 0.000 8.38050e-07 1.800 8.40000e-07 1.800 8.40050e-07 0.000 8.41000e-07 0.000
+ 8.41050e-07 1.800 8.43000e-07 1.800 8.43050e-07 0.000 8.47000e-07 0.000 8.47050e-07 1.800 8.48000e-07 1.800
+ 8.48050e-07 0.000 8.49000e-07 0.000 8.49050e-07 1.800 8.52000e-07 1.800 8.52050e-07 0.000 8.53000e-07 0.000
+ 8.53050e-07 1.800 8.58000e-07 1.800 8.58050e-07 0.000 8.60000e-07 0.000 8.60050e-07 1.800 8.61000e-07 1.800
+ 8.61050e-07 0.000 8.64000e-07 0.000 8.64050e-07 1.800 8.65000e-07 1.800 8.65050e-07 0.000 8.66000e-07 0.000
+ 8.66050e-07 1.800 8.67000e-07 1.800 8.67050e-07 0.000 8.69000e-07 0.000 8.69050e-07 1.800 8.71000e-07 1.800
+ 8.71050e-07 0.000 8.72000e-07 0.000 8.72050e-07 1.800 8.73000e-07 1.800 8.73050e-07 0.000 8.74000e-07 0.000
+ 8.74050e-07 1.800 8.75000e-07 1.800 8.75050e-07 0.000 8.80000e-07 0.000 8.80050e-07 1.800 8.82000e-07 1.800
+ 8.82050e-07 0.000 8.83000e-07 0.000 8.83050e-07 1.800 8.84000e-07 1.800 8.84050e-07 0.000 8.86000e-07 0.000
+ 8.86050e-07 1.800 8.88000e-07 1.800 8.88050e-07 0.000 8.89000e-07 0.000 8.89050e-07 1.800 8.90000e-07 1.800
+ 8.90050e-07 0.000 8.91000e-07 0.000 8.91050e-07 1.800 8.92000e-07 1.800 8.92050e-07 0.000 8.95000e-07 0.000
+ 8.95050e-07 1.800 8.99000e-07 1.800 8.99050e-07 0.000 9.00000e-07 0.000 9.00050e-07 1.800 9.02000e-07 1.800
+ 9.02050e-07 0.000 9.06000e-07 0.000 9.06050e-07 1.800 9.09000e-07 1.800 9.09050e-07 0.000 9.10000e-07 0.000
+ 9.10050e-07 1.800 9.13000e-07 1.800 9.13050e-07 0.000 9.15000e-07 0.000 9.15050e-07 1.800 9.17000e-07 1.800
+ 9.17050e-07 0.000 9.19000e-07 0.000 9.19050e-07 1.800 9.20000e-07 1.800 9.20050e-07 0.000 9.21000e-07 0.000
+ 9.21050e-07 1.800 9.23000e-07 1.800 9.23050e-07 0.000 9.27000e-07 0.000 9.27050e-07 1.800 9.29000e-07 1.800
+ 9.29050e-07 0.000 9.31000e-07 0.000 9.31050e-07 1.800 9.33000e-07 1.800 9.33050e-07 0.000 9.34000e-07 0.000
+ 9.34050e-07 1.800 9.35000e-07 1.800 9.35050e-07 0.000 9.36000e-07 0.000 9.36050e-07 1.800 9.39000e-07 1.800
+ 9.39050e-07 0.000 9.41000e-07 0.000 9.41050e-07 1.800 9.43000e-07 1.800 9.43050e-07 0.000 9.44000e-07 0.000
+ 9.44050e-07 1.800 9.45000e-07 1.800 9.45050e-07 0.000 9.47000e-07 0.000 9.47050e-07 1.800 9.48000e-07 1.800
+ 9.48050e-07 0.000 9.49000e-07 0.000 9.49050e-07 1.800 9.51000e-07 1.800 9.51050e-07 0.000 9.54000e-07 0.000
+ 9.54050e-07 1.800 9.55000e-07 1.800 9.55050e-07 0.000 9.56000e-07 0.000 9.56050e-07 1.800 9.58000e-07 1.800
+ 9.58050e-07 0.000 9.60000e-07 0.000 9.60050e-07 1.800 9.61000e-07 1.800 9.61050e-07 0.000 9.66000e-07 0.000
+ 9.66050e-07 1.800 9.67000e-07 1.800 9.67050e-07 0.000 9.68000e-07 0.000 9.68050e-07 1.800 9.69000e-07 1.800
+ 9.69050e-07 0.000 9.73000e-07 0.000 9.73050e-07 1.800 9.74000e-07 1.800 9.74050e-07 0.000 9.81000e-07 0.000
+ 9.81050e-07 1.800 9.83000e-07 1.800 9.83050e-07 0.000 9.84000e-07 0.000 9.84050e-07 1.800 9.88000e-07 1.800
+ 9.88050e-07 0.000 9.89000e-07 0.000 9.89050e-07 1.800 9.91000e-07 1.800 9.91050e-07 0.000 9.94000e-07 0.000
+ 9.94050e-07 1.800 9.95000e-07 1.800 9.95050e-07 0.000 9.97000e-07 0.000 9.97050e-07 1.800 1.00100e-06 1.800
+ 1.00105e-06 0.000 1.00300e-06 0.000 1.00305e-06 1.800 1.00400e-06 1.800 1.00405e-06 0.000 1.00500e-06 0.000
+ 1.00505e-06 1.800 1.00600e-06 1.800 1.00605e-06 0.000 1.00700e-06 0.000 1.00705e-06 1.800 1.00800e-06 1.800
+ 1.00805e-06 0.000 1.00900e-06 0.000 1.00905e-06 1.800 1.01000e-06 1.800 1.01005e-06 0.000 1.01400e-06 0.000
+ 1.01405e-06 1.800 1.01500e-06 1.800 1.01505e-06 0.000 1.01600e-06 0.000 1.01605e-06 1.800 1.02400e-06 1.800
+ )
Xd_g1b src_g1b g1b vdd gnd tb_inv
Vt1b src_t1b gnd PWL(
+ 0.00000e+00 1.800 3.20000e-08 1.800 3.20500e-08 0.000 6.40000e-08 0.000 6.40500e-08 1.800 9.60000e-08 1.800
+ 9.60500e-08 0.000 1.28000e-07 0.000 1.28050e-07 1.800 1.60000e-07 1.800 1.60050e-07 0.000 1.92000e-07 0.000
+ 1.92050e-07 1.800 2.24000e-07 1.800 2.24050e-07 0.000 2.56000e-07 0.000 2.56050e-07 1.800 2.88000e-07 1.800
+ 2.88050e-07 0.000 3.20000e-07 0.000 3.20050e-07 1.800 3.52000e-07 1.800 3.52050e-07 0.000 3.84000e-07 0.000
+ 3.84050e-07 1.800 4.16000e-07 1.800 4.16050e-07 0.000 4.48000e-07 0.000 4.48050e-07 1.800 4.80000e-07 1.800
+ 4.80050e-07 0.000 5.12000e-07 0.000 5.12050e-07 1.800 5.13000e-07 1.800 5.13050e-07 0.000 5.14000e-07 0.000
+ 5.14050e-07 1.800 5.17000e-07 1.800 5.17050e-07 0.000 5.18000e-07 0.000 5.18050e-07 1.800 5.19000e-07 1.800
+ 5.19050e-07 0.000 5.20000e-07 0.000 5.20050e-07 1.800 5.23000e-07 1.800 5.23050e-07 0.000 5.24000e-07 0.000
+ 5.24050e-07 1.800 5.25000e-07 1.800 5.25050e-07 0.000 5.27000e-07 0.000 5.27050e-07 1.800 5.32000e-07 1.800
+ 5.32050e-07 0.000 5.33000e-07 0.000 5.33050e-07 1.800 5.35000e-07 1.800 5.35050e-07 0.000 5.36000e-07 0.000
+ 5.36050e-07 1.800 5.37000e-07 1.800 5.37050e-07 0.000 5.40000e-07 0.000 5.40050e-07 1.800 5.41000e-07 1.800
+ 5.41050e-07 0.000 5.42000e-07 0.000 5.42050e-07 1.800 5.44000e-07 1.800 5.44050e-07 0.000 5.45000e-07 0.000
+ 5.45050e-07 1.800 5.46000e-07 1.800 5.46050e-07 0.000 5.48000e-07 0.000 5.48050e-07 1.800 5.49000e-07 1.800
+ 5.49050e-07 0.000 5.52000e-07 0.000 5.52050e-07 1.800 5.53000e-07 1.800 5.53050e-07 0.000 5.54000e-07 0.000
+ 5.54050e-07 1.800 5.55000e-07 1.800 5.55050e-07 0.000 5.62000e-07 0.000 5.62050e-07 1.800 5.65000e-07 1.800
+ 5.65050e-07 0.000 5.70000e-07 0.000 5.70050e-07 1.800 5.71000e-07 1.800 5.71050e-07 0.000 5.73000e-07 0.000
+ 5.73050e-07 1.800 5.75000e-07 1.800 5.75050e-07 0.000 5.80000e-07 0.000 5.80050e-07 1.800 5.81000e-07 1.800
+ 5.81050e-07 0.000 5.82000e-07 0.000 5.82050e-07 1.800 5.85000e-07 1.800 5.85050e-07 0.000 5.86000e-07 0.000
+ 5.86050e-07 1.800 5.88000e-07 1.800 5.88050e-07 0.000 5.89000e-07 0.000 5.89050e-07 1.800 5.90000e-07 1.800
+ 5.90050e-07 0.000 5.93000e-07 0.000 5.93050e-07 1.800 5.95000e-07 1.800 5.95050e-07 0.000 5.96000e-07 0.000
+ 5.96050e-07 1.800 5.99000e-07 1.800 5.99050e-07 0.000 6.02000e-07 0.000 6.02050e-07 1.800 6.03000e-07 1.800
+ 6.03050e-07 0.000 6.08000e-07 0.000 6.08050e-07 1.800 6.09000e-07 1.800 6.09050e-07 0.000 6.12000e-07 0.000
+ 6.12050e-07 1.800 6.14000e-07 1.800 6.14050e-07 0.000 6.15000e-07 0.000 6.15050e-07 1.800 6.17000e-07 1.800
+ 6.17050e-07 0.000 6.18000e-07 0.000 6.18050e-07 1.800 6.19000e-07 1.800 6.19050e-07 0.000 6.20000e-07 0.000
+ 6.20050e-07 1.800 6.22000e-07 1.800 6.22050e-07 0.000 6.23000e-07 0.000 6.23050e-07 1.800 6.24000e-07 1.800
+ 6.24050e-07 0.000 6.25000e-07 0.000 6.25050e-07 1.800 6.26000e-07 1.800 6.26050e-07 0.000 6.30000e-07 0.000
+ 6.30050e-07 1.800 6.32000e-07 1.800 6.32050e-07 0.000 6.33000e-07 0.000 6.33050e-07 1.800 6.36000e-07 1.800
+ 6.36050e-07 0.000 6.37000e-07 0.000 6.37050e-07 1.800 6.39000e-07 1.800 6.39050e-07 0.000 6.43000e-07 0.000
+ 6.43050e-07 1.800 6.45000e-07 1.800 6.45050e-07 0.000 6.46000e-07 0.000 6.46050e-07 1.800 6.47000e-07 1.800
+ 6.47050e-07 0.000 6.48000e-07 0.000 6.48050e-07 1.800 6.49000e-07 1.800 6.49050e-07 0.000 6.51000e-07 0.000
+ 6.51050e-07 1.800 6.53000e-07 1.800 6.53050e-07 0.000 6.55000e-07 0.000 6.55050e-07 1.800 6.58000e-07 1.800
+ 6.58050e-07 0.000 6.59000e-07 0.000 6.59050e-07 1.800 6.61000e-07 1.800 6.61050e-07 0.000 6.63000e-07 0.000
+ 6.63050e-07 1.800 6.65000e-07 1.800 6.65050e-07 0.000 6.71000e-07 0.000 6.71050e-07 1.800 6.73000e-07 1.800
+ 6.73050e-07 0.000 6.77000e-07 0.000 6.77050e-07 1.800 6.78000e-07 1.800 6.78050e-07 0.000 6.81000e-07 0.000
+ 6.81050e-07 1.800 6.82000e-07 1.800 6.82050e-07 0.000 6.83000e-07 0.000 6.83050e-07 1.800 6.85000e-07 1.800
+ 6.85050e-07 0.000 6.86000e-07 0.000 6.86050e-07 1.800 6.91000e-07 1.800 6.91050e-07 0.000 6.92000e-07 0.000
+ 6.92050e-07 1.800 6.93000e-07 1.800 6.93050e-07 0.000 6.97000e-07 0.000 6.97050e-07 1.800 7.00000e-07 1.800
+ 7.00050e-07 0.000 7.01000e-07 0.000 7.01050e-07 1.800 7.02000e-07 1.800 7.02050e-07 0.000 7.03000e-07 0.000
+ 7.03050e-07 1.800 7.04000e-07 1.800 7.04050e-07 0.000 7.07000e-07 0.000 7.07050e-07 1.800 7.09000e-07 1.800
+ 7.09050e-07 0.000 7.10000e-07 0.000 7.10050e-07 1.800 7.11000e-07 1.800 7.11050e-07 0.000 7.12000e-07 0.000
+ 7.12050e-07 1.800 7.13000e-07 1.800 7.13050e-07 0.000 7.17000e-07 0.000 7.17050e-07 1.800 7.19000e-07 1.800
+ 7.19050e-07 0.000 7.21000e-07 0.000 7.21050e-07 1.800 7.22000e-07 1.800 7.22050e-07 0.000 7.24000e-07 0.000
+ 7.24050e-07 1.800 7.29000e-07 1.800 7.29050e-07 0.000 7.31000e-07 0.000 7.31050e-07 1.800 7.32000e-07 1.800
+ 7.32050e-07 0.000 7.34000e-07 0.000 7.34050e-07 1.800 7.35000e-07 1.800 7.35050e-07 0.000 7.37000e-07 0.000
+ 7.37050e-07 1.800 7.39000e-07 1.800 7.39050e-07 0.000 7.40000e-07 0.000 7.40050e-07 1.800 7.44000e-07 1.800
+ 7.44050e-07 0.000 7.52000e-07 0.000 7.52050e-07 1.800 7.54000e-07 1.800 7.54050e-07 0.000 7.57000e-07 0.000
+ 7.57050e-07 1.800 7.60000e-07 1.800 7.60050e-07 0.000 7.62000e-07 0.000 7.62050e-07 1.800 7.64000e-07 1.800
+ 7.64050e-07 0.000 7.70000e-07 0.000 7.70050e-07 1.800 7.72000e-07 1.800 7.72050e-07 0.000 7.73000e-07 0.000
+ 7.73050e-07 1.800 7.76000e-07 1.800 7.76050e-07 0.000 7.77000e-07 0.000 7.77050e-07 1.800 7.85000e-07 1.800
+ 7.85050e-07 0.000 7.87000e-07 0.000 7.87050e-07 1.800 7.89000e-07 1.800 7.89050e-07 0.000 7.92000e-07 0.000
+ 7.92050e-07 1.800 7.97000e-07 1.800 7.97050e-07 0.000 7.98000e-07 0.000 7.98050e-07 1.800 7.99000e-07 1.800
+ 7.99050e-07 0.000 8.01000e-07 0.000 8.01050e-07 1.800 8.05000e-07 1.800 8.05050e-07 0.000 8.06000e-07 0.000
+ 8.06050e-07 1.800 8.07000e-07 1.800 8.07050e-07 0.000 8.08000e-07 0.000 8.08050e-07 1.800 8.11000e-07 1.800
+ 8.11050e-07 0.000 8.16000e-07 0.000 8.16050e-07 1.800 8.18000e-07 1.800 8.18050e-07 0.000 8.19000e-07 0.000
+ 8.19050e-07 1.800 8.23000e-07 1.800 8.23050e-07 0.000 8.24000e-07 0.000 8.24050e-07 1.800 8.25000e-07 1.800
+ 8.25050e-07 0.000 8.26000e-07 0.000 8.26050e-07 1.800 8.27000e-07 1.800 8.27050e-07 0.000 8.30000e-07 0.000
+ 8.30050e-07 1.800 8.32000e-07 1.800 8.32050e-07 0.000 8.33000e-07 0.000 8.33050e-07 1.800 8.34000e-07 1.800
+ 8.34050e-07 0.000 8.36000e-07 0.000 8.36050e-07 1.800 8.37000e-07 1.800 8.37050e-07 0.000 8.38000e-07 0.000
+ 8.38050e-07 1.800 8.39000e-07 1.800 8.39050e-07 0.000 8.40000e-07 0.000 8.40050e-07 1.800 8.41000e-07 1.800
+ 8.41050e-07 0.000 8.42000e-07 0.000 8.42050e-07 1.800 8.47000e-07 1.800 8.47050e-07 0.000 8.53000e-07 0.000
+ 8.53050e-07 1.800 8.55000e-07 1.800 8.55050e-07 0.000 8.56000e-07 0.000 8.56050e-07 1.800 8.57000e-07 1.800
+ 8.57050e-07 0.000 8.59000e-07 0.000 8.59050e-07 1.800 8.60000e-07 1.800 8.60050e-07 0.000 8.62000e-07 0.000
+ 8.62050e-07 1.800 8.63000e-07 1.800 8.63050e-07 0.000 8.66000e-07 0.000 8.66050e-07 1.800 8.68000e-07 1.800
+ 8.68050e-07 0.000 8.69000e-07 0.000 8.69050e-07 1.800 8.75000e-07 1.800 8.75050e-07 0.000 8.77000e-07 0.000
+ 8.77050e-07 1.800 8.78000e-07 1.800 8.78050e-07 0.000 8.79000e-07 0.000 8.79050e-07 1.800 8.80000e-07 1.800
+ 8.80050e-07 0.000 8.82000e-07 0.000 8.82050e-07 1.800 8.88000e-07 1.800 8.88050e-07 0.000 8.89000e-07 0.000
+ 8.89050e-07 1.800 8.90000e-07 1.800 8.90050e-07 0.000 8.91000e-07 0.000 8.91050e-07 1.800 8.96000e-07 1.800
+ 8.96050e-07 0.000 9.00000e-07 0.000 9.00050e-07 1.800 9.02000e-07 1.800 9.02050e-07 0.000 9.03000e-07 0.000
+ 9.03050e-07 1.800 9.04000e-07 1.800 9.04050e-07 0.000 9.08000e-07 0.000 9.08050e-07 1.800 9.11000e-07 1.800
+ 9.11050e-07 0.000 9.12000e-07 0.000 9.12050e-07 1.800 9.15000e-07 1.800 9.15050e-07 0.000 9.18000e-07 0.000
+ 9.18050e-07 1.800 9.20000e-07 1.800 9.20050e-07 0.000 9.21000e-07 0.000 9.21050e-07 1.800 9.22000e-07 1.800
+ 9.22050e-07 0.000 9.23000e-07 0.000 9.23050e-07 1.800 9.28000e-07 1.800 9.28050e-07 0.000 9.31000e-07 0.000
+ 9.31050e-07 1.800 9.32000e-07 1.800 9.32050e-07 0.000 9.33000e-07 0.000 9.33050e-07 1.800 9.35000e-07 1.800
+ 9.35050e-07 0.000 9.37000e-07 0.000 9.37050e-07 1.800 9.39000e-07 1.800 9.39050e-07 0.000 9.40000e-07 0.000
+ 9.40050e-07 1.800 9.41000e-07 1.800 9.41050e-07 0.000 9.42000e-07 0.000 9.42050e-07 1.800 9.45000e-07 1.800
+ 9.45050e-07 0.000 9.50000e-07 0.000 9.50050e-07 1.800 9.51000e-07 1.800 9.51050e-07 0.000 9.52000e-07 0.000
+ 9.52050e-07 1.800 9.54000e-07 1.800 9.54050e-07 0.000 9.55000e-07 0.000 9.55050e-07 1.800 9.57000e-07 1.800
+ 9.57050e-07 0.000 9.58000e-07 0.000 9.58050e-07 1.800 9.61000e-07 1.800 9.61050e-07 0.000 9.64000e-07 0.000
+ 9.64050e-07 1.800 9.65000e-07 1.800 9.65050e-07 0.000 9.68000e-07 0.000 9.68050e-07 1.800 9.69000e-07 1.800
+ 9.69050e-07 0.000 9.73000e-07 0.000 9.73050e-07 1.800 9.74000e-07 1.800 9.74050e-07 0.000 9.76000e-07 0.000
+ 9.76050e-07 1.800 9.77000e-07 1.800 9.77050e-07 0.000 9.78000e-07 0.000 9.78050e-07 1.800 9.87000e-07 1.800
+ 9.87050e-07 0.000 9.88000e-07 0.000 9.88050e-07 1.800 9.89000e-07 1.800 9.89050e-07 0.000 9.94000e-07 0.000
+ 9.94050e-07 1.800 9.95000e-07 1.800 9.95050e-07 0.000 9.97000e-07 0.000 9.97050e-07 1.800 1.00000e-06 1.800
+ 1.00005e-06 0.000 1.00100e-06 0.000 1.00105e-06 1.800 1.00300e-06 1.800 1.00305e-06 0.000 1.00400e-06 0.000
+ 1.00405e-06 1.800 1.00600e-06 1.800 1.00605e-06 0.000 1.00900e-06 0.000 1.00905e-06 1.800 1.01200e-06 1.800
+ 1.01205e-06 0.000 1.01400e-06 0.000 1.01405e-06 1.800 1.01500e-06 1.800 1.01505e-06 0.000 1.01700e-06 0.000
+ 1.01705e-06 1.800 1.01800e-06 1.800 1.01805e-06 0.000 1.01900e-06 0.000 1.01905e-06 1.800 1.02100e-06 1.800
+ 1.02105e-06 0.000 1.02300e-06 0.000 1.02305e-06 1.800 1.02400e-06 1.800
+ )
Xd_t1b src_t1b t1b vdd gnd tb_inv
Vg2b src_g2b gnd PWL(
+ 0.00000e+00 1.800 1.60000e-08 1.800 1.60500e-08 0.000 3.20000e-08 0.000 3.20500e-08 1.800 4.80000e-08 1.800
+ 4.80500e-08 0.000 6.40000e-08 0.000 6.40500e-08 1.800 8.00000e-08 1.800 8.00500e-08 0.000 9.60000e-08 0.000
+ 9.60500e-08 1.800 1.12000e-07 1.800 1.12050e-07 0.000 1.28000e-07 0.000 1.28050e-07 1.800 1.44000e-07 1.800
+ 1.44050e-07 0.000 1.60000e-07 0.000 1.60050e-07 1.800 1.76000e-07 1.800 1.76050e-07 0.000 1.92000e-07 0.000
+ 1.92050e-07 1.800 2.08000e-07 1.800 2.08050e-07 0.000 2.24000e-07 0.000 2.24050e-07 1.800 2.40000e-07 1.800
+ 2.40050e-07 0.000 2.56000e-07 0.000 2.56050e-07 1.800 2.72000e-07 1.800 2.72050e-07 0.000 2.88000e-07 0.000
+ 2.88050e-07 1.800 3.04000e-07 1.800 3.04050e-07 0.000 3.20000e-07 0.000 3.20050e-07 1.800 3.36000e-07 1.800
+ 3.36050e-07 0.000 3.52000e-07 0.000 3.52050e-07 1.800 3.68000e-07 1.800 3.68050e-07 0.000 3.84000e-07 0.000
+ 3.84050e-07 1.800 4.00000e-07 1.800 4.00050e-07 0.000 4.16000e-07 0.000 4.16050e-07 1.800 4.32000e-07 1.800
+ 4.32050e-07 0.000 4.48000e-07 0.000 4.48050e-07 1.800 4.64000e-07 1.800 4.64050e-07 0.000 4.80000e-07 0.000
+ 4.80050e-07 1.800 4.96000e-07 1.800 4.96050e-07 0.000 5.14000e-07 0.000 5.14050e-07 1.800 5.15000e-07 1.800
+ 5.15050e-07 0.000 5.16000e-07 0.000 5.16050e-07 1.800 5.17000e-07 1.800 5.17050e-07 0.000 5.18000e-07 0.000
+ 5.18050e-07 1.800 5.19000e-07 1.800 5.19050e-07 0.000 5.22000e-07 0.000 5.22050e-07 1.800 5.24000e-07 1.800
+ 5.24050e-07 0.000 5.25000e-07 0.000 5.25050e-07 1.800 5.26000e-07 1.800 5.26050e-07 0.000 5.28000e-07 0.000
+ 5.28050e-07 1.800 5.29000e-07 1.800 5.29050e-07 0.000 5.31000e-07 0.000 5.31050e-07 1.800 5.34000e-07 1.800
+ 5.34050e-07 0.000 5.35000e-07 0.000 5.35050e-07 1.800 5.40000e-07 1.800 5.40050e-07 0.000 5.42000e-07 0.000
+ 5.42050e-07 1.800 5.45000e-07 1.800 5.45050e-07 0.000 5.47000e-07 0.000 5.47050e-07 1.800 5.48000e-07 1.800
+ 5.48050e-07 0.000 5.50000e-07 0.000 5.50050e-07 1.800 5.51000e-07 1.800 5.51050e-07 0.000 5.52000e-07 0.000
+ 5.52050e-07 1.800 5.53000e-07 1.800 5.53050e-07 0.000 5.56000e-07 0.000 5.56050e-07 1.800 5.62000e-07 1.800
+ 5.62050e-07 0.000 5.63000e-07 0.000 5.63050e-07 1.800 5.65000e-07 1.800 5.65050e-07 0.000 5.66000e-07 0.000
+ 5.66050e-07 1.800 5.67000e-07 1.800 5.67050e-07 0.000 5.72000e-07 0.000 5.72050e-07 1.800 5.73000e-07 1.800
+ 5.73050e-07 0.000 5.74000e-07 0.000 5.74050e-07 1.800 5.75000e-07 1.800 5.75050e-07 0.000 5.76000e-07 0.000
+ 5.76050e-07 1.800 5.77000e-07 1.800 5.77050e-07 0.000 5.78000e-07 0.000 5.78050e-07 1.800 5.79000e-07 1.800
+ 5.79050e-07 0.000 5.80000e-07 0.000 5.80050e-07 1.800 5.84000e-07 1.800 5.84050e-07 0.000 5.85000e-07 0.000
+ 5.85050e-07 1.800 5.86000e-07 1.800 5.86050e-07 0.000 5.89000e-07 0.000 5.89050e-07 1.800 5.95000e-07 1.800
+ 5.95050e-07 0.000 5.96000e-07 0.000 5.96050e-07 1.800 5.97000e-07 1.800 5.97050e-07 0.000 5.98000e-07 0.000
+ 5.98050e-07 1.800 5.99000e-07 1.800 5.99050e-07 0.000 6.00000e-07 0.000 6.00050e-07 1.800 6.01000e-07 1.800
+ 6.01050e-07 0.000 6.02000e-07 0.000 6.02050e-07 1.800 6.03000e-07 1.800 6.03050e-07 0.000 6.06000e-07 0.000
+ 6.06050e-07 1.800 6.07000e-07 1.800 6.07050e-07 0.000 6.08000e-07 0.000 6.08050e-07 1.800 6.09000e-07 1.800
+ 6.09050e-07 0.000 6.10000e-07 0.000 6.10050e-07 1.800 6.15000e-07 1.800 6.15050e-07 0.000 6.16000e-07 0.000
+ 6.16050e-07 1.800 6.18000e-07 1.800 6.18050e-07 0.000 6.21000e-07 0.000 6.21050e-07 1.800 6.23000e-07 1.800
+ 6.23050e-07 0.000 6.24000e-07 0.000 6.24050e-07 1.800 6.28000e-07 1.800 6.28050e-07 0.000 6.29000e-07 0.000
+ 6.29050e-07 1.800 6.30000e-07 1.800 6.30050e-07 0.000 6.34000e-07 0.000 6.34050e-07 1.800 6.35000e-07 1.800
+ 6.35050e-07 0.000 6.36000e-07 0.000 6.36050e-07 1.800 6.37000e-07 1.800 6.37050e-07 0.000 6.38000e-07 0.000
+ 6.38050e-07 1.800 6.41000e-07 1.800 6.41050e-07 0.000 6.42000e-07 0.000 6.42050e-07 1.800 6.43000e-07 1.800
+ 6.43050e-07 0.000 6.44000e-07 0.000 6.44050e-07 1.800 6.46000e-07 1.800 6.46050e-07 0.000 6.48000e-07 0.000
+ 6.48050e-07 1.800 6.50000e-07 1.800 6.50050e-07 0.000 6.52000e-07 0.000 6.52050e-07 1.800 6.53000e-07 1.800
+ 6.53050e-07 0.000 6.54000e-07 0.000 6.54050e-07 1.800 6.55000e-07 1.800 6.55050e-07 0.000 6.58000e-07 0.000
+ 6.58050e-07 1.800 6.59000e-07 1.800 6.59050e-07 0.000 6.62000e-07 0.000 6.62050e-07 1.800 6.63000e-07 1.800
+ 6.63050e-07 0.000 6.65000e-07 0.000 6.65050e-07 1.800 6.66000e-07 1.800 6.66050e-07 0.000 6.67000e-07 0.000
+ 6.67050e-07 1.800 6.69000e-07 1.800 6.69050e-07 0.000 6.70000e-07 0.000 6.70050e-07 1.800 6.75000e-07 1.800
+ 6.75050e-07 0.000 6.76000e-07 0.000 6.76050e-07 1.800 6.78000e-07 1.800 6.78050e-07 0.000 6.83000e-07 0.000
+ 6.83050e-07 1.800 6.84000e-07 1.800 6.84050e-07 0.000 6.87000e-07 0.000 6.87050e-07 1.800 6.89000e-07 1.800
+ 6.89050e-07 0.000 6.92000e-07 0.000 6.92050e-07 1.800 6.93000e-07 1.800 6.93050e-07 0.000 6.96000e-07 0.000
+ 6.96050e-07 1.800 6.98000e-07 1.800 6.98050e-07 0.000 7.01000e-07 0.000 7.01050e-07 1.800 7.02000e-07 1.800
+ 7.02050e-07 0.000 7.03000e-07 0.000 7.03050e-07 1.800 7.06000e-07 1.800 7.06050e-07 0.000 7.07000e-07 0.000
+ 7.07050e-07 1.800 7.13000e-07 1.800 7.13050e-07 0.000 7.14000e-07 0.000 7.14050e-07 1.800 7.15000e-07 1.800
+ 7.15050e-07 0.000 7.16000e-07 0.000 7.16050e-07 1.800 7.18000e-07 1.800 7.18050e-07 0.000 7.20000e-07 0.000
+ 7.20050e-07 1.800 7.25000e-07 1.800 7.25050e-07 0.000 7.26000e-07 0.000 7.26050e-07 1.800 7.27000e-07 1.800
+ 7.27050e-07 0.000 7.30000e-07 0.000 7.30050e-07 1.800 7.33000e-07 1.800 7.33050e-07 0.000 7.37000e-07 0.000
+ 7.37050e-07 1.800 7.38000e-07 1.800 7.38050e-07 0.000 7.39000e-07 0.000 7.39050e-07 1.800 7.40000e-07 1.800
+ 7.40050e-07 0.000 7.45000e-07 0.000 7.45050e-07 1.800 7.47000e-07 1.800 7.47050e-07 0.000 7.48000e-07 0.000
+ 7.48050e-07 1.800 7.49000e-07 1.800 7.49050e-07 0.000 7.50000e-07 0.000 7.50050e-07 1.800 7.52000e-07 1.800
+ 7.52050e-07 0.000 7.54000e-07 0.000 7.54050e-07 1.800 7.55000e-07 1.800 7.55050e-07 0.000 7.56000e-07 0.000
+ 7.56050e-07 1.800 7.57000e-07 1.800 7.57050e-07 0.000 7.65000e-07 0.000 7.65050e-07 1.800 7.68000e-07 1.800
+ 7.68050e-07 0.000 7.70000e-07 0.000 7.70050e-07 1.800 7.71000e-07 1.800 7.71050e-07 0.000 7.72000e-07 0.000
+ 7.72050e-07 1.800 7.74000e-07 1.800 7.74050e-07 0.000 7.76000e-07 0.000 7.76050e-07 1.800 7.78000e-07 1.800
+ 7.78050e-07 0.000 7.82000e-07 0.000 7.82050e-07 1.800 7.85000e-07 1.800 7.85050e-07 0.000 7.87000e-07 0.000
+ 7.87050e-07 1.800 7.88000e-07 1.800 7.88050e-07 0.000 7.89000e-07 0.000 7.89050e-07 1.800 7.92000e-07 1.800
+ 7.92050e-07 0.000 7.94000e-07 0.000 7.94050e-07 1.800 7.97000e-07 1.800 7.97050e-07 0.000 7.98000e-07 0.000
+ 7.98050e-07 1.800 8.00000e-07 1.800 8.00050e-07 0.000 8.01000e-07 0.000 8.01050e-07 1.800 8.06000e-07 1.800
+ 8.06050e-07 0.000 8.07000e-07 0.000 8.07050e-07 1.800 8.09000e-07 1.800 8.09050e-07 0.000 8.10000e-07 0.000
+ 8.10050e-07 1.800 8.11000e-07 1.800 8.11050e-07 0.000 8.14000e-07 0.000 8.14050e-07 1.800 8.16000e-07 1.800
+ 8.16050e-07 0.000 8.17000e-07 0.000 8.17050e-07 1.800 8.19000e-07 1.800 8.19050e-07 0.000 8.23000e-07 0.000
+ 8.23050e-07 1.800 8.25000e-07 1.800 8.25050e-07 0.000 8.28000e-07 0.000 8.28050e-07 1.800 8.29000e-07 1.800
+ 8.29050e-07 0.000 8.30000e-07 0.000 8.30050e-07 1.800 8.36000e-07 1.800 8.36050e-07 0.000 8.39000e-07 0.000
+ 8.39050e-07 1.800 8.40000e-07 1.800 8.40050e-07 0.000 8.41000e-07 0.000 8.41050e-07 1.800 8.42000e-07 1.800
+ 8.42050e-07 0.000 8.44000e-07 0.000 8.44050e-07 1.800 8.45000e-07 1.800 8.45050e-07 0.000 8.46000e-07 0.000
+ 8.46050e-07 1.800 8.47000e-07 1.800 8.47050e-07 0.000 8.48000e-07 0.000 8.48050e-07 1.800 8.50000e-07 1.800
+ 8.50050e-07 0.000 8.52000e-07 0.000 8.52050e-07 1.800 8.53000e-07 1.800 8.53050e-07 0.000 8.54000e-07 0.000
+ 8.54050e-07 1.800 8.55000e-07 1.800 8.55050e-07 0.000 8.60000e-07 0.000 8.60050e-07 1.800 8.61000e-07 1.800
+ 8.61050e-07 0.000 8.62000e-07 0.000 8.62050e-07 1.800 8.63000e-07 1.800 8.63050e-07 0.000 8.68000e-07 0.000
+ 8.68050e-07 1.800 8.69000e-07 1.800 8.69050e-07 0.000 8.70000e-07 0.000 8.70050e-07 1.800 8.76000e-07 1.800
+ 8.76050e-07 0.000 8.79000e-07 0.000 8.79050e-07 1.800 8.80000e-07 1.800 8.80050e-07 0.000 8.81000e-07 0.000
+ 8.81050e-07 1.800 8.86000e-07 1.800 8.86050e-07 0.000 8.88000e-07 0.000 8.88050e-07 1.800 8.90000e-07 1.800
+ 8.90050e-07 0.000 8.91000e-07 0.000 8.91050e-07 1.800 8.92000e-07 1.800 8.92050e-07 0.000 8.94000e-07 0.000
+ 8.94050e-07 1.800 8.98000e-07 1.800 8.98050e-07 0.000 8.99000e-07 0.000 8.99050e-07 1.800 9.00000e-07 1.800
+ 9.00050e-07 0.000 9.07000e-07 0.000 9.07050e-07 1.800 9.09000e-07 1.800 9.09050e-07 0.000 9.10000e-07 0.000
+ 9.10050e-07 1.800 9.11000e-07 1.800 9.11050e-07 0.000 9.12000e-07 0.000 9.12050e-07 1.800 9.13000e-07 1.800
+ 9.13050e-07 0.000 9.14000e-07 0.000 9.14050e-07 1.800 9.16000e-07 1.800 9.16050e-07 0.000 9.19000e-07 0.000
+ 9.19050e-07 1.800 9.21000e-07 1.800 9.21050e-07 0.000 9.26000e-07 0.000 9.26050e-07 1.800 9.27000e-07 1.800
+ 9.27050e-07 0.000 9.32000e-07 0.000 9.32050e-07 1.800 9.35000e-07 1.800 9.35050e-07 0.000 9.36000e-07 0.000
+ 9.36050e-07 1.800 9.37000e-07 1.800 9.37050e-07 0.000 9.39000e-07 0.000 9.39050e-07 1.800 9.40000e-07 1.800
+ 9.40050e-07 0.000 9.41000e-07 0.000 9.41050e-07 1.800 9.43000e-07 1.800 9.43050e-07 0.000 9.44000e-07 0.000
+ 9.44050e-07 1.800 9.48000e-07 1.800 9.48050e-07 0.000 9.52000e-07 0.000 9.52050e-07 1.800 9.53000e-07 1.800
+ 9.53050e-07 0.000 9.55000e-07 0.000 9.55050e-07 1.800 9.56000e-07 1.800 9.56050e-07 0.000 9.57000e-07 0.000
+ 9.57050e-07 1.800 9.58000e-07 1.800 9.58050e-07 0.000 9.61000e-07 0.000 9.61050e-07 1.800 9.62000e-07 1.800
+ 9.62050e-07 0.000 9.70000e-07 0.000 9.70050e-07 1.800 9.71000e-07 1.800 9.71050e-07 0.000 9.73000e-07 0.000
+ 9.73050e-07 1.800 9.75000e-07 1.800 9.75050e-07 0.000 9.77000e-07 0.000 9.77050e-07 1.800 9.78000e-07 1.800
+ 9.78050e-07 0.000 9.79000e-07 0.000 9.79050e-07 1.800 9.82000e-07 1.800 9.82050e-07 0.000 9.83000e-07 0.000
+ 9.83050e-07 1.800 9.89000e-07 1.800 9.89050e-07 0.000 9.90000e-07 0.000 9.90050e-07 1.800 9.91000e-07 1.800
+ 9.91050e-07 0.000 9.94000e-07 0.000 9.94050e-07 1.800 1.00000e-06 1.800 1.00005e-06 0.000 1.00200e-06 0.000
+ 1.00205e-06 1.800 1.00600e-06 1.800 1.00605e-06 0.000 1.00800e-06 0.000 1.00805e-06 1.800 1.00900e-06 1.800
+ 1.00905e-06 0.000 1.01000e-06 0.000 1.01005e-06 1.800 1.01200e-06 1.800 1.01205e-06 0.000 1.01300e-06 0.000
+ 1.01305e-06 1.800 1.01500e-06 1.800 1.01505e-06 0.000 1.01700e-06 0.000 1.01705e-06 1.800 1.02000e-06 1.800
+ 1.02005e-06 0.000 1.02200e-06 0.000 1.02205e-06 1.800 1.02400e-06 1.800
+ )
Xd_g2b src_g2b g2b vdd gnd tb_inv
Vt2b src_t2b gnd PWL(
+ 0.00000e+00 1.800 8.00000e-09 1.800 8.05000e-09 0.000 1.60000e-08 0.000 1.60500e-08 1.800 2.40000e-08 1.800
+ 2.40500e-08 0.000 3.20000e-08 0.000 3.20500e-08 1.800 4.00000e-08 1.800 4.00500e-08 0.000 4.80000e-08 0.000
+ 4.80500e-08 1.800 5.60000e-08 1.800 5.60500e-08 0.000 6.40000e-08 0.000 6.40500e-08 1.800 7.20000e-08 1.800
+ 7.20500e-08 0.000 8.00000e-08 0.000 8.00500e-08 1.800 8.80000e-08 1.800 8.80500e-08 0.000 9.60000e-08 0.000
+ 9.60500e-08 1.800 1.04000e-07 1.800 1.04050e-07 0.000 1.12000e-07 0.000 1.12050e-07 1.800 1.20000e-07 1.800
+ 1.20050e-07 0.000 1.28000e-07 0.000 1.28050e-07 1.800 1.36000e-07 1.800 1.36050e-07 0.000 1.44000e-07 0.000
+ 1.44050e-07 1.800 1.52000e-07 1.800 1.52050e-07 0.000 1.60000e-07 0.000 1.60050e-07 1.800 1.68000e-07 1.800
+ 1.68050e-07 0.000 1.76000e-07 0.000 1.76050e-07 1.800 1.84000e-07 1.800 1.84050e-07 0.000 1.92000e-07 0.000
+ 1.92050e-07 1.800 2.00000e-07 1.800 2.00050e-07 0.000 2.08000e-07 0.000 2.08050e-07 1.800 2.16000e-07 1.800
+ 2.16050e-07 0.000 2.24000e-07 0.000 2.24050e-07 1.800 2.32000e-07 1.800 2.32050e-07 0.000 2.40000e-07 0.000
+ 2.40050e-07 1.800 2.48000e-07 1.800 2.48050e-07 0.000 2.56000e-07 0.000 2.56050e-07 1.800 2.64000e-07 1.800
+ 2.64050e-07 0.000 2.72000e-07 0.000 2.72050e-07 1.800 2.80000e-07 1.800 2.80050e-07 0.000 2.88000e-07 0.000
+ 2.88050e-07 1.800 2.96000e-07 1.800 2.96050e-07 0.000 3.04000e-07 0.000 3.04050e-07 1.800 3.12000e-07 1.800
+ 3.12050e-07 0.000 3.20000e-07 0.000 3.20050e-07 1.800 3.28000e-07 1.800 3.28050e-07 0.000 3.36000e-07 0.000
+ 3.36050e-07 1.800 3.44000e-07 1.800 3.44050e-07 0.000 3.52000e-07 0.000 3.52050e-07 1.800 3.60000e-07 1.800
+ 3.60050e-07 0.000 3.68000e-07 0.000 3.68050e-07 1.800 3.76000e-07 1.800 3.76050e-07 0.000 3.84000e-07 0.000
+ 3.84050e-07 1.800 3.92000e-07 1.800 3.92050e-07 0.000 4.00000e-07 0.000 4.00050e-07 1.800 4.08000e-07 1.800
+ 4.08050e-07 0.000 4.16000e-07 0.000 4.16050e-07 1.800 4.24000e-07 1.800 4.24050e-07 0.000 4.32000e-07 0.000
+ 4.32050e-07 1.800 4.40000e-07 1.800 4.40050e-07 0.000 4.48000e-07 0.000 4.48050e-07 1.800 4.56000e-07 1.800
+ 4.56050e-07 0.000 4.64000e-07 0.000 4.64050e-07 1.800 4.72000e-07 1.800 4.72050e-07 0.000 4.80000e-07 0.000
+ 4.80050e-07 1.800 4.88000e-07 1.800 4.88050e-07 0.000 4.96000e-07 0.000 4.96050e-07 1.800 5.04000e-07 1.800
+ 5.04050e-07 0.000 5.12000e-07 0.000 5.12050e-07 1.800 5.13000e-07 1.800 5.13050e-07 0.000 5.14000e-07 0.000
+ 5.14050e-07 1.800 5.16000e-07 1.800 5.16050e-07 0.000 5.17000e-07 0.000 5.17050e-07 1.800 5.21000e-07 1.800
+ 5.21050e-07 0.000 5.22000e-07 0.000 5.22050e-07 1.800 5.24000e-07 1.800 5.24050e-07 0.000 5.27000e-07 0.000
+ 5.27050e-07 1.800 5.28000e-07 1.800 5.28050e-07 0.000 5.29000e-07 0.000 5.29050e-07 1.800 5.36000e-07 1.800
+ 5.36050e-07 0.000 5.37000e-07 0.000 5.37050e-07 1.800 5.38000e-07 1.800 5.38050e-07 0.000 5.39000e-07 0.000
+ 5.39050e-07 1.800 5.41000e-07 1.800 5.41050e-07 0.000 5.43000e-07 0.000 5.43050e-07 1.800 5.48000e-07 1.800
+ 5.48050e-07 0.000 5.50000e-07 0.000 5.50050e-07 1.800 5.52000e-07 1.800 5.52050e-07 0.000 5.53000e-07 0.000
+ 5.53050e-07 1.800 5.54000e-07 1.800 5.54050e-07 0.000 5.55000e-07 0.000 5.55050e-07 1.800 5.60000e-07 1.800
+ 5.60050e-07 0.000 5.61000e-07 0.000 5.61050e-07 1.800 5.64000e-07 1.800 5.64050e-07 0.000 5.66000e-07 0.000
+ 5.66050e-07 1.800 5.69000e-07 1.800 5.69050e-07 0.000 5.74000e-07 0.000 5.74050e-07 1.800 5.75000e-07 1.800
+ 5.75050e-07 0.000 5.76000e-07 0.000 5.76050e-07 1.800 5.77000e-07 1.800 5.77050e-07 0.000 5.78000e-07 0.000
+ 5.78050e-07 1.800 5.80000e-07 1.800 5.80050e-07 0.000 5.82000e-07 0.000 5.82050e-07 1.800 5.84000e-07 1.800
+ 5.84050e-07 0.000 5.85000e-07 0.000 5.85050e-07 1.800 5.87000e-07 1.800 5.87050e-07 0.000 5.89000e-07 0.000
+ 5.89050e-07 1.800 5.91000e-07 1.800 5.91050e-07 0.000 5.92000e-07 0.000 5.92050e-07 1.800 5.93000e-07 1.800
+ 5.93050e-07 0.000 5.95000e-07 0.000 5.95050e-07 1.800 5.96000e-07 1.800 5.96050e-07 0.000 5.99000e-07 0.000
+ 5.99050e-07 1.800 6.00000e-07 1.800 6.00050e-07 0.000 6.02000e-07 0.000 6.02050e-07 1.800 6.04000e-07 1.800
+ 6.04050e-07 0.000 6.05000e-07 0.000 6.05050e-07 1.800 6.06000e-07 1.800 6.06050e-07 0.000 6.07000e-07 0.000
+ 6.07050e-07 1.800 6.08000e-07 1.800 6.08050e-07 0.000 6.11000e-07 0.000 6.11050e-07 1.800 6.14000e-07 1.800
+ 6.14050e-07 0.000 6.15000e-07 0.000 6.15050e-07 1.800 6.16000e-07 1.800 6.16050e-07 0.000 6.18000e-07 0.000
+ 6.18050e-07 1.800 6.19000e-07 1.800 6.19050e-07 0.000 6.21000e-07 0.000 6.21050e-07 1.800 6.22000e-07 1.800
+ 6.22050e-07 0.000 6.23000e-07 0.000 6.23050e-07 1.800 6.27000e-07 1.800 6.27050e-07 0.000 6.29000e-07 0.000
+ 6.29050e-07 1.800 6.30000e-07 1.800 6.30050e-07 0.000 6.31000e-07 0.000 6.31050e-07 1.800 6.32000e-07 1.800
+ 6.32050e-07 0.000 6.33000e-07 0.000 6.33050e-07 1.800 6.34000e-07 1.800 6.34050e-07 0.000 6.35000e-07 0.000
+ 6.35050e-07 1.800 6.38000e-07 1.800 6.38050e-07 0.000 6.40000e-07 0.000 6.40050e-07 1.800 6.42000e-07 1.800
+ 6.42050e-07 0.000 6.45000e-07 0.000 6.45050e-07 1.800 6.47000e-07 1.800 6.47050e-07 0.000 6.48000e-07 0.000
+ 6.48050e-07 1.800 6.50000e-07 1.800 6.50050e-07 0.000 6.52000e-07 0.000 6.52050e-07 1.800 6.54000e-07 1.800
+ 6.54050e-07 0.000 6.55000e-07 0.000 6.55050e-07 1.800 6.56000e-07 1.800 6.56050e-07 0.000 6.59000e-07 0.000
+ 6.59050e-07 1.800 6.60000e-07 1.800 6.60050e-07 0.000 6.63000e-07 0.000 6.63050e-07 1.800 6.65000e-07 1.800
+ 6.65050e-07 0.000 6.66000e-07 0.000 6.66050e-07 1.800 6.67000e-07 1.800 6.67050e-07 0.000 6.70000e-07 0.000
+ 6.70050e-07 1.800 6.72000e-07 1.800 6.72050e-07 0.000 6.74000e-07 0.000 6.74050e-07 1.800 6.75000e-07 1.800
+ 6.75050e-07 0.000 6.83000e-07 0.000 6.83050e-07 1.800 6.84000e-07 1.800 6.84050e-07 0.000 6.87000e-07 0.000
+ 6.87050e-07 1.800 6.90000e-07 1.800 6.90050e-07 0.000 6.91000e-07 0.000 6.91050e-07 1.800 6.92000e-07 1.800
+ 6.92050e-07 0.000 6.98000e-07 0.000 6.98050e-07 1.800 6.99000e-07 1.800 6.99050e-07 0.000 7.01000e-07 0.000
+ 7.01050e-07 1.800 7.02000e-07 1.800 7.02050e-07 0.000 7.03000e-07 0.000 7.03050e-07 1.800 7.08000e-07 1.800
+ 7.08050e-07 0.000 7.11000e-07 0.000 7.11050e-07 1.800 7.14000e-07 1.800 7.14050e-07 0.000 7.15000e-07 0.000
+ 7.15050e-07 1.800 7.17000e-07 1.800 7.17050e-07 0.000 7.18000e-07 0.000 7.18050e-07 1.800 7.22000e-07 1.800
+ 7.22050e-07 0.000 7.26000e-07 0.000 7.26050e-07 1.800 7.29000e-07 1.800 7.29050e-07 0.000 7.30000e-07 0.000
+ 7.30050e-07 1.800 7.31000e-07 1.800 7.31050e-07 0.000 7.32000e-07 0.000 7.32050e-07 1.800 7.34000e-07 1.800
+ 7.34050e-07 0.000 7.36000e-07 0.000 7.36050e-07 1.800 7.39000e-07 1.800 7.39050e-07 0.000 7.40000e-07 0.000
+ 7.40050e-07 1.800 7.41000e-07 1.800 7.41050e-07 0.000 7.45000e-07 0.000 7.45050e-07 1.800 7.46000e-07 1.800
+ 7.46050e-07 0.000 7.47000e-07 0.000 7.47050e-07 1.800 7.48000e-07 1.800 7.48050e-07 0.000 7.49000e-07 0.000
+ 7.49050e-07 1.800 7.50000e-07 1.800 7.50050e-07 0.000 7.51000e-07 0.000 7.51050e-07 1.800 7.52000e-07 1.800
+ 7.52050e-07 0.000 7.55000e-07 0.000 7.55050e-07 1.800 7.56000e-07 1.800 7.56050e-07 0.000 7.57000e-07 0.000
+ 7.57050e-07 1.800 7.61000e-07 1.800 7.61050e-07 0.000 7.63000e-07 0.000 7.63050e-07 1.800 7.64000e-07 1.800
+ 7.64050e-07 0.000 7.66000e-07 0.000 7.66050e-07 1.800 7.68000e-07 1.800 7.68050e-07 0.000 7.69000e-07 0.000
+ 7.69050e-07 1.800 7.70000e-07 1.800 7.70050e-07 0.000 7.72000e-07 0.000 7.72050e-07 1.800 7.74000e-07 1.800
+ 7.74050e-07 0.000 7.77000e-07 0.000 7.77050e-07 1.800 7.78000e-07 1.800 7.78050e-07 0.000 7.80000e-07 0.000
+ 7.80050e-07 1.800 7.81000e-07 1.800 7.81050e-07 0.000 7.85000e-07 0.000 7.85050e-07 1.800 7.87000e-07 1.800
+ 7.87050e-07 0.000 7.88000e-07 0.000 7.88050e-07 1.800 7.90000e-07 1.800 7.90050e-07 0.000 7.91000e-07 0.000
+ 7.91050e-07 1.800 7.94000e-07 1.800 7.94050e-07 0.000 7.97000e-07 0.000 7.97050e-07 1.800 7.98000e-07 1.800
+ 7.98050e-07 0.000 8.00000e-07 0.000 8.00050e-07 1.800 8.03000e-07 1.800 8.03050e-07 0.000 8.04000e-07 0.000
+ 8.04050e-07 1.800 8.07000e-07 1.800 8.07050e-07 0.000 8.08000e-07 0.000 8.08050e-07 1.800 8.09000e-07 1.800
+ 8.09050e-07 0.000 8.12000e-07 0.000 8.12050e-07 1.800 8.13000e-07 1.800 8.13050e-07 0.000 8.14000e-07 0.000
+ 8.14050e-07 1.800 8.15000e-07 1.800 8.15050e-07 0.000 8.16000e-07 0.000 8.16050e-07 1.800 8.17000e-07 1.800
+ 8.17050e-07 0.000 8.18000e-07 0.000 8.18050e-07 1.800 8.19000e-07 1.800 8.19050e-07 0.000 8.20000e-07 0.000
+ 8.20050e-07 1.800 8.26000e-07 1.800 8.26050e-07 0.000 8.31000e-07 0.000 8.31050e-07 1.800 8.33000e-07 1.800
+ 8.33050e-07 0.000 8.35000e-07 0.000 8.35050e-07 1.800 8.37000e-07 1.800 8.37050e-07 0.000 8.44000e-07 0.000
+ 8.44050e-07 1.800 8.45000e-07 1.800 8.45050e-07 0.000 8.47000e-07 0.000 8.47050e-07 1.800 8.48000e-07 1.800
+ 8.48050e-07 0.000 8.52000e-07 0.000 8.52050e-07 1.800 8.56000e-07 1.800 8.56050e-07 0.000 8.57000e-07 0.000
+ 8.57050e-07 1.800 8.58000e-07 1.800 8.58050e-07 0.000 8.59000e-07 0.000 8.59050e-07 1.800 8.61000e-07 1.800
+ 8.61050e-07 0.000 8.65000e-07 0.000 8.65050e-07 1.800 8.66000e-07 1.800 8.66050e-07 0.000 8.71000e-07 0.000
+ 8.71050e-07 1.800 8.75000e-07 1.800 8.75050e-07 0.000 8.76000e-07 0.000 8.76050e-07 1.800 8.78000e-07 1.800
+ 8.78050e-07 0.000 8.79000e-07 0.000 8.79050e-07 1.800 8.84000e-07 1.800 8.84050e-07 0.000 8.85000e-07 0.000
+ 8.85050e-07 1.800 8.86000e-07 1.800 8.86050e-07 0.000 8.87000e-07 0.000 8.87050e-07 1.800 8.94000e-07 1.800
+ 8.94050e-07 0.000 9.01000e-07 0.000 9.01050e-07 1.800 9.03000e-07 1.800 9.03050e-07 0.000 9.04000e-07 0.000
+ 9.04050e-07 1.800 9.05000e-07 1.800 9.05050e-07 0.000 9.07000e-07 0.000 9.07050e-07 1.800 9.08000e-07 1.800
+ 9.08050e-07 0.000 9.09000e-07 0.000 9.09050e-07 1.800 9.10000e-07 1.800 9.10050e-07 0.000 9.11000e-07 0.000
+ 9.11050e-07 1.800 9.14000e-07 1.800 9.14050e-07 0.000 9.20000e-07 0.000 9.20050e-07 1.800 9.21000e-07 1.800
+ 9.21050e-07 0.000 9.24000e-07 0.000 9.24050e-07 1.800 9.26000e-07 1.800 9.26050e-07 0.000 9.28000e-07 0.000
+ 9.28050e-07 1.800 9.29000e-07 1.800 9.29050e-07 0.000 9.30000e-07 0.000 9.30050e-07 1.800 9.32000e-07 1.800
+ 9.32050e-07 0.000 9.34000e-07 0.000 9.34050e-07 1.800 9.35000e-07 1.800 9.35050e-07 0.000 9.37000e-07 0.000
+ 9.37050e-07 1.800 9.38000e-07 1.800 9.38050e-07 0.000 9.39000e-07 0.000 9.39050e-07 1.800 9.41000e-07 1.800
+ 9.41050e-07 0.000 9.42000e-07 0.000 9.42050e-07 1.800 9.45000e-07 1.800 9.45050e-07 0.000 9.46000e-07 0.000
+ 9.46050e-07 1.800 9.47000e-07 1.800 9.47050e-07 0.000 9.50000e-07 0.000 9.50050e-07 1.800 9.53000e-07 1.800
+ 9.53050e-07 0.000 9.54000e-07 0.000 9.54050e-07 1.800 9.55000e-07 1.800 9.55050e-07 0.000 9.58000e-07 0.000
+ 9.58050e-07 1.800 9.59000e-07 1.800 9.59050e-07 0.000 9.60000e-07 0.000 9.60050e-07 1.800 9.61000e-07 1.800
+ 9.61050e-07 0.000 9.62000e-07 0.000 9.62050e-07 1.800 9.64000e-07 1.800 9.64050e-07 0.000 9.65000e-07 0.000
+ 9.65050e-07 1.800 9.68000e-07 1.800 9.68050e-07 0.000 9.69000e-07 0.000 9.69050e-07 1.800 9.71000e-07 1.800
+ 9.71050e-07 0.000 9.72000e-07 0.000 9.72050e-07 1.800 9.73000e-07 1.800 9.73050e-07 0.000 9.75000e-07 0.000
+ 9.75050e-07 1.800 9.76000e-07 1.800 9.76050e-07 0.000 9.79000e-07 0.000 9.79050e-07 1.800 9.83000e-07 1.800
+ 9.83050e-07 0.000 9.87000e-07 0.000 9.87050e-07 1.800 9.88000e-07 1.800 9.88050e-07 0.000 9.89000e-07 0.000
+ 9.89050e-07 1.800 9.90000e-07 1.800 9.90050e-07 0.000 9.91000e-07 0.000 9.91050e-07 1.800 9.92000e-07 1.800
+ 9.92050e-07 0.000 9.93000e-07 0.000 9.93050e-07 1.800 9.94000e-07 1.800 9.94050e-07 0.000 9.95000e-07 0.000
+ 9.95050e-07 1.800 9.98000e-07 1.800 9.98050e-07 0.000 9.99000e-07 0.000 9.99050e-07 1.800 1.00100e-06 1.800
+ 1.00105e-06 0.000 1.00200e-06 0.000 1.00205e-06 1.800 1.00300e-06 1.800 1.00305e-06 0.000 1.00700e-06 0.000
+ 1.00705e-06 1.800 1.00800e-06 1.800 1.00805e-06 0.000 1.00900e-06 0.000 1.00905e-06 1.800 1.01100e-06 1.800
+ 1.01105e-06 0.000 1.01200e-06 0.000 1.01205e-06 1.800 1.01500e-06 1.800 1.01505e-06 0.000 1.01700e-06 0.000
+ 1.01705e-06 1.800 1.02000e-06 1.800 1.02005e-06 0.000 1.02100e-06 0.000 1.02105e-06 1.800 1.02300e-06 1.800
+ 1.02305e-06 0.000 1.02400e-06 0.000
+ )
Xd_t2b src_t2b t2b vdd gnd tb_inv
Vg3b src_g3b gnd PWL(
+ 0.00000e+00 1.800 4.00000e-09 1.800 4.05000e-09 0.000 8.00000e-09 0.000 8.05000e-09 1.800 1.20000e-08 1.800
+ 1.20500e-08 0.000 1.60000e-08 0.000 1.60500e-08 1.800 2.00000e-08 1.800 2.00500e-08 0.000 2.40000e-08 0.000
+ 2.40500e-08 1.800 2.80000e-08 1.800 2.80500e-08 0.000 3.20000e-08 0.000 3.20500e-08 1.800 3.60000e-08 1.800
+ 3.60500e-08 0.000 4.00000e-08 0.000 4.00500e-08 1.800 4.40000e-08 1.800 4.40500e-08 0.000 4.80000e-08 0.000
+ 4.80500e-08 1.800 5.20000e-08 1.800 5.20500e-08 0.000 5.60000e-08 0.000 5.60500e-08 1.800 6.00000e-08 1.800
+ 6.00500e-08 0.000 6.40000e-08 0.000 6.40500e-08 1.800 6.80000e-08 1.800 6.80500e-08 0.000 7.20000e-08 0.000
+ 7.20500e-08 1.800 7.60000e-08 1.800 7.60500e-08 0.000 8.00000e-08 0.000 8.00500e-08 1.800 8.40000e-08 1.800
+ 8.40500e-08 0.000 8.80000e-08 0.000 8.80500e-08 1.800 9.20000e-08 1.800 9.20500e-08 0.000 9.60000e-08 0.000
+ 9.60500e-08 1.800 1.00000e-07 1.800 1.00050e-07 0.000 1.04000e-07 0.000 1.04050e-07 1.800 1.08000e-07 1.800
+ 1.08050e-07 0.000 1.12000e-07 0.000 1.12050e-07 1.800 1.16000e-07 1.800 1.16050e-07 0.000 1.20000e-07 0.000
+ 1.20050e-07 1.800 1.24000e-07 1.800 1.24050e-07 0.000 1.28000e-07 0.000 1.28050e-07 1.800 1.32000e-07 1.800
+ 1.32050e-07 0.000 1.36000e-07 0.000 1.36050e-07 1.800 1.40000e-07 1.800 1.40050e-07 0.000 1.44000e-07 0.000
+ 1.44050e-07 1.800 1.48000e-07 1.800 1.48050e-07 0.000 1.52000e-07 0.000 1.52050e-07 1.800 1.56000e-07 1.800
+ 1.56050e-07 0.000 1.60000e-07 0.000 1.60050e-07 1.800 1.64000e-07 1.800 1.64050e-07 0.000 1.68000e-07 0.000
+ 1.68050e-07 1.800 1.72000e-07 1.800 1.72050e-07 0.000 1.76000e-07 0.000 1.76050e-07 1.800 1.80000e-07 1.800
+ 1.80050e-07 0.000 1.84000e-07 0.000 1.84050e-07 1.800 1.88000e-07 1.800 1.88050e-07 0.000 1.92000e-07 0.000
+ 1.92050e-07 1.800 1.96000e-07 1.800 1.96050e-07 0.000 2.00000e-07 0.000 2.00050e-07 1.800 2.04000e-07 1.800
+ 2.04050e-07 0.000 2.08000e-07 0.000 2.08050e-07 1.800 2.12000e-07 1.800 2.12050e-07 0.000 2.16000e-07 0.000
+ 2.16050e-07 1.800 2.20000e-07 1.800 2.20050e-07 0.000 2.24000e-07 0.000 2.24050e-07 1.800 2.28000e-07 1.800
+ 2.28050e-07 0.000 2.32000e-07 0.000 2.32050e-07 1.800 2.36000e-07 1.800 2.36050e-07 0.000 2.40000e-07 0.000
+ 2.40050e-07 1.800 2.44000e-07 1.800 2.44050e-07 0.000 2.48000e-07 0.000 2.48050e-07 1.800 2.52000e-07 1.800
+ 2.52050e-07 0.000 2.56000e-07 0.000 2.56050e-07 1.800 2.60000e-07 1.800 2.60050e-07 0.000 2.64000e-07 0.000
+ 2.64050e-07 1.800 2.68000e-07 1.800 2.68050e-07 0.000 2.72000e-07 0.000 2.72050e-07 1.800 2.76000e-07 1.800
+ 2.76050e-07 0.000 2.80000e-07 0.000 2.80050e-07 1.800 2.84000e-07 1.800 2.84050e-07 0.000 2.88000e-07 0.000
+ 2.88050e-07 1.800 2.92000e-07 1.800 2.92050e-07 0.000 2.96000e-07 0.000 2.96050e-07 1.800 3.00000e-07 1.800
+ 3.00050e-07 0.000 3.04000e-07 0.000 3.04050e-07 1.800 3.08000e-07 1.800 3.08050e-07 0.000 3.12000e-07 0.000
+ 3.12050e-07 1.800 3.16000e-07 1.800 3.16050e-07 0.000 3.20000e-07 0.000 3.20050e-07 1.800 3.24000e-07 1.800
+ 3.24050e-07 0.000 3.28000e-07 0.000 3.28050e-07 1.800 3.32000e-07 1.800 3.32050e-07 0.000 3.36000e-07 0.000
+ 3.36050e-07 1.800 3.40000e-07 1.800 3.40050e-07 0.000 3.44000e-07 0.000 3.44050e-07 1.800 3.48000e-07 1.800
+ 3.48050e-07 0.000 3.52000e-07 0.000 3.52050e-07 1.800 3.56000e-07 1.800 3.56050e-07 0.000 3.60000e-07 0.000
+ 3.60050e-07 1.800 3.64000e-07 1.800 3.64050e-07 0.000 3.68000e-07 0.000 3.68050e-07 1.800 3.72000e-07 1.800
+ 3.72050e-07 0.000 3.76000e-07 0.000 3.76050e-07 1.800 3.80000e-07 1.800 3.80050e-07 0.000 3.84000e-07 0.000
+ 3.84050e-07 1.800 3.88000e-07 1.800 3.88050e-07 0.000 3.92000e-07 0.000 3.92050e-07 1.800 3.96000e-07 1.800
+ 3.96050e-07 0.000 4.00000e-07 0.000 4.00050e-07 1.800 4.04000e-07 1.800 4.04050e-07 0.000 4.08000e-07 0.000
+ 4.08050e-07 1.800 4.12000e-07 1.800 4.12050e-07 0.000 4.16000e-07 0.000 4.16050e-07 1.800 4.20000e-07 1.800
+ 4.20050e-07 0.000 4.24000e-07 0.000 4.24050e-07 1.800 4.28000e-07 1.800 4.28050e-07 0.000 4.32000e-07 0.000
+ 4.32050e-07 1.800 4.36000e-07 1.800 4.36050e-07 0.000 4.40000e-07 0.000 4.40050e-07 1.800 4.44000e-07 1.800
+ 4.44050e-07 0.000 4.48000e-07 0.000 4.48050e-07 1.800 4.52000e-07 1.800 4.52050e-07 0.000 4.56000e-07 0.000
+ 4.56050e-07 1.800 4.60000e-07 1.800 4.60050e-07 0.000 4.64000e-07 0.000 4.64050e-07 1.800 4.68000e-07 1.800
+ 4.68050e-07 0.000 4.72000e-07 0.000 4.72050e-07 1.800 4.76000e-07 1.800 4.76050e-07 0.000 4.80000e-07 0.000
+ 4.80050e-07 1.800 4.84000e-07 1.800 4.84050e-07 0.000 4.88000e-07 0.000 4.88050e-07 1.800 4.92000e-07 1.800
+ 4.92050e-07 0.000 4.96000e-07 0.000 4.96050e-07 1.800 5.00000e-07 1.800 5.00050e-07 0.000 5.04000e-07 0.000
+ 5.04050e-07 1.800 5.08000e-07 1.800 5.08050e-07 0.000 5.12000e-07 0.000 5.12050e-07 1.800 5.14000e-07 1.800
+ 5.14050e-07 0.000 5.15000e-07 0.000 5.15050e-07 1.800 5.16000e-07 1.800 5.16050e-07 0.000 5.20000e-07 0.000
+ 5.20050e-07 1.800 5.22000e-07 1.800 5.22050e-07 0.000 5.24000e-07 0.000 5.24050e-07 1.800 5.25000e-07 1.800
+ 5.25050e-07 0.000 5.27000e-07 0.000 5.27050e-07 1.800 5.28000e-07 1.800 5.28050e-07 0.000 5.31000e-07 0.000
+ 5.31050e-07 1.800 5.33000e-07 1.800 5.33050e-07 0.000 5.34000e-07 0.000 5.34050e-07 1.800 5.37000e-07 1.800
+ 5.37050e-07 0.000 5.39000e-07 0.000 5.39050e-07 1.800 5.45000e-07 1.800 5.45050e-07 0.000 5.47000e-07 0.000
+ 5.47050e-07 1.800 5.48000e-07 1.800 5.48050e-07 0.000 5.49000e-07 0.000 5.49050e-07 1.800 5.51000e-07 1.800
+ 5.51050e-07 0.000 5.52000e-07 0.000 5.52050e-07 1.800 5.54000e-07 1.800 5.54050e-07 0.000 5.55000e-07 0.000
+ 5.55050e-07 1.800 5.56000e-07 1.800 5.56050e-07 0.000 5.60000e-07 0.000 5.60050e-07 1.800 5.61000e-07 1.800
+ 5.61050e-07 0.000 5.63000e-07 0.000 5.63050e-07 1.800 5.64000e-07 1.800 5.64050e-07 0.000 5.66000e-07 0.000
+ 5.66050e-07 1.800 5.67000e-07 1.800 5.67050e-07 0.000 5.69000e-07 0.000 5.69050e-07 1.800 5.70000e-07 1.800
+ 5.70050e-07 0.000 5.71000e-07 0.000 5.71050e-07 1.800 5.72000e-07 1.800 5.72050e-07 0.000 5.74000e-07 0.000
+ 5.74050e-07 1.800 5.76000e-07 1.800 5.76050e-07 0.000 5.77000e-07 0.000 5.77050e-07 1.800 5.83000e-07 1.800
+ 5.83050e-07 0.000 5.85000e-07 0.000 5.85050e-07 1.800 5.87000e-07 1.800 5.87050e-07 0.000 5.88000e-07 0.000
+ 5.88050e-07 1.800 5.89000e-07 1.800 5.89050e-07 0.000 5.95000e-07 0.000 5.95050e-07 1.800 5.96000e-07 1.800
+ 5.96050e-07 0.000 5.98000e-07 0.000 5.98050e-07 1.800 6.00000e-07 1.800 6.00050e-07 0.000 6.02000e-07 0.000
+ 6.02050e-07 1.800 6.03000e-07 1.800 6.03050e-07 0.000 6.04000e-07 0.000 6.04050e-07 1.800 6.08000e-07 1.800
+ 6.08050e-07 0.000 6.09000e-07 0.000 6.09050e-07 1.800 6.10000e-07 1.800 6.10050e-07 0.000 6.14000e-07 0.000
+ 6.14050e-07 1.800 6.16000e-07 1.800 6.16050e-07 0.000 6.17000e-07 0.000 6.17050e-07 1.800 6.19000e-07 1.800
+ 6.19050e-07 0.000 6.20000e-07 0.000 6.20050e-07 1.800 6.21000e-07 1.800 6.21050e-07 0.000 6.24000e-07 0.000
+ 6.24050e-07 1.800 6.25000e-07 1.800 6.25050e-07 0.000 6.28000e-07 0.000 6.28050e-07 1.800 6.31000e-07 1.800
+ 6.31050e-07 0.000 6.32000e-07 0.000 6.32050e-07 1.800 6.35000e-07 1.800 6.35050e-07 0.000 6.36000e-07 0.000
+ 6.36050e-07 1.800 6.37000e-07 1.800 6.37050e-07 0.000 6.39000e-07 0.000 6.39050e-07 1.800 6.41000e-07 1.800
+ 6.41050e-07 0.000 6.43000e-07 0.000 6.43050e-07 1.800 6.44000e-07 1.800 6.44050e-07 0.000 6.48000e-07 0.000
+ 6.48050e-07 1.800 6.49000e-07 1.800 6.49050e-07 0.000 6.51000e-07 0.000 6.51050e-07 1.800 6.52000e-07 1.800
+ 6.52050e-07 0.000 6.53000e-07 0.000 6.53050e-07 1.800 6.55000e-07 1.800 6.55050e-07 0.000 6.56000e-07 0.000
+ 6.56050e-07 1.800 6.57000e-07 1.800 6.57050e-07 0.000 6.61000e-07 0.000 6.61050e-07 1.800 6.63000e-07 1.800
+ 6.63050e-07 0.000 6.64000e-07 0.000 6.64050e-07 1.800 6.67000e-07 1.800 6.67050e-07 0.000 6.69000e-07 0.000
+ 6.69050e-07 1.800 6.70000e-07 1.800 6.70050e-07 0.000 6.71000e-07 0.000 6.71050e-07 1.800 6.75000e-07 1.800
+ 6.75050e-07 0.000 6.78000e-07 0.000 6.78050e-07 1.800 6.79000e-07 1.800 6.79050e-07 0.000 6.81000e-07 0.000
+ 6.81050e-07 1.800 6.82000e-07 1.800 6.82050e-07 0.000 6.87000e-07 0.000 6.87050e-07 1.800 6.91000e-07 1.800
+ 6.91050e-07 0.000 6.95000e-07 0.000 6.95050e-07 1.800 6.96000e-07 1.800 6.96050e-07 0.000 7.00000e-07 0.000
+ 7.00050e-07 1.800 7.01000e-07 1.800 7.01050e-07 0.000 7.02000e-07 0.000 7.02050e-07 1.800 7.08000e-07 1.800
+ 7.08050e-07 0.000 7.09000e-07 0.000 7.09050e-07 1.800 7.10000e-07 1.800 7.10050e-07 0.000 7.11000e-07 0.000
+ 7.11050e-07 1.800 7.12000e-07 1.800 7.12050e-07 0.000 7.15000e-07 0.000 7.15050e-07 1.800 7.19000e-07 1.800
+ 7.19050e-07 0.000 7.21000e-07 0.000 7.21050e-07 1.800 7.23000e-07 1.800 7.23050e-07 0.000 7.24000e-07 0.000
+ 7.24050e-07 1.800 7.25000e-07 1.800 7.25050e-07 0.000 7.26000e-07 0.000 7.26050e-07 1.800 7.27000e-07 1.800
+ 7.27050e-07 0.000 7.31000e-07 0.000 7.31050e-07 1.800 7.35000e-07 1.800 7.35050e-07 0.000 7.36000e-07 0.000
+ 7.36050e-07 1.800 7.37000e-07 1.800 7.37050e-07 0.000 7.38000e-07 0.000 7.38050e-07 1.800 7.39000e-07 1.800
+ 7.39050e-07 0.000 7.40000e-07 0.000 7.40050e-07 1.800 7.41000e-07 1.800 7.41050e-07 0.000 7.42000e-07 0.000
+ 7.42050e-07 1.800 7.45000e-07 1.800 7.45050e-07 0.000 7.48000e-07 0.000 7.48050e-07 1.800 7.51000e-07 1.800
+ 7.51050e-07 0.000 7.53000e-07 0.000 7.53050e-07 1.800 7.60000e-07 1.800 7.60050e-07 0.000 7.62000e-07 0.000
+ 7.62050e-07 1.800 7.64000e-07 1.800 7.64050e-07 0.000 7.65000e-07 0.000 7.65050e-07 1.800 7.68000e-07 1.800
+ 7.68050e-07 0.000 7.73000e-07 0.000 7.73050e-07 1.800 7.74000e-07 1.800 7.74050e-07 0.000 7.75000e-07 0.000
+ 7.75050e-07 1.800 7.76000e-07 1.800 7.76050e-07 0.000 7.77000e-07 0.000 7.77050e-07 1.800 7.79000e-07 1.800
+ 7.79050e-07 0.000 7.82000e-07 0.000 7.82050e-07 1.800 7.84000e-07 1.800 7.84050e-07 0.000 7.85000e-07 0.000
+ 7.85050e-07 1.800 7.86000e-07 1.800 7.86050e-07 0.000 7.87000e-07 0.000 7.87050e-07 1.800 7.88000e-07 1.800
+ 7.88050e-07 0.000 7.89000e-07 0.000 7.89050e-07 1.800 7.90000e-07 1.800 7.90050e-07 0.000 7.91000e-07 0.000
+ 7.91050e-07 1.800 8.01000e-07 1.800 8.01050e-07 0.000 8.02000e-07 0.000 8.02050e-07 1.800 8.03000e-07 1.800
+ 8.03050e-07 0.000 8.05000e-07 0.000 8.05050e-07 1.800 8.06000e-07 1.800 8.06050e-07 0.000 8.11000e-07 0.000
+ 8.11050e-07 1.800 8.13000e-07 1.800 8.13050e-07 0.000 8.15000e-07 0.000 8.15050e-07 1.800 8.16000e-07 1.800
+ 8.16050e-07 0.000 8.17000e-07 0.000 8.17050e-07 1.800 8.19000e-07 1.800 8.19050e-07 0.000 8.21000e-07 0.000
+ 8.21050e-07 1.800 8.22000e-07 1.800 8.22050e-07 0.000 8.23000e-07 0.000 8.23050e-07 1.800 8.25000e-07 1.800
+ 8.25050e-07 0.000 8.27000e-07 0.000 8.27050e-07 1.800 8.28000e-07 1.800 8.28050e-07 0.000 8.33000e-07 0.000
+ 8.33050e-07 1.800 8.35000e-07 1.800 8.35050e-07 0.000 8.36000e-07 0.000 8.36050e-07 1.800 8.39000e-07 1.800
+ 8.39050e-07 0.000 8.41000e-07 0.000 8.41050e-07 1.800 8.44000e-07 1.800 8.44050e-07 0.000 8.47000e-07 0.000
+ 8.47050e-07 1.800 8.51000e-07 1.800 8.51050e-07 0.000 8.53000e-07 0.000 8.53050e-07 1.800 8.56000e-07 1.800
+ 8.56050e-07 0.000 8.58000e-07 0.000 8.58050e-07 1.800 8.60000e-07 1.800 8.60050e-07 0.000 8.61000e-07 0.000
+ 8.61050e-07 1.800 8.63000e-07 1.800 8.63050e-07 0.000 8.64000e-07 0.000 8.64050e-07 1.800 8.65000e-07 1.800
+ 8.65050e-07 0.000 8.67000e-07 0.000 8.67050e-07 1.800 8.69000e-07 1.800 8.69050e-07 0.000 8.70000e-07 0.000
+ 8.70050e-07 1.800 8.72000e-07 1.800 8.72050e-07 0.000 8.74000e-07 0.000 8.74050e-07 1.800 8.76000e-07 1.800
+ 8.76050e-07 0.000 8.77000e-07 0.000 8.77050e-07 1.800 8.78000e-07 1.800 8.78050e-07 0.000 8.79000e-07 0.000
+ 8.79050e-07 1.800 8.80000e-07 1.800 8.80050e-07 0.000 8.86000e-07 0.000 8.86050e-07 1.800 8.87000e-07 1.800
+ 8.87050e-07 0.000 8.91000e-07 0.000 8.91050e-07 1.800 8.92000e-07 1.800 8.92050e-07 0.000 8.94000e-07 0.000
+ 8.94050e-07 1.800 8.97000e-07 1.800 8.97050e-07 0.000 8.98000e-07 0.000 8.98050e-07 1.800 9.00000e-07 1.800
+ 9.00050e-07 0.000 9.02000e-07 0.000 9.02050e-07 1.800 9.04000e-07 1.800 9.04050e-07 0.000 9.05000e-07 0.000
+ 9.05050e-07 1.800 9.06000e-07 1.800 9.06050e-07 0.000 9.08000e-07 0.000 9.08050e-07 1.800 9.10000e-07 1.800
+ 9.10050e-07 0.000 9.13000e-07 0.000 9.13050e-07 1.800 9.15000e-07 1.800 9.15050e-07 0.000 9.17000e-07 0.000
+ 9.17050e-07 1.800 9.19000e-07 1.800 9.19050e-07 0.000 9.21000e-07 0.000 9.21050e-07 1.800 9.24000e-07 1.800
+ 9.24050e-07 0.000 9.27000e-07 0.000 9.27050e-07 1.800 9.28000e-07 1.800 9.28050e-07 0.000 9.31000e-07 0.000
+ 9.31050e-07 1.800 9.32000e-07 1.800 9.32050e-07 0.000 9.33000e-07 0.000 9.33050e-07 1.800 9.35000e-07 1.800
+ 9.35050e-07 0.000 9.37000e-07 0.000 9.37050e-07 1.800 9.40000e-07 1.800 9.40050e-07 0.000 9.41000e-07 0.000
+ 9.41050e-07 1.800 9.45000e-07 1.800 9.45050e-07 0.000 9.46000e-07 0.000 9.46050e-07 1.800 9.48000e-07 1.800
+ 9.48050e-07 0.000 9.51000e-07 0.000 9.51050e-07 1.800 9.53000e-07 1.800 9.53050e-07 0.000 9.54000e-07 0.000
+ 9.54050e-07 1.800 9.56000e-07 1.800 9.56050e-07 0.000 9.59000e-07 0.000 9.59050e-07 1.800 9.60000e-07 1.800
+ 9.60050e-07 0.000 9.61000e-07 0.000 9.61050e-07 1.800 9.62000e-07 1.800 9.62050e-07 0.000 9.63000e-07 0.000
+ 9.63050e-07 1.800 9.65000e-07 1.800 9.65050e-07 0.000 9.66000e-07 0.000 9.66050e-07 1.800 9.67000e-07 1.800
+ 9.67050e-07 0.000 9.68000e-07 0.000 9.68050e-07 1.800 9.69000e-07 1.800 9.69050e-07 0.000 9.70000e-07 0.000
+ 9.70050e-07 1.800 9.73000e-07 1.800 9.73050e-07 0.000 9.75000e-07 0.000 9.75050e-07 1.800 9.77000e-07 1.800
+ 9.77050e-07 0.000 9.79000e-07 0.000 9.79050e-07 1.800 9.81000e-07 1.800 9.81050e-07 0.000 9.85000e-07 0.000
+ 9.85050e-07 1.800 9.86000e-07 1.800 9.86050e-07 0.000 9.87000e-07 0.000 9.87050e-07 1.800 9.88000e-07 1.800
+ 9.88050e-07 0.000 9.93000e-07 0.000 9.93050e-07 1.800 9.95000e-07 1.800 9.95050e-07 0.000 9.97000e-07 0.000
+ 9.97050e-07 1.800 9.99000e-07 1.800 9.99050e-07 0.000 1.00300e-06 0.000 1.00305e-06 1.800 1.00500e-06 1.800
+ 1.00505e-06 0.000 1.00600e-06 0.000 1.00605e-06 1.800 1.01100e-06 1.800 1.01105e-06 0.000 1.01200e-06 0.000
+ 1.01205e-06 1.800 1.01300e-06 1.800 1.01305e-06 0.000 1.01700e-06 0.000 1.01705e-06 1.800 1.01900e-06 1.800
+ 1.01905e-06 0.000 1.02000e-06 0.000 1.02005e-06 1.800 1.02400e-06 1.800
+ )
Xd_g3b src_g3b g3b vdd gnd tb_inv
Vt3b src_t3b gnd PWL(
+ 0.00000e+00 1.800 2.00000e-09 1.800 2.05000e-09 0.000 4.00000e-09 0.000 4.05000e-09 1.800 6.00000e-09 1.800
+ 6.05000e-09 0.000 8.00000e-09 0.000 8.05000e-09 1.800 1.00000e-08 1.800 1.00500e-08 0.000 1.20000e-08 0.000
+ 1.20500e-08 1.800 1.40000e-08 1.800 1.40500e-08 0.000 1.60000e-08 0.000 1.60500e-08 1.800 1.80000e-08 1.800
+ 1.80500e-08 0.000 2.00000e-08 0.000 2.00500e-08 1.800 2.20000e-08 1.800 2.20500e-08 0.000 2.40000e-08 0.000
+ 2.40500e-08 1.800 2.60000e-08 1.800 2.60500e-08 0.000 2.80000e-08 0.000 2.80500e-08 1.800 3.00000e-08 1.800
+ 3.00500e-08 0.000 3.20000e-08 0.000 3.20500e-08 1.800 3.40000e-08 1.800 3.40500e-08 0.000 3.60000e-08 0.000
+ 3.60500e-08 1.800 3.80000e-08 1.800 3.80500e-08 0.000 4.00000e-08 0.000 4.00500e-08 1.800 4.20000e-08 1.800
+ 4.20500e-08 0.000 4.40000e-08 0.000 4.40500e-08 1.800 4.60000e-08 1.800 4.60500e-08 0.000 4.80000e-08 0.000
+ 4.80500e-08 1.800 5.00000e-08 1.800 5.00500e-08 0.000 5.20000e-08 0.000 5.20500e-08 1.800 5.40000e-08 1.800
+ 5.40500e-08 0.000 5.60000e-08 0.000 5.60500e-08 1.800 5.80000e-08 1.800 5.80500e-08 0.000 6.00000e-08 0.000
+ 6.00500e-08 1.800 6.20000e-08 1.800 6.20500e-08 0.000 6.40000e-08 0.000 6.40500e-08 1.800 6.60000e-08 1.800
+ 6.60500e-08 0.000 6.80000e-08 0.000 6.80500e-08 1.800 7.00000e-08 1.800 7.00500e-08 0.000 7.20000e-08 0.000
+ 7.20500e-08 1.800 7.40000e-08 1.800 7.40500e-08 0.000 7.60000e-08 0.000 7.60500e-08 1.800 7.80000e-08 1.800
+ 7.80500e-08 0.000 8.00000e-08 0.000 8.00500e-08 1.800 8.20000e-08 1.800 8.20500e-08 0.000 8.40000e-08 0.000
+ 8.40500e-08 1.800 8.60000e-08 1.800 8.60500e-08 0.000 8.80000e-08 0.000 8.80500e-08 1.800 9.00000e-08 1.800
+ 9.00500e-08 0.000 9.20000e-08 0.000 9.20500e-08 1.800 9.40000e-08 1.800 9.40500e-08 0.000 9.60000e-08 0.000
+ 9.60500e-08 1.800 9.80000e-08 1.800 9.80500e-08 0.000 1.00000e-07 0.000 1.00050e-07 1.800 1.02000e-07 1.800
+ 1.02050e-07 0.000 1.04000e-07 0.000 1.04050e-07 1.800 1.06000e-07 1.800 1.06050e-07 0.000 1.08000e-07 0.000
+ 1.08050e-07 1.800 1.10000e-07 1.800 1.10050e-07 0.000 1.12000e-07 0.000 1.12050e-07 1.800 1.14000e-07 1.800
+ 1.14050e-07 0.000 1.16000e-07 0.000 1.16050e-07 1.800 1.18000e-07 1.800 1.18050e-07 0.000 1.20000e-07 0.000
+ 1.20050e-07 1.800 1.22000e-07 1.800 1.22050e-07 0.000 1.24000e-07 0.000 1.24050e-07 1.800 1.26000e-07 1.800
+ 1.26050e-07 0.000 1.28000e-07 0.000 1.28050e-07 1.800 1.30000e-07 1.800 1.30050e-07 0.000 1.32000e-07 0.000
+ 1.32050e-07 1.800 1.34000e-07 1.800 1.34050e-07 0.000 1.36000e-07 0.000 1.36050e-07 1.800 1.38000e-07 1.800
+ 1.38050e-07 0.000 1.40000e-07 0.000 1.40050e-07 1.800 1.42000e-07 1.800 1.42050e-07 0.000 1.44000e-07 0.000
+ 1.44050e-07 1.800 1.46000e-07 1.800 1.46050e-07 0.000 1.48000e-07 0.000 1.48050e-07 1.800 1.50000e-07 1.800
+ 1.50050e-07 0.000 1.52000e-07 0.000 1.52050e-07 1.800 1.54000e-07 1.800 1.54050e-07 0.000 1.56000e-07 0.000
+ 1.56050e-07 1.800 1.58000e-07 1.800 1.58050e-07 0.000 1.60000e-07 0.000 1.60050e-07 1.800 1.62000e-07 1.800
+ 1.62050e-07 0.000 1.64000e-07 0.000 1.64050e-07 1.800 1.66000e-07 1.800 1.66050e-07 0.000 1.68000e-07 0.000
+ 1.68050e-07 1.800 1.70000e-07 1.800 1.70050e-07 0.000 1.72000e-07 0.000 1.72050e-07 1.800 1.74000e-07 1.800
+ 1.74050e-07 0.000 1.76000e-07 0.000 1.76050e-07 1.800 1.78000e-07 1.800 1.78050e-07 0.000 1.80000e-07 0.000
+ 1.80050e-07 1.800 1.82000e-07 1.800 1.82050e-07 0.000 1.84000e-07 0.000 1.84050e-07 1.800 1.86000e-07 1.800
+ 1.86050e-07 0.000 1.88000e-07 0.000 1.88050e-07 1.800 1.90000e-07 1.800 1.90050e-07 0.000 1.92000e-07 0.000
+ 1.92050e-07 1.800 1.94000e-07 1.800 1.94050e-07 0.000 1.96000e-07 0.000 1.96050e-07 1.800 1.98000e-07 1.800
+ 1.98050e-07 0.000 2.00000e-07 0.000 2.00050e-07 1.800 2.02000e-07 1.800 2.02050e-07 0.000 2.04000e-07 0.000
+ 2.04050e-07 1.800 2.06000e-07 1.800 2.06050e-07 0.000 2.08000e-07 0.000 2.08050e-07 1.800 2.10000e-07 1.800
+ 2.10050e-07 0.000 2.12000e-07 0.000 2.12050e-07 1.800 2.14000e-07 1.800 2.14050e-07 0.000 2.16000e-07 0.000
+ 2.16050e-07 1.800 2.18000e-07 1.800 2.18050e-07 0.000 2.20000e-07 0.000 2.20050e-07 1.800 2.22000e-07 1.800
+ 2.22050e-07 0.000 2.24000e-07 0.000 2.24050e-07 1.800 2.26000e-07 1.800 2.26050e-07 0.000 2.28000e-07 0.000
+ 2.28050e-07 1.800 2.30000e-07 1.800 2.30050e-07 0.000 2.32000e-07 0.000 2.32050e-07 1.800 2.34000e-07 1.800
+ 2.34050e-07 0.000 2.36000e-07 0.000 2.36050e-07 1.800 2.38000e-07 1.800 2.38050e-07 0.000 2.40000e-07 0.000
+ 2.40050e-07 1.800 2.42000e-07 1.800 2.42050e-07 0.000 2.44000e-07 0.000 2.44050e-07 1.800 2.46000e-07 1.800
+ 2.46050e-07 0.000 2.48000e-07 0.000 2.48050e-07 1.800 2.50000e-07 1.800 2.50050e-07 0.000 2.52000e-07 0.000
+ 2.52050e-07 1.800 2.54000e-07 1.800 2.54050e-07 0.000 2.56000e-07 0.000 2.56050e-07 1.800 2.58000e-07 1.800
+ 2.58050e-07 0.000 2.60000e-07 0.000 2.60050e-07 1.800 2.62000e-07 1.800 2.62050e-07 0.000 2.64000e-07 0.000
+ 2.64050e-07 1.800 2.66000e-07 1.800 2.66050e-07 0.000 2.68000e-07 0.000 2.68050e-07 1.800 2.70000e-07 1.800
+ 2.70050e-07 0.000 2.72000e-07 0.000 2.72050e-07 1.800 2.74000e-07 1.800 2.74050e-07 0.000 2.76000e-07 0.000
+ 2.76050e-07 1.800 2.78000e-07 1.800 2.78050e-07 0.000 2.80000e-07 0.000 2.80050e-07 1.800 2.82000e-07 1.800
+ 2.82050e-07 0.000 2.84000e-07 0.000 2.84050e-07 1.800 2.86000e-07 1.800 2.86050e-07 0.000 2.88000e-07 0.000
+ 2.88050e-07 1.800 2.90000e-07 1.800 2.90050e-07 0.000 2.92000e-07 0.000 2.92050e-07 1.800 2.94000e-07 1.800
+ 2.94050e-07 0.000 2.96000e-07 0.000 2.96050e-07 1.800 2.98000e-07 1.800 2.98050e-07 0.000 3.00000e-07 0.000
+ 3.00050e-07 1.800 3.02000e-07 1.800 3.02050e-07 0.000 3.04000e-07 0.000 3.04050e-07 1.800 3.06000e-07 1.800
+ 3.06050e-07 0.000 3.08000e-07 0.000 3.08050e-07 1.800 3.10000e-07 1.800 3.10050e-07 0.000 3.12000e-07 0.000
+ 3.12050e-07 1.800 3.14000e-07 1.800 3.14050e-07 0.000 3.16000e-07 0.000 3.16050e-07 1.800 3.18000e-07 1.800
+ 3.18050e-07 0.000 3.20000e-07 0.000 3.20050e-07 1.800 3.22000e-07 1.800 3.22050e-07 0.000 3.24000e-07 0.000
+ 3.24050e-07 1.800 3.26000e-07 1.800 3.26050e-07 0.000 3.28000e-07 0.000 3.28050e-07 1.800 3.30000e-07 1.800
+ 3.30050e-07 0.000 3.32000e-07 0.000 3.32050e-07 1.800 3.34000e-07 1.800 3.34050e-07 0.000 3.36000e-07 0.000
+ 3.36050e-07 1.800 3.38000e-07 1.800 3.38050e-07 0.000 3.40000e-07 0.000 3.40050e-07 1.800 3.42000e-07 1.800
+ 3.42050e-07 0.000 3.44000e-07 0.000 3.44050e-07 1.800 3.46000e-07 1.800 3.46050e-07 0.000 3.48000e-07 0.000
+ 3.48050e-07 1.800 3.50000e-07 1.800 3.50050e-07 0.000 3.52000e-07 0.000 3.52050e-07 1.800 3.54000e-07 1.800
+ 3.54050e-07 0.000 3.56000e-07 0.000 3.56050e-07 1.800 3.58000e-07 1.800 3.58050e-07 0.000 3.60000e-07 0.000
+ 3.60050e-07 1.800 3.62000e-07 1.800 3.62050e-07 0.000 3.64000e-07 0.000 3.64050e-07 1.800 3.66000e-07 1.800
+ 3.66050e-07 0.000 3.68000e-07 0.000 3.68050e-07 1.800 3.70000e-07 1.800 3.70050e-07 0.000 3.72000e-07 0.000
+ 3.72050e-07 1.800 3.74000e-07 1.800 3.74050e-07 0.000 3.76000e-07 0.000 3.76050e-07 1.800 3.78000e-07 1.800
+ 3.78050e-07 0.000 3.80000e-07 0.000 3.80050e-07 1.800 3.82000e-07 1.800 3.82050e-07 0.000 3.84000e-07 0.000
+ 3.84050e-07 1.800 3.86000e-07 1.800 3.86050e-07 0.000 3.88000e-07 0.000 3.88050e-07 1.800 3.90000e-07 1.800
+ 3.90050e-07 0.000 3.92000e-07 0.000 3.92050e-07 1.800 3.94000e-07 1.800 3.94050e-07 0.000 3.96000e-07 0.000
+ 3.96050e-07 1.800 3.98000e-07 1.800 3.98050e-07 0.000 4.00000e-07 0.000 4.00050e-07 1.800 4.02000e-07 1.800
+ 4.02050e-07 0.000 4.04000e-07 0.000 4.04050e-07 1.800 4.06000e-07 1.800 4.06050e-07 0.000 4.08000e-07 0.000
+ 4.08050e-07 1.800 4.10000e-07 1.800 4.10050e-07 0.000 4.12000e-07 0.000 4.12050e-07 1.800 4.14000e-07 1.800
+ 4.14050e-07 0.000 4.16000e-07 0.000 4.16050e-07 1.800 4.18000e-07 1.800 4.18050e-07 0.000 4.20000e-07 0.000
+ 4.20050e-07 1.800 4.22000e-07 1.800 4.22050e-07 0.000 4.24000e-07 0.000 4.24050e-07 1.800 4.26000e-07 1.800
+ 4.26050e-07 0.000 4.28000e-07 0.000 4.28050e-07 1.800 4.30000e-07 1.800 4.30050e-07 0.000 4.32000e-07 0.000
+ 4.32050e-07 1.800 4.34000e-07 1.800 4.34050e-07 0.000 4.36000e-07 0.000 4.36050e-07 1.800 4.38000e-07 1.800
+ 4.38050e-07 0.000 4.40000e-07 0.000 4.40050e-07 1.800 4.42000e-07 1.800 4.42050e-07 0.000 4.44000e-07 0.000
+ 4.44050e-07 1.800 4.46000e-07 1.800 4.46050e-07 0.000 4.48000e-07 0.000 4.48050e-07 1.800 4.50000e-07 1.800
+ 4.50050e-07 0.000 4.52000e-07 0.000 4.52050e-07 1.800 4.54000e-07 1.800 4.54050e-07 0.000 4.56000e-07 0.000
+ 4.56050e-07 1.800 4.58000e-07 1.800 4.58050e-07 0.000 4.60000e-07 0.000 4.60050e-07 1.800 4.62000e-07 1.800
+ 4.62050e-07 0.000 4.64000e-07 0.000 4.64050e-07 1.800 4.66000e-07 1.800 4.66050e-07 0.000 4.68000e-07 0.000
+ 4.68050e-07 1.800 4.70000e-07 1.800 4.70050e-07 0.000 4.72000e-07 0.000 4.72050e-07 1.800 4.74000e-07 1.800
+ 4.74050e-07 0.000 4.76000e-07 0.000 4.76050e-07 1.800 4.78000e-07 1.800 4.78050e-07 0.000 4.80000e-07 0.000
+ 4.80050e-07 1.800 4.82000e-07 1.800 4.82050e-07 0.000 4.84000e-07 0.000 4.84050e-07 1.800 4.86000e-07 1.800
+ 4.86050e-07 0.000 4.88000e-07 0.000 4.88050e-07 1.800 4.90000e-07 1.800 4.90050e-07 0.000 4.92000e-07 0.000
+ 4.92050e-07 1.800 4.94000e-07 1.800 4.94050e-07 0.000 4.96000e-07 0.000 4.96050e-07 1.800 4.98000e-07 1.800
+ 4.98050e-07 0.000 5.00000e-07 0.000 5.00050e-07 1.800 5.02000e-07 1.800 5.02050e-07 0.000 5.04000e-07 0.000
+ 5.04050e-07 1.800 5.06000e-07 1.800 5.06050e-07 0.000 5.08000e-07 0.000 5.08050e-07 1.800 5.10000e-07 1.800
+ 5.10050e-07 0.000 5.14000e-07 0.000 5.14050e-07 1.800 5.16000e-07 1.800 5.16050e-07 0.000 5.17000e-07 0.000
+ 5.17050e-07 1.800 5.18000e-07 1.800 5.18050e-07 0.000 5.19000e-07 0.000 5.19050e-07 1.800 5.20000e-07 1.800
+ 5.20050e-07 0.000 5.21000e-07 0.000 5.21050e-07 1.800 5.22000e-07 1.800 5.22050e-07 0.000 5.24000e-07 0.000
+ 5.24050e-07 1.800 5.25000e-07 1.800 5.25050e-07 0.000 5.27000e-07 0.000 5.27050e-07 1.800 5.30000e-07 1.800
+ 5.30050e-07 0.000 5.34000e-07 0.000 5.34050e-07 1.800 5.35000e-07 1.800 5.35050e-07 0.000 5.37000e-07 0.000
+ 5.37050e-07 1.800 5.38000e-07 1.800 5.38050e-07 0.000 5.40000e-07 0.000 5.40050e-07 1.800 5.41000e-07 1.800
+ 5.41050e-07 0.000 5.42000e-07 0.000 5.42050e-07 1.800 5.43000e-07 1.800 5.43050e-07 0.000 5.44000e-07 0.000
+ 5.44050e-07 1.800 5.45000e-07 1.800 5.45050e-07 0.000 5.47000e-07 0.000 5.47050e-07 1.800 5.49000e-07 1.800
+ 5.49050e-07 0.000 5.51000e-07 0.000 5.51050e-07 1.800 5.55000e-07 1.800 5.55050e-07 0.000 5.56000e-07 0.000
+ 5.56050e-07 1.800 5.58000e-07 1.800 5.58050e-07 0.000 5.59000e-07 0.000 5.59050e-07 1.800 5.60000e-07 1.800
+ 5.60050e-07 0.000 5.62000e-07 0.000 5.62050e-07 1.800 5.64000e-07 1.800 5.64050e-07 0.000 5.67000e-07 0.000
+ 5.67050e-07 1.800 5.69000e-07 1.800 5.69050e-07 0.000 5.71000e-07 0.000 5.71050e-07 1.800 5.75000e-07 1.800
+ 5.75050e-07 0.000 5.76000e-07 0.000 5.76050e-07 1.800 5.79000e-07 1.800 5.79050e-07 0.000 5.86000e-07 0.000
+ 5.86050e-07 1.800 5.88000e-07 1.800 5.88050e-07 0.000 5.90000e-07 0.000 5.90050e-07 1.800 5.94000e-07 1.800
+ 5.94050e-07 0.000 5.95000e-07 0.000 5.95050e-07 1.800 5.96000e-07 1.800 5.96050e-07 0.000 5.98000e-07 0.000
+ 5.98050e-07 1.800 5.99000e-07 1.800 5.99050e-07 0.000 6.00000e-07 0.000 6.00050e-07 1.800 6.01000e-07 1.800
+ 6.01050e-07 0.000 6.02000e-07 0.000 6.02050e-07 1.800 6.03000e-07 1.800 6.03050e-07 0.000 6.04000e-07 0.000
+ 6.04050e-07 1.800 6.05000e-07 1.800 6.05050e-07 0.000 6.06000e-07 0.000 6.06050e-07 1.800 6.09000e-07 1.800
+ 6.09050e-07 0.000 6.11000e-07 0.000 6.11050e-07 1.800 6.12000e-07 1.800 6.12050e-07 0.000 6.13000e-07 0.000
+ 6.13050e-07 1.800 6.14000e-07 1.800 6.14050e-07 0.000 6.15000e-07 0.000 6.15050e-07 1.800 6.17000e-07 1.800
+ 6.17050e-07 0.000 6.19000e-07 0.000 6.19050e-07 1.800 6.20000e-07 1.800 6.20050e-07 0.000 6.21000e-07 0.000
+ 6.21050e-07 1.800 6.23000e-07 1.800 6.23050e-07 0.000 6.24000e-07 0.000 6.24050e-07 1.800 6.26000e-07 1.800
+ 6.26050e-07 0.000 6.29000e-07 0.000 6.29050e-07 1.800 6.33000e-07 1.800 6.33050e-07 0.000 6.36000e-07 0.000
+ 6.36050e-07 1.800 6.38000e-07 1.800 6.38050e-07 0.000 6.39000e-07 0.000 6.39050e-07 1.800 6.42000e-07 1.800
+ 6.42050e-07 0.000 6.45000e-07 0.000 6.45050e-07 1.800 6.46000e-07 1.800 6.46050e-07 0.000 6.47000e-07 0.000
+ 6.47050e-07 1.800 6.48000e-07 1.800 6.48050e-07 0.000 6.55000e-07 0.000 6.55050e-07 1.800 6.56000e-07 1.800
+ 6.56050e-07 0.000 6.57000e-07 0.000 6.57050e-07 1.800 6.60000e-07 1.800 6.60050e-07 0.000 6.61000e-07 0.000
+ 6.61050e-07 1.800 6.63000e-07 1.800 6.63050e-07 0.000 6.65000e-07 0.000 6.65050e-07 1.800 6.67000e-07 1.800
+ 6.67050e-07 0.000 6.68000e-07 0.000 6.68050e-07 1.800 6.69000e-07 1.800 6.69050e-07 0.000 6.70000e-07 0.000
+ 6.70050e-07 1.800 6.72000e-07 1.800 6.72050e-07 0.000 6.73000e-07 0.000 6.73050e-07 1.800 6.76000e-07 1.800
+ 6.76050e-07 0.000 6.77000e-07 0.000 6.77050e-07 1.800 6.81000e-07 1.800 6.81050e-07 0.000 6.84000e-07 0.000
+ 6.84050e-07 1.800 6.86000e-07 1.800 6.86050e-07 0.000 6.88000e-07 0.000 6.88050e-07 1.800 6.91000e-07 1.800
+ 6.91050e-07 0.000 6.92000e-07 0.000 6.92050e-07 1.800 6.93000e-07 1.800 6.93050e-07 0.000 6.94000e-07 0.000
+ 6.94050e-07 1.800 6.99000e-07 1.800 6.99050e-07 0.000 7.00000e-07 0.000 7.00050e-07 1.800 7.05000e-07 1.800
+ 7.05050e-07 0.000 7.07000e-07 0.000 7.07050e-07 1.800 7.09000e-07 1.800 7.09050e-07 0.000 7.12000e-07 0.000
+ 7.12050e-07 1.800 7.13000e-07 1.800 7.13050e-07 0.000 7.14000e-07 0.000 7.14050e-07 1.800 7.15000e-07 1.800
+ 7.15050e-07 0.000 7.17000e-07 0.000 7.17050e-07 1.800 7.20000e-07 1.800 7.20050e-07 0.000 7.21000e-07 0.000
+ 7.21050e-07 1.800 7.23000e-07 1.800 7.23050e-07 0.000 7.24000e-07 0.000 7.24050e-07 1.800 7.26000e-07 1.800
+ 7.26050e-07 0.000 7.28000e-07 0.000 7.28050e-07 1.800 7.30000e-07 1.800 7.30050e-07 0.000 7.36000e-07 0.000
+ 7.36050e-07 1.800 7.40000e-07 1.800 7.40050e-07 0.000 7.41000e-07 0.000 7.41050e-07 1.800 7.43000e-07 1.800
+ 7.43050e-07 0.000 7.45000e-07 0.000 7.45050e-07 1.800 7.46000e-07 1.800 7.46050e-07 0.000 7.47000e-07 0.000
+ 7.47050e-07 1.800 7.50000e-07 1.800 7.50050e-07 0.000 7.56000e-07 0.000 7.56050e-07 1.800 7.57000e-07 1.800
+ 7.57050e-07 0.000 7.59000e-07 0.000 7.59050e-07 1.800 7.60000e-07 1.800 7.60050e-07 0.000 7.61000e-07 0.000
+ 7.61050e-07 1.800 7.63000e-07 1.800 7.63050e-07 0.000 7.66000e-07 0.000 7.66050e-07 1.800 7.67000e-07 1.800
+ 7.67050e-07 0.000 7.69000e-07 0.000 7.69050e-07 1.800 7.71000e-07 1.800 7.71050e-07 0.000 7.74000e-07 0.000
+ 7.74050e-07 1.800 7.79000e-07 1.800 7.79050e-07 0.000 7.84000e-07 0.000 7.84050e-07 1.800 7.85000e-07 1.800
+ 7.85050e-07 0.000 7.86000e-07 0.000 7.86050e-07 1.800 7.89000e-07 1.800 7.89050e-07 0.000 7.96000e-07 0.000
+ 7.96050e-07 1.800 7.97000e-07 1.800 7.97050e-07 0.000 7.99000e-07 0.000 7.99050e-07 1.800 8.03000e-07 1.800
+ 8.03050e-07 0.000 8.04000e-07 0.000 8.04050e-07 1.800 8.06000e-07 1.800 8.06050e-07 0.000 8.08000e-07 0.000
+ 8.08050e-07 1.800 8.09000e-07 1.800 8.09050e-07 0.000 8.10000e-07 0.000 8.10050e-07 1.800 8.11000e-07 1.800
+ 8.11050e-07 0.000 8.14000e-07 0.000 8.14050e-07 1.800 8.16000e-07 1.800 8.16050e-07 0.000 8.18000e-07 0.000
+ 8.18050e-07 1.800 8.20000e-07 1.800 8.20050e-07 0.000 8.21000e-07 0.000 8.21050e-07 1.800 8.23000e-07 1.800
+ 8.23050e-07 0.000 8.24000e-07 0.000 8.24050e-07 1.800 8.25000e-07 1.800 8.25050e-07 0.000 8.27000e-07 0.000
+ 8.27050e-07 1.800 8.28000e-07 1.800 8.28050e-07 0.000 8.33000e-07 0.000 8.33050e-07 1.800 8.34000e-07 1.800
+ 8.34050e-07 0.000 8.35000e-07 0.000 8.35050e-07 1.800 8.38000e-07 1.800 8.38050e-07 0.000 8.40000e-07 0.000
+ 8.40050e-07 1.800 8.41000e-07 1.800 8.41050e-07 0.000 8.42000e-07 0.000 8.42050e-07 1.800 8.43000e-07 1.800
+ 8.43050e-07 0.000 8.44000e-07 0.000 8.44050e-07 1.800 8.45000e-07 1.800 8.45050e-07 0.000 8.49000e-07 0.000
+ 8.49050e-07 1.800 8.51000e-07 1.800 8.51050e-07 0.000 8.54000e-07 0.000 8.54050e-07 1.800 8.57000e-07 1.800
+ 8.57050e-07 0.000 8.58000e-07 0.000 8.58050e-07 1.800 8.59000e-07 1.800 8.59050e-07 0.000 8.61000e-07 0.000
+ 8.61050e-07 1.800 8.63000e-07 1.800 8.63050e-07 0.000 8.66000e-07 0.000 8.66050e-07 1.800 8.67000e-07 1.800
+ 8.67050e-07 0.000 8.68000e-07 0.000 8.68050e-07 1.800 8.69000e-07 1.800 8.69050e-07 0.000 8.70000e-07 0.000
+ 8.70050e-07 1.800 8.71000e-07 1.800 8.71050e-07 0.000 8.73000e-07 0.000 8.73050e-07 1.800 8.74000e-07 1.800
+ 8.74050e-07 0.000 8.75000e-07 0.000 8.75050e-07 1.800 8.76000e-07 1.800 8.76050e-07 0.000 8.77000e-07 0.000
+ 8.77050e-07 1.800 8.78000e-07 1.800 8.78050e-07 0.000 8.79000e-07 0.000 8.79050e-07 1.800 8.81000e-07 1.800
+ 8.81050e-07 0.000 8.85000e-07 0.000 8.85050e-07 1.800 8.88000e-07 1.800 8.88050e-07 0.000 8.90000e-07 0.000
+ 8.90050e-07 1.800 8.92000e-07 1.800 8.92050e-07 0.000 8.96000e-07 0.000 8.96050e-07 1.800 8.97000e-07 1.800
+ 8.97050e-07 0.000 8.99000e-07 0.000 8.99050e-07 1.800 9.01000e-07 1.800 9.01050e-07 0.000 9.02000e-07 0.000
+ 9.02050e-07 1.800 9.03000e-07 1.800 9.03050e-07 0.000 9.06000e-07 0.000 9.06050e-07 1.800 9.08000e-07 1.800
+ 9.08050e-07 0.000 9.12000e-07 0.000 9.12050e-07 1.800 9.13000e-07 1.800 9.13050e-07 0.000 9.15000e-07 0.000
+ 9.15050e-07 1.800 9.16000e-07 1.800 9.16050e-07 0.000 9.17000e-07 0.000 9.17050e-07 1.800 9.20000e-07 1.800
+ 9.20050e-07 0.000 9.21000e-07 0.000 9.21050e-07 1.800 9.22000e-07 1.800 9.22050e-07 0.000 9.23000e-07 0.000
+ 9.23050e-07 1.800 9.26000e-07 1.800 9.26050e-07 0.000 9.27000e-07 0.000 9.27050e-07 1.800 9.34000e-07 1.800
+ 9.34050e-07 0.000 9.36000e-07 0.000 9.36050e-07 1.800 9.38000e-07 1.800 9.38050e-07 0.000 9.39000e-07 0.000
+ 9.39050e-07 1.800 9.40000e-07 1.800 9.40050e-07 0.000 9.41000e-07 0.000 9.41050e-07 1.800 9.42000e-07 1.800
+ 9.42050e-07 0.000 9.43000e-07 0.000 9.43050e-07 1.800 9.47000e-07 1.800 9.47050e-07 0.000 9.48000e-07 0.000
+ 9.48050e-07 1.800 9.50000e-07 1.800 9.50050e-07 0.000 9.55000e-07 0.000 9.55050e-07 1.800 9.61000e-07 1.800
+ 9.61050e-07 0.000 9.63000e-07 0.000 9.63050e-07 1.800 9.64000e-07 1.800 9.64050e-07 0.000 9.66000e-07 0.000
+ 9.66050e-07 1.800 9.67000e-07 1.800 9.67050e-07 0.000 9.70000e-07 0.000 9.70050e-07 1.800 9.71000e-07 1.800
+ 9.71050e-07 0.000 9.72000e-07 0.000 9.72050e-07 1.800 9.73000e-07 1.800 9.73050e-07 0.000 9.74000e-07 0.000
+ 9.74050e-07 1.800 9.75000e-07 1.800 9.75050e-07 0.000 9.76000e-07 0.000 9.76050e-07 1.800 9.77000e-07 1.800
+ 9.77050e-07 0.000 9.81000e-07 0.000 9.81050e-07 1.800 9.85000e-07 1.800 9.85050e-07 0.000 9.88000e-07 0.000
+ 9.88050e-07 1.800 9.90000e-07 1.800 9.90050e-07 0.000 9.91000e-07 0.000 9.91050e-07 1.800 9.99000e-07 1.800
+ 9.99050e-07 0.000 1.00100e-06 0.000 1.00105e-06 1.800 1.00200e-06 1.800 1.00205e-06 0.000 1.00400e-06 0.000
+ 1.00405e-06 1.800 1.00500e-06 1.800 1.00505e-06 0.000 1.00600e-06 0.000 1.00605e-06 1.800 1.00800e-06 1.800
+ 1.00805e-06 0.000 1.01100e-06 0.000 1.01105e-06 1.800 1.01300e-06 1.800 1.01305e-06 0.000 1.01400e-06 0.000
+ 1.01405e-06 1.800 1.01700e-06 1.800 1.01705e-06 0.000 1.01800e-06 0.000 1.01805e-06 1.800 1.01900e-06 1.800
+ 1.01905e-06 0.000 1.02100e-06 0.000 1.02105e-06 1.800 1.02200e-06 1.800 1.02205e-06 0.000 1.02300e-06 0.000
+ 1.02305e-06 1.800 1.02400e-06 1.800
+ )
Xd_t3b src_t3b t3b vdd gnd tb_inv
Vc0b src_c0b gnd PWL(
+ 0.00000e+00 1.800 1.00000e-09 1.800 1.05000e-09 0.000 2.00000e-09 0.000 2.05000e-09 1.800 3.00000e-09 1.800
+ 3.05000e-09 0.000 4.00000e-09 0.000 4.05000e-09 1.800 5.00000e-09 1.800 5.05000e-09 0.000 6.00000e-09 0.000
+ 6.05000e-09 1.800 7.00000e-09 1.800 7.05000e-09 0.000 8.00000e-09 0.000 8.05000e-09 1.800 9.00000e-09 1.800
+ 9.05000e-09 0.000 1.00000e-08 0.000 1.00500e-08 1.800 1.10000e-08 1.800 1.10500e-08 0.000 1.20000e-08 0.000
+ 1.20500e-08 1.800 1.30000e-08 1.800 1.30500e-08 0.000 1.40000e-08 0.000 1.40500e-08 1.800 1.50000e-08 1.800
+ 1.50500e-08 0.000 1.60000e-08 0.000 1.60500e-08 1.800 1.70000e-08 1.800 1.70500e-08 0.000 1.80000e-08 0.000
+ 1.80500e-08 1.800 1.90000e-08 1.800 1.90500e-08 0.000 2.00000e-08 0.000 2.00500e-08 1.800 2.10000e-08 1.800
+ 2.10500e-08 0.000 2.20000e-08 0.000 2.20500e-08 1.800 2.30000e-08 1.800 2.30500e-08 0.000 2.40000e-08 0.000
+ 2.40500e-08 1.800 2.50000e-08 1.800 2.50500e-08 0.000 2.60000e-08 0.000 2.60500e-08 1.800 2.70000e-08 1.800
+ 2.70500e-08 0.000 2.80000e-08 0.000 2.80500e-08 1.800 2.90000e-08 1.800 2.90500e-08 0.000 3.00000e-08 0.000
+ 3.00500e-08 1.800 3.10000e-08 1.800 3.10500e-08 0.000 3.20000e-08 0.000 3.20500e-08 1.800 3.30000e-08 1.800
+ 3.30500e-08 0.000 3.40000e-08 0.000 3.40500e-08 1.800 3.50000e-08 1.800 3.50500e-08 0.000 3.60000e-08 0.000
+ 3.60500e-08 1.800 3.70000e-08 1.800 3.70500e-08 0.000 3.80000e-08 0.000 3.80500e-08 1.800 3.90000e-08 1.800
+ 3.90500e-08 0.000 4.00000e-08 0.000 4.00500e-08 1.800 4.10000e-08 1.800 4.10500e-08 0.000 4.20000e-08 0.000
+ 4.20500e-08 1.800 4.30000e-08 1.800 4.30500e-08 0.000 4.40000e-08 0.000 4.40500e-08 1.800 4.50000e-08 1.800
+ 4.50500e-08 0.000 4.60000e-08 0.000 4.60500e-08 1.800 4.70000e-08 1.800 4.70500e-08 0.000 4.80000e-08 0.000
+ 4.80500e-08 1.800 4.90000e-08 1.800 4.90500e-08 0.000 5.00000e-08 0.000 5.00500e-08 1.800 5.10000e-08 1.800
+ 5.10500e-08 0.000 5.20000e-08 0.000 5.20500e-08 1.800 5.30000e-08 1.800 5.30500e-08 0.000 5.40000e-08 0.000
+ 5.40500e-08 1.800 5.50000e-08 1.800 5.50500e-08 0.000 5.60000e-08 0.000 5.60500e-08 1.800 5.70000e-08 1.800
+ 5.70500e-08 0.000 5.80000e-08 0.000 5.80500e-08 1.800 5.90000e-08 1.800 5.90500e-08 0.000 6.00000e-08 0.000
+ 6.00500e-08 1.800 6.10000e-08 1.800 6.10500e-08 0.000 6.20000e-08 0.000 6.20500e-08 1.800 6.30000e-08 1.800
+ 6.30500e-08 0.000 6.40000e-08 0.000 6.40500e-08 1.800 6.50000e-08 1.800 6.50500e-08 0.000 6.60000e-08 0.000
+ 6.60500e-08 1.800 6.70000e-08 1.800 6.70500e-08 0.000 6.80000e-08 0.000 6.80500e-08 1.800 6.90000e-08 1.800
+ 6.90500e-08 0.000 7.00000e-08 0.000 7.00500e-08 1.800 7.10000e-08 1.800 7.10500e-08 0.000 7.20000e-08 0.000
+ 7.20500e-08 1.800 7.30000e-08 1.800 7.30500e-08 0.000 7.40000e-08 0.000 7.40500e-08 1.800 7.50000e-08 1.800
+ 7.50500e-08 0.000 7.60000e-08 0.000 7.60500e-08 1.800 7.70000e-08 1.800 7.70500e-08 0.000 7.80000e-08 0.000
+ 7.80500e-08 1.800 7.90000e-08 1.800 7.90500e-08 0.000 8.00000e-08 0.000 8.00500e-08 1.800 8.10000e-08 1.800
+ 8.10500e-08 0.000 8.20000e-08 0.000 8.20500e-08 1.800 8.30000e-08 1.800 8.30500e-08 0.000 8.40000e-08 0.000
+ 8.40500e-08 1.800 8.50000e-08 1.800 8.50500e-08 0.000 8.60000e-08 0.000 8.60500e-08 1.800 8.70000e-08 1.800
+ 8.70500e-08 0.000 8.80000e-08 0.000 8.80500e-08 1.800 8.90000e-08 1.800 8.90500e-08 0.000 9.00000e-08 0.000
+ 9.00500e-08 1.800 9.10000e-08 1.800 9.10500e-08 0.000 9.20000e-08 0.000 9.20500e-08 1.800 9.30000e-08 1.800
+ 9.30500e-08 0.000 9.40000e-08 0.000 9.40500e-08 1.800 9.50000e-08 1.800 9.50500e-08 0.000 9.60000e-08 0.000
+ 9.60500e-08 1.800 9.70000e-08 1.800 9.70500e-08 0.000 9.80000e-08 0.000 9.80500e-08 1.800 9.90000e-08 1.800
+ 9.90500e-08 0.000 1.00000e-07 0.000 1.00050e-07 1.800 1.01000e-07 1.800 1.01050e-07 0.000 1.02000e-07 0.000
+ 1.02050e-07 1.800 1.03000e-07 1.800 1.03050e-07 0.000 1.04000e-07 0.000 1.04050e-07 1.800 1.05000e-07 1.800
+ 1.05050e-07 0.000 1.06000e-07 0.000 1.06050e-07 1.800 1.07000e-07 1.800 1.07050e-07 0.000 1.08000e-07 0.000
+ 1.08050e-07 1.800 1.09000e-07 1.800 1.09050e-07 0.000 1.10000e-07 0.000 1.10050e-07 1.800 1.11000e-07 1.800
+ 1.11050e-07 0.000 1.12000e-07 0.000 1.12050e-07 1.800 1.13000e-07 1.800 1.13050e-07 0.000 1.14000e-07 0.000
+ 1.14050e-07 1.800 1.15000e-07 1.800 1.15050e-07 0.000 1.16000e-07 0.000 1.16050e-07 1.800 1.17000e-07 1.800
+ 1.17050e-07 0.000 1.18000e-07 0.000 1.18050e-07 1.800 1.19000e-07 1.800 1.19050e-07 0.000 1.20000e-07 0.000
+ 1.20050e-07 1.800 1.21000e-07 1.800 1.21050e-07 0.000 1.22000e-07 0.000 1.22050e-07 1.800 1.23000e-07 1.800
+ 1.23050e-07 0.000 1.24000e-07 0.000 1.24050e-07 1.800 1.25000e-07 1.800 1.25050e-07 0.000 1.26000e-07 0.000
+ 1.26050e-07 1.800 1.27000e-07 1.800 1.27050e-07 0.000 1.28000e-07 0.000 1.28050e-07 1.800 1.29000e-07 1.800
+ 1.29050e-07 0.000 1.30000e-07 0.000 1.30050e-07 1.800 1.31000e-07 1.800 1.31050e-07 0.000 1.32000e-07 0.000
+ 1.32050e-07 1.800 1.33000e-07 1.800 1.33050e-07 0.000 1.34000e-07 0.000 1.34050e-07 1.800 1.35000e-07 1.800
+ 1.35050e-07 0.000 1.36000e-07 0.000 1.36050e-07 1.800 1.37000e-07 1.800 1.37050e-07 0.000 1.38000e-07 0.000
+ 1.38050e-07 1.800 1.39000e-07 1.800 1.39050e-07 0.000 1.40000e-07 0.000 1.40050e-07 1.800 1.41000e-07 1.800
+ 1.41050e-07 0.000 1.42000e-07 0.000 1.42050e-07 1.800 1.43000e-07 1.800 1.43050e-07 0.000 1.44000e-07 0.000
+ 1.44050e-07 1.800 1.45000e-07 1.800 1.45050e-07 0.000 1.46000e-07 0.000 1.46050e-07 1.800 1.47000e-07 1.800
+ 1.47050e-07 0.000 1.48000e-07 0.000 1.48050e-07 1.800 1.49000e-07 1.800 1.49050e-07 0.000 1.50000e-07 0.000
+ 1.50050e-07 1.800 1.51000e-07 1.800 1.51050e-07 0.000 1.52000e-07 0.000 1.52050e-07 1.800 1.53000e-07 1.800
+ 1.53050e-07 0.000 1.54000e-07 0.000 1.54050e-07 1.800 1.55000e-07 1.800 1.55050e-07 0.000 1.56000e-07 0.000
+ 1.56050e-07 1.800 1.57000e-07 1.800 1.57050e-07 0.000 1.58000e-07 0.000 1.58050e-07 1.800 1.59000e-07 1.800
+ 1.59050e-07 0.000 1.60000e-07 0.000 1.60050e-07 1.800 1.61000e-07 1.800 1.61050e-07 0.000 1.62000e-07 0.000
+ 1.62050e-07 1.800 1.63000e-07 1.800 1.63050e-07 0.000 1.64000e-07 0.000 1.64050e-07 1.800 1.65000e-07 1.800
+ 1.65050e-07 0.000 1.66000e-07 0.000 1.66050e-07 1.800 1.67000e-07 1.800 1.67050e-07 0.000 1.68000e-07 0.000
+ 1.68050e-07 1.800 1.69000e-07 1.800 1.69050e-07 0.000 1.70000e-07 0.000 1.70050e-07 1.800 1.71000e-07 1.800
+ 1.71050e-07 0.000 1.72000e-07 0.000 1.72050e-07 1.800 1.73000e-07 1.800 1.73050e-07 0.000 1.74000e-07 0.000
+ 1.74050e-07 1.800 1.75000e-07 1.800 1.75050e-07 0.000 1.76000e-07 0.000 1.76050e-07 1.800 1.77000e-07 1.800
+ 1.77050e-07 0.000 1.78000e-07 0.000 1.78050e-07 1.800 1.79000e-07 1.800 1.79050e-07 0.000 1.80000e-07 0.000
+ 1.80050e-07 1.800 1.81000e-07 1.800 1.81050e-07 0.000 1.82000e-07 0.000 1.82050e-07 1.800 1.83000e-07 1.800
+ 1.83050e-07 0.000 1.84000e-07 0.000 1.84050e-07 1.800 1.85000e-07 1.800 1.85050e-07 0.000 1.86000e-07 0.000
+ 1.86050e-07 1.800 1.87000e-07 1.800 1.87050e-07 0.000 1.88000e-07 0.000 1.88050e-07 1.800 1.89000e-07 1.800
+ 1.89050e-07 0.000 1.90000e-07 0.000 1.90050e-07 1.800 1.91000e-07 1.800 1.91050e-07 0.000 1.92000e-07 0.000
+ 1.92050e-07 1.800 1.93000e-07 1.800 1.93050e-07 0.000 1.94000e-07 0.000 1.94050e-07 1.800 1.95000e-07 1.800
+ 1.95050e-07 0.000 1.96000e-07 0.000 1.96050e-07 1.800 1.97000e-07 1.800 1.97050e-07 0.000 1.98000e-07 0.000
+ 1.98050e-07 1.800 1.99000e-07 1.800 1.99050e-07 0.000 2.00000e-07 0.000 2.00050e-07 1.800 2.01000e-07 1.800
+ 2.01050e-07 0.000 2.02000e-07 0.000 2.02050e-07 1.800 2.03000e-07 1.800 2.03050e-07 0.000 2.04000e-07 0.000
+ 2.04050e-07 1.800 2.05000e-07 1.800 2.05050e-07 0.000 2.06000e-07 0.000 2.06050e-07 1.800 2.07000e-07 1.800
+ 2.07050e-07 0.000 2.08000e-07 0.000 2.08050e-07 1.800 2.09000e-07 1.800 2.09050e-07 0.000 2.10000e-07 0.000
+ 2.10050e-07 1.800 2.11000e-07 1.800 2.11050e-07 0.000 2.12000e-07 0.000 2.12050e-07 1.800 2.13000e-07 1.800
+ 2.13050e-07 0.000 2.14000e-07 0.000 2.14050e-07 1.800 2.15000e-07 1.800 2.15050e-07 0.000 2.16000e-07 0.000
+ 2.16050e-07 1.800 2.17000e-07 1.800 2.17050e-07 0.000 2.18000e-07 0.000 2.18050e-07 1.800 2.19000e-07 1.800
+ 2.19050e-07 0.000 2.20000e-07 0.000 2.20050e-07 1.800 2.21000e-07 1.800 2.21050e-07 0.000 2.22000e-07 0.000
+ 2.22050e-07 1.800 2.23000e-07 1.800 2.23050e-07 0.000 2.24000e-07 0.000 2.24050e-07 1.800 2.25000e-07 1.800
+ 2.25050e-07 0.000 2.26000e-07 0.000 2.26050e-07 1.800 2.27000e-07 1.800 2.27050e-07 0.000 2.28000e-07 0.000
+ 2.28050e-07 1.800 2.29000e-07 1.800 2.29050e-07 0.000 2.30000e-07 0.000 2.30050e-07 1.800 2.31000e-07 1.800
+ 2.31050e-07 0.000 2.32000e-07 0.000 2.32050e-07 1.800 2.33000e-07 1.800 2.33050e-07 0.000 2.34000e-07 0.000
+ 2.34050e-07 1.800 2.35000e-07 1.800 2.35050e-07 0.000 2.36000e-07 0.000 2.36050e-07 1.800 2.37000e-07 1.800
+ 2.37050e-07 0.000 2.38000e-07 0.000 2.38050e-07 1.800 2.39000e-07 1.800 2.39050e-07 0.000 2.40000e-07 0.000
+ 2.40050e-07 1.800 2.41000e-07 1.800 2.41050e-07 0.000 2.42000e-07 0.000 2.42050e-07 1.800 2.43000e-07 1.800
+ 2.43050e-07 0.000 2.44000e-07 0.000 2.44050e-07 1.800 2.45000e-07 1.800 2.45050e-07 0.000 2.46000e-07 0.000
+ 2.46050e-07 1.800 2.47000e-07 1.800 2.47050e-07 0.000 2.48000e-07 0.000 2.48050e-07 1.800 2.49000e-07 1.800
+ 2.49050e-07 0.000 2.50000e-07 0.000 2.50050e-07 1.800 2.51000e-07 1.800 2.51050e-07 0.000 2.52000e-07 0.000
+ 2.52050e-07 1.800 2.53000e-07 1.800 2.53050e-07 0.000 2.54000e-07 0.000 2.54050e-07 1.800 2.55000e-07 1.800
+ 2.55050e-07 0.000 2.56000e-07 0.000 2.56050e-07 1.800 2.57000e-07 1.800 2.57050e-07 0.000 2.58000e-07 0.000
+ 2.58050e-07 1.800 2.59000e-07 1.800 2.59050e-07 0.000 2.60000e-07 0.000 2.60050e-07 1.800 2.61000e-07 1.800
+ 2.61050e-07 0.000 2.62000e-07 0.000 2.62050e-07 1.800 2.63000e-07 1.800 2.63050e-07 0.000 2.64000e-07 0.000
+ 2.64050e-07 1.800 2.65000e-07 1.800 2.65050e-07 0.000 2.66000e-07 0.000 2.66050e-07 1.800 2.67000e-07 1.800
+ 2.67050e-07 0.000 2.68000e-07 0.000 2.68050e-07 1.800 2.69000e-07 1.800 2.69050e-07 0.000 2.70000e-07 0.000
+ 2.70050e-07 1.800 2.71000e-07 1.800 2.71050e-07 0.000 2.72000e-07 0.000 2.72050e-07 1.800 2.73000e-07 1.800
+ 2.73050e-07 0.000 2.74000e-07 0.000 2.74050e-07 1.800 2.75000e-07 1.800 2.75050e-07 0.000 2.76000e-07 0.000
+ 2.76050e-07 1.800 2.77000e-07 1.800 2.77050e-07 0.000 2.78000e-07 0.000 2.78050e-07 1.800 2.79000e-07 1.800
+ 2.79050e-07 0.000 2.80000e-07 0.000 2.80050e-07 1.800 2.81000e-07 1.800 2.81050e-07 0.000 2.82000e-07 0.000
+ 2.82050e-07 1.800 2.83000e-07 1.800 2.83050e-07 0.000 2.84000e-07 0.000 2.84050e-07 1.800 2.85000e-07 1.800
+ 2.85050e-07 0.000 2.86000e-07 0.000 2.86050e-07 1.800 2.87000e-07 1.800 2.87050e-07 0.000 2.88000e-07 0.000
+ 2.88050e-07 1.800 2.89000e-07 1.800 2.89050e-07 0.000 2.90000e-07 0.000 2.90050e-07 1.800 2.91000e-07 1.800
+ 2.91050e-07 0.000 2.92000e-07 0.000 2.92050e-07 1.800 2.93000e-07 1.800 2.93050e-07 0.000 2.94000e-07 0.000
+ 2.94050e-07 1.800 2.95000e-07 1.800 2.95050e-07 0.000 2.96000e-07 0.000 2.96050e-07 1.800 2.97000e-07 1.800
+ 2.97050e-07 0.000 2.98000e-07 0.000 2.98050e-07 1.800 2.99000e-07 1.800 2.99050e-07 0.000 3.00000e-07 0.000
+ 3.00050e-07 1.800 3.01000e-07 1.800 3.01050e-07 0.000 3.02000e-07 0.000 3.02050e-07 1.800 3.03000e-07 1.800
+ 3.03050e-07 0.000 3.04000e-07 0.000 3.04050e-07 1.800 3.05000e-07 1.800 3.05050e-07 0.000 3.06000e-07 0.000
+ 3.06050e-07 1.800 3.07000e-07 1.800 3.07050e-07 0.000 3.08000e-07 0.000 3.08050e-07 1.800 3.09000e-07 1.800
+ 3.09050e-07 0.000 3.10000e-07 0.000 3.10050e-07 1.800 3.11000e-07 1.800 3.11050e-07 0.000 3.12000e-07 0.000
+ 3.12050e-07 1.800 3.13000e-07 1.800 3.13050e-07 0.000 3.14000e-07 0.000 3.14050e-07 1.800 3.15000e-07 1.800
+ 3.15050e-07 0.000 3.16000e-07 0.000 3.16050e-07 1.800 3.17000e-07 1.800 3.17050e-07 0.000 3.18000e-07 0.000
+ 3.18050e-07 1.800 3.19000e-07 1.800 3.19050e-07 0.000 3.20000e-07 0.000 3.20050e-07 1.800 3.21000e-07 1.800
+ 3.21050e-07 0.000 3.22000e-07 0.000 3.22050e-07 1.800 3.23000e-07 1.800 3.23050e-07 0.000 3.24000e-07 0.000
+ 3.24050e-07 1.800 3.25000e-07 1.800 3.25050e-07 0.000 3.26000e-07 0.000 3.26050e-07 1.800 3.27000e-07 1.800
+ 3.27050e-07 0.000 3.28000e-07 0.000 3.28050e-07 1.800 3.29000e-07 1.800 3.29050e-07 0.000 3.30000e-07 0.000
+ 3.30050e-07 1.800 3.31000e-07 1.800 3.31050e-07 0.000 3.32000e-07 0.000 3.32050e-07 1.800 3.33000e-07 1.800
+ 3.33050e-07 0.000 3.34000e-07 0.000 3.34050e-07 1.800 3.35000e-07 1.800 3.35050e-07 0.000 3.36000e-07 0.000
+ 3.36050e-07 1.800 3.37000e-07 1.800 3.37050e-07 0.000 3.38000e-07 0.000 3.38050e-07 1.800 3.39000e-07 1.800
+ 3.39050e-07 0.000 3.40000e-07 0.000 3.40050e-07 1.800 3.41000e-07 1.800 3.41050e-07 0.000 3.42000e-07 0.000
+ 3.42050e-07 1.800 3.43000e-07 1.800 3.43050e-07 0.000 3.44000e-07 0.000 3.44050e-07 1.800 3.45000e-07 1.800
+ 3.45050e-07 0.000 3.46000e-07 0.000 3.46050e-07 1.800 3.47000e-07 1.800 3.47050e-07 0.000 3.48000e-07 0.000
+ 3.48050e-07 1.800 3.49000e-07 1.800 3.49050e-07 0.000 3.50000e-07 0.000 3.50050e-07 1.800 3.51000e-07 1.800
+ 3.51050e-07 0.000 3.52000e-07 0.000 3.52050e-07 1.800 3.53000e-07 1.800 3.53050e-07 0.000 3.54000e-07 0.000
+ 3.54050e-07 1.800 3.55000e-07 1.800 3.55050e-07 0.000 3.56000e-07 0.000 3.56050e-07 1.800 3.57000e-07 1.800
+ 3.57050e-07 0.000 3.58000e-07 0.000 3.58050e-07 1.800 3.59000e-07 1.800 3.59050e-07 0.000 3.60000e-07 0.000
+ 3.60050e-07 1.800 3.61000e-07 1.800 3.61050e-07 0.000 3.62000e-07 0.000 3.62050e-07 1.800 3.63000e-07 1.800
+ 3.63050e-07 0.000 3.64000e-07 0.000 3.64050e-07 1.800 3.65000e-07 1.800 3.65050e-07 0.000 3.66000e-07 0.000
+ 3.66050e-07 1.800 3.67000e-07 1.800 3.67050e-07 0.000 3.68000e-07 0.000 3.68050e-07 1.800 3.69000e-07 1.800
+ 3.69050e-07 0.000 3.70000e-07 0.000 3.70050e-07 1.800 3.71000e-07 1.800 3.71050e-07 0.000 3.72000e-07 0.000
+ 3.72050e-07 1.800 3.73000e-07 1.800 3.73050e-07 0.000 3.74000e-07 0.000 3.74050e-07 1.800 3.75000e-07 1.800
+ 3.75050e-07 0.000 3.76000e-07 0.000 3.76050e-07 1.800 3.77000e-07 1.800 3.77050e-07 0.000 3.78000e-07 0.000
+ 3.78050e-07 1.800 3.79000e-07 1.800 3.79050e-07 0.000 3.80000e-07 0.000 3.80050e-07 1.800 3.81000e-07 1.800
+ 3.81050e-07 0.000 3.82000e-07 0.000 3.82050e-07 1.800 3.83000e-07 1.800 3.83050e-07 0.000 3.84000e-07 0.000
+ 3.84050e-07 1.800 3.85000e-07 1.800 3.85050e-07 0.000 3.86000e-07 0.000 3.86050e-07 1.800 3.87000e-07 1.800
+ 3.87050e-07 0.000 3.88000e-07 0.000 3.88050e-07 1.800 3.89000e-07 1.800 3.89050e-07 0.000 3.90000e-07 0.000
+ 3.90050e-07 1.800 3.91000e-07 1.800 3.91050e-07 0.000 3.92000e-07 0.000 3.92050e-07 1.800 3.93000e-07 1.800
+ 3.93050e-07 0.000 3.94000e-07 0.000 3.94050e-07 1.800 3.95000e-07 1.800 3.95050e-07 0.000 3.96000e-07 0.000
+ 3.96050e-07 1.800 3.97000e-07 1.800 3.97050e-07 0.000 3.98000e-07 0.000 3.98050e-07 1.800 3.99000e-07 1.800
+ 3.99050e-07 0.000 4.00000e-07 0.000 4.00050e-07 1.800 4.01000e-07 1.800 4.01050e-07 0.000 4.02000e-07 0.000
+ 4.02050e-07 1.800 4.03000e-07 1.800 4.03050e-07 0.000 4.04000e-07 0.000 4.04050e-07 1.800 4.05000e-07 1.800
+ 4.05050e-07 0.000 4.06000e-07 0.000 4.06050e-07 1.800 4.07000e-07 1.800 4.07050e-07 0.000 4.08000e-07 0.000
+ 4.08050e-07 1.800 4.09000e-07 1.800 4.09050e-07 0.000 4.10000e-07 0.000 4.10050e-07 1.800 4.11000e-07 1.800
+ 4.11050e-07 0.000 4.12000e-07 0.000 4.12050e-07 1.800 4.13000e-07 1.800 4.13050e-07 0.000 4.14000e-07 0.000
+ 4.14050e-07 1.800 4.15000e-07 1.800 4.15050e-07 0.000 4.16000e-07 0.000 4.16050e-07 1.800 4.17000e-07 1.800
+ 4.17050e-07 0.000 4.18000e-07 0.000 4.18050e-07 1.800 4.19000e-07 1.800 4.19050e-07 0.000 4.20000e-07 0.000
+ 4.20050e-07 1.800 4.21000e-07 1.800 4.21050e-07 0.000 4.22000e-07 0.000 4.22050e-07 1.800 4.23000e-07 1.800
+ 4.23050e-07 0.000 4.24000e-07 0.000 4.24050e-07 1.800 4.25000e-07 1.800 4.25050e-07 0.000 4.26000e-07 0.000
+ 4.26050e-07 1.800 4.27000e-07 1.800 4.27050e-07 0.000 4.28000e-07 0.000 4.28050e-07 1.800 4.29000e-07 1.800
+ 4.29050e-07 0.000 4.30000e-07 0.000 4.30050e-07 1.800 4.31000e-07 1.800 4.31050e-07 0.000 4.32000e-07 0.000
+ 4.32050e-07 1.800 4.33000e-07 1.800 4.33050e-07 0.000 4.34000e-07 0.000 4.34050e-07 1.800 4.35000e-07 1.800
+ 4.35050e-07 0.000 4.36000e-07 0.000 4.36050e-07 1.800 4.37000e-07 1.800 4.37050e-07 0.000 4.38000e-07 0.000
+ 4.38050e-07 1.800 4.39000e-07 1.800 4.39050e-07 0.000 4.40000e-07 0.000 4.40050e-07 1.800 4.41000e-07 1.800
+ 4.41050e-07 0.000 4.42000e-07 0.000 4.42050e-07 1.800 4.43000e-07 1.800 4.43050e-07 0.000 4.44000e-07 0.000
+ 4.44050e-07 1.800 4.45000e-07 1.800 4.45050e-07 0.000 4.46000e-07 0.000 4.46050e-07 1.800 4.47000e-07 1.800
+ 4.47050e-07 0.000 4.48000e-07 0.000 4.48050e-07 1.800 4.49000e-07 1.800 4.49050e-07 0.000 4.50000e-07 0.000
+ 4.50050e-07 1.800 4.51000e-07 1.800 4.51050e-07 0.000 4.52000e-07 0.000 4.52050e-07 1.800 4.53000e-07 1.800
+ 4.53050e-07 0.000 4.54000e-07 0.000 4.54050e-07 1.800 4.55000e-07 1.800 4.55050e-07 0.000 4.56000e-07 0.000
+ 4.56050e-07 1.800 4.57000e-07 1.800 4.57050e-07 0.000 4.58000e-07 0.000 4.58050e-07 1.800 4.59000e-07 1.800
+ 4.59050e-07 0.000 4.60000e-07 0.000 4.60050e-07 1.800 4.61000e-07 1.800 4.61050e-07 0.000 4.62000e-07 0.000
+ 4.62050e-07 1.800 4.63000e-07 1.800 4.63050e-07 0.000 4.64000e-07 0.000 4.64050e-07 1.800 4.65000e-07 1.800
+ 4.65050e-07 0.000 4.66000e-07 0.000 4.66050e-07 1.800 4.67000e-07 1.800 4.67050e-07 0.000 4.68000e-07 0.000
+ 4.68050e-07 1.800 4.69000e-07 1.800 4.69050e-07 0.000 4.70000e-07 0.000 4.70050e-07 1.800 4.71000e-07 1.800
+ 4.71050e-07 0.000 4.72000e-07 0.000 4.72050e-07 1.800 4.73000e-07 1.800 4.73050e-07 0.000 4.74000e-07 0.000
+ 4.74050e-07 1.800 4.75000e-07 1.800 4.75050e-07 0.000 4.76000e-07 0.000 4.76050e-07 1.800 4.77000e-07 1.800
+ 4.77050e-07 0.000 4.78000e-07 0.000 4.78050e-07 1.800 4.79000e-07 1.800 4.79050e-07 0.000 4.80000e-07 0.000
+ 4.80050e-07 1.800 4.81000e-07 1.800 4.81050e-07 0.000 4.82000e-07 0.000 4.82050e-07 1.800 4.83000e-07 1.800
+ 4.83050e-07 0.000 4.84000e-07 0.000 4.84050e-07 1.800 4.85000e-07 1.800 4.85050e-07 0.000 4.86000e-07 0.000
+ 4.86050e-07 1.800 4.87000e-07 1.800 4.87050e-07 0.000 4.88000e-07 0.000 4.88050e-07 1.800 4.89000e-07 1.800
+ 4.89050e-07 0.000 4.90000e-07 0.000 4.90050e-07 1.800 4.91000e-07 1.800 4.91050e-07 0.000 4.92000e-07 0.000
+ 4.92050e-07 1.800 4.93000e-07 1.800 4.93050e-07 0.000 4.94000e-07 0.000 4.94050e-07 1.800 4.95000e-07 1.800
+ 4.95050e-07 0.000 4.96000e-07 0.000 4.96050e-07 1.800 4.97000e-07 1.800 4.97050e-07 0.000 4.98000e-07 0.000
+ 4.98050e-07 1.800 4.99000e-07 1.800 4.99050e-07 0.000 5.00000e-07 0.000 5.00050e-07 1.800 5.01000e-07 1.800
+ 5.01050e-07 0.000 5.02000e-07 0.000 5.02050e-07 1.800 5.03000e-07 1.800 5.03050e-07 0.000 5.04000e-07 0.000
+ 5.04050e-07 1.800 5.05000e-07 1.800 5.05050e-07 0.000 5.06000e-07 0.000 5.06050e-07 1.800 5.07000e-07 1.800
+ 5.07050e-07 0.000 5.08000e-07 0.000 5.08050e-07 1.800 5.09000e-07 1.800 5.09050e-07 0.000 5.10000e-07 0.000
+ 5.10050e-07 1.800 5.11000e-07 1.800 5.11050e-07 0.000 5.12000e-07 0.000 5.12050e-07 1.800 5.13000e-07 1.800
+ 5.13050e-07 0.000 5.16000e-07 0.000 5.16050e-07 1.800 5.17000e-07 1.800 5.17050e-07 0.000 5.21000e-07 0.000
+ 5.21050e-07 1.800 5.22000e-07 1.800 5.22050e-07 0.000 5.23000e-07 0.000 5.23050e-07 1.800 5.24000e-07 1.800
+ 5.24050e-07 0.000 5.25000e-07 0.000 5.25050e-07 1.800 5.26000e-07 1.800 5.26050e-07 0.000 5.27000e-07 0.000
+ 5.27050e-07 1.800 5.28000e-07 1.800 5.28050e-07 0.000 5.29000e-07 0.000 5.29050e-07 1.800 5.31000e-07 1.800
+ 5.31050e-07 0.000 5.33000e-07 0.000 5.33050e-07 1.800 5.38000e-07 1.800 5.38050e-07 0.000 5.39000e-07 0.000
+ 5.39050e-07 1.800 5.40000e-07 1.800 5.40050e-07 0.000 5.41000e-07 0.000 5.41050e-07 1.800 5.42000e-07 1.800
+ 5.42050e-07 0.000 5.43000e-07 0.000 5.43050e-07 1.800 5.46000e-07 1.800 5.46050e-07 0.000 5.51000e-07 0.000
+ 5.51050e-07 1.800 5.52000e-07 1.800 5.52050e-07 0.000 5.54000e-07 0.000 5.54050e-07 1.800 5.55000e-07 1.800
+ 5.55050e-07 0.000 5.58000e-07 0.000 5.58050e-07 1.800 5.59000e-07 1.800 5.59050e-07 0.000 5.63000e-07 0.000
+ 5.63050e-07 1.800 5.64000e-07 1.800 5.64050e-07 0.000 5.65000e-07 0.000 5.65050e-07 1.800 5.67000e-07 1.800
+ 5.67050e-07 0.000 5.68000e-07 0.000 5.68050e-07 1.800 5.69000e-07 1.800 5.69050e-07 0.000 5.72000e-07 0.000
+ 5.72050e-07 1.800 5.75000e-07 1.800 5.75050e-07 0.000 5.76000e-07 0.000 5.76050e-07 1.800 5.78000e-07 1.800
+ 5.78050e-07 0.000 5.79000e-07 0.000 5.79050e-07 1.800 5.81000e-07 1.800 5.81050e-07 0.000 5.85000e-07 0.000
+ 5.85050e-07 1.800 5.88000e-07 1.800 5.88050e-07 0.000 5.89000e-07 0.000 5.89050e-07 1.800 5.91000e-07 1.800
+ 5.91050e-07 0.000 5.93000e-07 0.000 5.93050e-07 1.800 5.94000e-07 1.800 5.94050e-07 0.000 5.99000e-07 0.000
+ 5.99050e-07 1.800 6.02000e-07 1.800 6.02050e-07 0.000 6.04000e-07 0.000 6.04050e-07 1.800 6.09000e-07 1.800
+ 6.09050e-07 0.000 6.14000e-07 0.000 6.14050e-07 1.800 6.16000e-07 1.800 6.16050e-07 0.000 6.17000e-07 0.000
+ 6.17050e-07 1.800 6.19000e-07 1.800 6.19050e-07 0.000 6.21000e-07 0.000 6.21050e-07 1.800 6.22000e-07 1.800
+ 6.22050e-07 0.000 6.23000e-07 0.000 6.23050e-07 1.800 6.24000e-07 1.800 6.24050e-07 0.000 6.28000e-07 0.000
+ 6.28050e-07 1.800 6.29000e-07 1.800 6.29050e-07 0.000 6.30000e-07 0.000 6.30050e-07 1.800 6.31000e-07 1.800
+ 6.31050e-07 0.000 6.35000e-07 0.000 6.35050e-07 1.800 6.37000e-07 1.800 6.37050e-07 0.000 6.38000e-07 0.000
+ 6.38050e-07 1.800 6.39000e-07 1.800 6.39050e-07 0.000 6.40000e-07 0.000 6.40050e-07 1.800 6.41000e-07 1.800
+ 6.41050e-07 0.000 6.44000e-07 0.000 6.44050e-07 1.800 6.46000e-07 1.800 6.46050e-07 0.000 6.47000e-07 0.000
+ 6.47050e-07 1.800 6.48000e-07 1.800 6.48050e-07 0.000 6.49000e-07 0.000 6.49050e-07 1.800 6.50000e-07 1.800
+ 6.50050e-07 0.000 6.52000e-07 0.000 6.52050e-07 1.800 6.53000e-07 1.800 6.53050e-07 0.000 6.54000e-07 0.000
+ 6.54050e-07 1.800 6.56000e-07 1.800 6.56050e-07 0.000 6.59000e-07 0.000 6.59050e-07 1.800 6.61000e-07 1.800
+ 6.61050e-07 0.000 6.66000e-07 0.000 6.66050e-07 1.800 6.68000e-07 1.800 6.68050e-07 0.000 6.69000e-07 0.000
+ 6.69050e-07 1.800 6.70000e-07 1.800 6.70050e-07 0.000 6.71000e-07 0.000 6.71050e-07 1.800 6.75000e-07 1.800
+ 6.75050e-07 0.000 6.78000e-07 0.000 6.78050e-07 1.800 6.80000e-07 1.800 6.80050e-07 0.000 6.81000e-07 0.000
+ 6.81050e-07 1.800 6.84000e-07 1.800 6.84050e-07 0.000 6.86000e-07 0.000 6.86050e-07 1.800 6.88000e-07 1.800
+ 6.88050e-07 0.000 6.89000e-07 0.000 6.89050e-07 1.800 6.90000e-07 1.800 6.90050e-07 0.000 6.91000e-07 0.000
+ 6.91050e-07 1.800 6.92000e-07 1.800 6.92050e-07 0.000 6.94000e-07 0.000 6.94050e-07 1.800 6.96000e-07 1.800
+ 6.96050e-07 0.000 6.97000e-07 0.000 6.97050e-07 1.800 6.98000e-07 1.800 6.98050e-07 0.000 6.99000e-07 0.000
+ 6.99050e-07 1.800 7.00000e-07 1.800 7.00050e-07 0.000 7.01000e-07 0.000 7.01050e-07 1.800 7.03000e-07 1.800
+ 7.03050e-07 0.000 7.05000e-07 0.000 7.05050e-07 1.800 7.09000e-07 1.800 7.09050e-07 0.000 7.12000e-07 0.000
+ 7.12050e-07 1.800 7.14000e-07 1.800 7.14050e-07 0.000 7.15000e-07 0.000 7.15050e-07 1.800 7.21000e-07 1.800
+ 7.21050e-07 0.000 7.22000e-07 0.000 7.22050e-07 1.800 7.23000e-07 1.800 7.23050e-07 0.000 7.24000e-07 0.000
+ 7.24050e-07 1.800 7.25000e-07 1.800 7.25050e-07 0.000 7.34000e-07 0.000 7.34050e-07 1.800 7.36000e-07 1.800
+ 7.36050e-07 0.000 7.37000e-07 0.000 7.37050e-07 1.800 7.38000e-07 1.800 7.38050e-07 0.000 7.39000e-07 0.000
+ 7.39050e-07 1.800 7.41000e-07 1.800 7.41050e-07 0.000 7.44000e-07 0.000 7.44050e-07 1.800 7.45000e-07 1.800
+ 7.45050e-07 0.000 7.46000e-07 0.000 7.46050e-07 1.800 7.48000e-07 1.800 7.48050e-07 0.000 7.49000e-07 0.000
+ 7.49050e-07 1.800 7.51000e-07 1.800 7.51050e-07 0.000 7.52000e-07 0.000 7.52050e-07 1.800 7.53000e-07 1.800
+ 7.53050e-07 0.000 7.57000e-07 0.000 7.57050e-07 1.800 7.59000e-07 1.800 7.59050e-07 0.000 7.60000e-07 0.000
+ 7.60050e-07 1.800 7.62000e-07 1.800 7.62050e-07 0.000 7.63000e-07 0.000 7.63050e-07 1.800 7.66000e-07 1.800
+ 7.66050e-07 0.000 7.67000e-07 0.000 7.67050e-07 1.800 7.69000e-07 1.800 7.69050e-07 0.000 7.70000e-07 0.000
+ 7.70050e-07 1.800 7.72000e-07 1.800 7.72050e-07 0.000 7.74000e-07 0.000 7.74050e-07 1.800 7.83000e-07 1.800
+ 7.83050e-07 0.000 7.84000e-07 0.000 7.84050e-07 1.800 7.86000e-07 1.800 7.86050e-07 0.000 7.87000e-07 0.000
+ 7.87050e-07 1.800 7.89000e-07 1.800 7.89050e-07 0.000 7.90000e-07 0.000 7.90050e-07 1.800 7.91000e-07 1.800
+ 7.91050e-07 0.000 7.92000e-07 0.000 7.92050e-07 1.800 7.95000e-07 1.800 7.95050e-07 0.000 7.98000e-07 0.000
+ 7.98050e-07 1.800 7.99000e-07 1.800 7.99050e-07 0.000 8.00000e-07 0.000 8.00050e-07 1.800 8.01000e-07 1.800
+ 8.01050e-07 0.000 8.04000e-07 0.000 8.04050e-07 1.800 8.06000e-07 1.800 8.06050e-07 0.000 8.10000e-07 0.000
+ 8.10050e-07 1.800 8.17000e-07 1.800 8.17050e-07 0.000 8.18000e-07 0.000 8.18050e-07 1.800 8.20000e-07 1.800
+ 8.20050e-07 0.000 8.24000e-07 0.000 8.24050e-07 1.800 8.25000e-07 1.800 8.25050e-07 0.000 8.26000e-07 0.000
+ 8.26050e-07 1.800 8.29000e-07 1.800 8.29050e-07 0.000 8.33000e-07 0.000 8.33050e-07 1.800 8.37000e-07 1.800
+ 8.37050e-07 0.000 8.38000e-07 0.000 8.38050e-07 1.800 8.41000e-07 1.800 8.41050e-07 0.000 8.43000e-07 0.000
+ 8.43050e-07 1.800 8.44000e-07 1.800 8.44050e-07 0.000 8.46000e-07 0.000 8.46050e-07 1.800 8.47000e-07 1.800
+ 8.47050e-07 0.000 8.48000e-07 0.000 8.48050e-07 1.800 8.49000e-07 1.800 8.49050e-07 0.000 8.52000e-07 0.000
+ 8.52050e-07 1.800 8.53000e-07 1.800 8.53050e-07 0.000 8.54000e-07 0.000 8.54050e-07 1.800 8.55000e-07 1.800
+ 8.55050e-07 0.000 8.57000e-07 0.000 8.57050e-07 1.800 8.59000e-07 1.800 8.59050e-07 0.000 8.60000e-07 0.000
+ 8.60050e-07 1.800 8.68000e-07 1.800 8.68050e-07 0.000 8.71000e-07 0.000 8.71050e-07 1.800 8.77000e-07 1.800
+ 8.77050e-07 0.000 8.80000e-07 0.000 8.80050e-07 1.800 8.81000e-07 1.800 8.81050e-07 0.000 8.82000e-07 0.000
+ 8.82050e-07 1.800 8.83000e-07 1.800 8.83050e-07 0.000 8.87000e-07 0.000 8.87050e-07 1.800 8.91000e-07 1.800
+ 8.91050e-07 0.000 8.92000e-07 0.000 8.92050e-07 1.800 8.93000e-07 1.800 8.93050e-07 0.000 8.96000e-07 0.000
+ 8.96050e-07 1.800 8.97000e-07 1.800 8.97050e-07 0.000 8.98000e-07 0.000 8.98050e-07 1.800 9.00000e-07 1.800
+ 9.00050e-07 0.000 9.01000e-07 0.000 9.01050e-07 1.800 9.04000e-07 1.800 9.04050e-07 0.000 9.05000e-07 0.000
+ 9.05050e-07 1.800 9.06000e-07 1.800 9.06050e-07 0.000 9.08000e-07 0.000 9.08050e-07 1.800 9.09000e-07 1.800
+ 9.09050e-07 0.000 9.10000e-07 0.000 9.10050e-07 1.800 9.11000e-07 1.800 9.11050e-07 0.000 9.12000e-07 0.000
+ 9.12050e-07 1.800 9.13000e-07 1.800 9.13050e-07 0.000 9.14000e-07 0.000 9.14050e-07 1.800 9.16000e-07 1.800
+ 9.16050e-07 0.000 9.21000e-07 0.000 9.21050e-07 1.800 9.22000e-07 1.800 9.22050e-07 0.000 9.23000e-07 0.000
+ 9.23050e-07 1.800 9.30000e-07 1.800 9.30050e-07 0.000 9.34000e-07 0.000 9.34050e-07 1.800 9.35000e-07 1.800
+ 9.35050e-07 0.000 9.36000e-07 0.000 9.36050e-07 1.800 9.37000e-07 1.800 9.37050e-07 0.000 9.41000e-07 0.000
+ 9.41050e-07 1.800 9.42000e-07 1.800 9.42050e-07 0.000 9.43000e-07 0.000 9.43050e-07 1.800 9.46000e-07 1.800
+ 9.46050e-07 0.000 9.47000e-07 0.000 9.47050e-07 1.800 9.49000e-07 1.800 9.49050e-07 0.000 9.51000e-07 0.000
+ 9.51050e-07 1.800 9.53000e-07 1.800 9.53050e-07 0.000 9.55000e-07 0.000 9.55050e-07 1.800 9.58000e-07 1.800
+ 9.58050e-07 0.000 9.60000e-07 0.000 9.60050e-07 1.800 9.61000e-07 1.800 9.61050e-07 0.000 9.62000e-07 0.000
+ 9.62050e-07 1.800 9.67000e-07 1.800 9.67050e-07 0.000 9.70000e-07 0.000 9.70050e-07 1.800 9.71000e-07 1.800
+ 9.71050e-07 0.000 9.73000e-07 0.000 9.73050e-07 1.800 9.74000e-07 1.800 9.74050e-07 0.000 9.76000e-07 0.000
+ 9.76050e-07 1.800 9.78000e-07 1.800 9.78050e-07 0.000 9.81000e-07 0.000 9.81050e-07 1.800 9.82000e-07 1.800
+ 9.82050e-07 0.000 9.83000e-07 0.000 9.83050e-07 1.800 9.84000e-07 1.800 9.84050e-07 0.000 9.87000e-07 0.000
+ 9.87050e-07 1.800 9.88000e-07 1.800 9.88050e-07 0.000 9.89000e-07 0.000 9.89050e-07 1.800 9.91000e-07 1.800
+ 9.91050e-07 0.000 9.92000e-07 0.000 9.92050e-07 1.800 9.93000e-07 1.800 9.93050e-07 0.000 9.94000e-07 0.000
+ 9.94050e-07 1.800 9.97000e-07 1.800 9.97050e-07 0.000 9.98000e-07 0.000 9.98050e-07 1.800 1.00000e-06 1.800
+ 1.00005e-06 0.000 1.00500e-06 0.000 1.00505e-06 1.800 1.00600e-06 1.800 1.00605e-06 0.000 1.00700e-06 0.000
+ 1.00705e-06 1.800 1.00800e-06 1.800 1.00805e-06 0.000 1.01000e-06 0.000 1.01005e-06 1.800 1.01100e-06 1.800
+ 1.01105e-06 0.000 1.01300e-06 0.000 1.01305e-06 1.800 1.01400e-06 1.800 1.01405e-06 0.000 1.01600e-06 0.000
+ 1.01605e-06 1.800 1.01900e-06 1.800 1.01905e-06 0.000 1.02000e-06 0.000 1.02005e-06 1.800 1.02100e-06 1.800
+ 1.02105e-06 0.000 1.02400e-06 0.000
+ )
Xd_c0b src_c0b c0b vdd gnd tb_inv
Xl_c4 c4 lo_c4 vdd gnd tb_inv
X0 g0b t0b g1b t1b g2b t2b g3b t3b c0b c4 vdd gnd c4_x1
.tran 200p 1.02400e-06
.control
set wr_singlescale
set wr_vecnames
run
set curplottitle=Bhargav-2025102061-1.3-c4_x1-function
wrdata wave.txt v(g0b) v(t0b) v(g1b) v(t1b) v(g2b) v(t2b) v(g3b) v(t3b) v(c0b) v(c4) i(VDD)
quit
.endc
.end
