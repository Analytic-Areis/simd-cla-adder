* Truth table of carry_r_x1: inputs through unit inverters, outputs load 20L/10L inverter
.include ../../../../spice/models/TSMC_180nm.txt
.options reltol=1e-3
VDD vdd gnd 1.8
* inv_x1: inverter
* GENERATED from part1/cells/library.py. Do not edit by hand.
.subckt inv_x1 a y vdd gnd
Mp1 y a vdd vdd CMOSP W=1.8000e-06 L=1.8000e-07 AS=9.7200e-13 PS=4.6800e-06 AD=9.7200e-13 PD=4.6800e-06
Mn1 y a gnd gnd CMOSN W=9.0000e-07 L=1.8000e-07 AS=4.8600e-13 PS=2.8800e-06 AD=4.8600e-13 PD=2.8800e-06
.ends inv_x1
* c1_x1: C1 complex gate, stack 2
* GENERATED from part1/cells/library.py. Do not edit by hand.
.subckt c1_x1 g0b t0b c0b c1 vdd gnd
Mp1 c1 g0b vdd vdd CMOSP W=1.8000e-06 L=1.8000e-07 AS=9.7200e-13 PS=4.6800e-06 AD=9.7200e-13 PD=4.6800e-06
Mp2 xp1 t0b vdd vdd CMOSP W=3.6000e-06 L=1.8000e-07 AS=1.9440e-12 PS=8.2800e-06 AD=9.7200e-13 PD=7.7400e-06
Mp3 c1 c0b xp1 vdd CMOSP W=3.6000e-06 L=1.8000e-07 AS=9.7200e-13 PS=7.7400e-06 AD=1.9440e-12 PD=8.2800e-06
Mn1 c1 g0b xn1 gnd CMOSN W=1.8000e-06 L=1.8000e-07 AS=9.7200e-13 PS=4.6800e-06 AD=9.7200e-13 PD=4.6800e-06
Mn2 xn1 t0b gnd gnd CMOSN W=1.8000e-06 L=1.8000e-07 AS=9.7200e-13 PS=4.6800e-06 AD=9.7200e-13 PD=4.6800e-06
Mn3 xn1 c0b gnd gnd CMOSN W=1.8000e-06 L=1.8000e-07 AS=9.7200e-13 PS=4.6800e-06 AD=9.7200e-13 PD=4.6800e-06
.ends c1_x1
* c2_x1: C2 complex gate, stack 3
* GENERATED from part1/cells/library.py. Do not edit by hand.
.subckt c2_x1 g0b t0b g1b t1b c0b c2 vdd gnd
Mp1 c2 g1b vdd vdd CMOSP W=1.8000e-06 L=1.8000e-07 AS=9.7200e-13 PS=4.6800e-06 AD=9.7200e-13 PD=4.6800e-06
Mp2 xp1 t1b vdd vdd CMOSP W=5.4000e-06 L=1.8000e-07 AS=2.9160e-12 PS=1.1880e-05 AD=2.9160e-12 PD=1.1880e-05
Mp3 c2 g0b xp1 vdd CMOSP W=3.6000e-06 L=1.8000e-07 AS=1.9440e-12 PS=8.2800e-06 AD=1.9440e-12 PD=8.2800e-06
Mp4 xp2 t0b xp1 vdd CMOSP W=5.4000e-06 L=1.8000e-07 AS=2.9160e-12 PS=1.1880e-05 AD=1.4580e-12 PD=1.1340e-05
Mp5 c2 c0b xp2 vdd CMOSP W=5.4000e-06 L=1.8000e-07 AS=1.4580e-12 PS=1.1340e-05 AD=2.9160e-12 PD=1.1880e-05
Mn1 c2 g1b xn1 gnd CMOSN W=2.7000e-06 L=1.8000e-07 AS=1.4580e-12 PS=6.4800e-06 AD=1.4580e-12 PD=6.4800e-06
Mn2 xn1 t1b gnd gnd CMOSN W=1.8000e-06 L=1.8000e-07 AS=9.7200e-13 PS=4.6800e-06 AD=9.7200e-13 PD=4.6800e-06
Mn3 xn1 g0b xn2 gnd CMOSN W=2.7000e-06 L=1.8000e-07 AS=1.4580e-12 PS=6.4800e-06 AD=1.4580e-12 PD=6.4800e-06
Mn4 xn2 t0b gnd gnd CMOSN W=2.7000e-06 L=1.8000e-07 AS=1.4580e-12 PS=6.4800e-06 AD=1.4580e-12 PD=6.4800e-06
Mn5 xn2 c0b gnd gnd CMOSN W=2.7000e-06 L=1.8000e-07 AS=1.4580e-12 PS=6.4800e-06 AD=1.4580e-12 PD=6.4800e-06
.ends c2_x1
* c3_x1: C3 complex gate, stack 4
* GENERATED from part1/cells/library.py. Do not edit by hand.
.subckt c3_x1 g0b t0b g1b t1b g2b t2b c0b c3 vdd gnd
Mp1 c3 g2b vdd vdd CMOSP W=1.8000e-06 L=1.8000e-07 AS=9.7200e-13 PS=4.6800e-06 AD=9.7200e-13 PD=4.6800e-06
Mp2 xp1 t2b vdd vdd CMOSP W=7.2000e-06 L=1.8000e-07 AS=3.8880e-12 PS=1.5480e-05 AD=3.8880e-12 PD=1.5480e-05
Mp3 c3 g1b xp1 vdd CMOSP W=3.6000e-06 L=1.8000e-07 AS=1.9440e-12 PS=8.2800e-06 AD=1.9440e-12 PD=8.2800e-06
Mp4 xp2 t1b xp1 vdd CMOSP W=7.2000e-06 L=1.8000e-07 AS=3.8880e-12 PS=1.5480e-05 AD=3.8880e-12 PD=1.5480e-05
Mp5 c3 g0b xp2 vdd CMOSP W=5.4000e-06 L=1.8000e-07 AS=2.9160e-12 PS=1.1880e-05 AD=2.9160e-12 PD=1.1880e-05
Mp6 xp3 t0b xp2 vdd CMOSP W=7.2000e-06 L=1.8000e-07 AS=3.8880e-12 PS=1.5480e-05 AD=1.9440e-12 PD=1.4940e-05
Mp7 c3 c0b xp3 vdd CMOSP W=7.2000e-06 L=1.8000e-07 AS=1.9440e-12 PS=1.4940e-05 AD=3.8880e-12 PD=1.5480e-05
Mn1 c3 g2b xn1 gnd CMOSN W=3.6000e-06 L=1.8000e-07 AS=1.9440e-12 PS=8.2800e-06 AD=1.9440e-12 PD=8.2800e-06
Mn2 xn1 t2b gnd gnd CMOSN W=1.8000e-06 L=1.8000e-07 AS=9.7200e-13 PS=4.6800e-06 AD=9.7200e-13 PD=4.6800e-06
Mn3 xn1 g1b xn2 gnd CMOSN W=3.6000e-06 L=1.8000e-07 AS=1.9440e-12 PS=8.2800e-06 AD=1.9440e-12 PD=8.2800e-06
Mn4 xn2 t1b gnd gnd CMOSN W=2.7000e-06 L=1.8000e-07 AS=1.4580e-12 PS=6.4800e-06 AD=1.4580e-12 PD=6.4800e-06
Mn5 xn2 g0b xn3 gnd CMOSN W=3.6000e-06 L=1.8000e-07 AS=1.9440e-12 PS=8.2800e-06 AD=1.9440e-12 PD=8.2800e-06
Mn6 xn3 t0b gnd gnd CMOSN W=3.6000e-06 L=1.8000e-07 AS=1.9440e-12 PS=8.2800e-06 AD=1.9440e-12 PD=8.2800e-06
Mn7 xn3 c0b gnd gnd CMOSN W=3.6000e-06 L=1.8000e-07 AS=1.9440e-12 PS=8.2800e-06 AD=1.9440e-12 PD=8.2800e-06
.ends c3_x1
* c4b_mirror_x1: C4-bar mirror gate, stack 3
* GENERATED from part1/cells/library.py. Do not edit by hand.
.subckt c4b_mirror_x1 a3 b3 a2 b2 c2 c4b vdd gnd
Mp1 xp1 b3 vdd vdd CMOSP W=3.6000e-06 L=1.8000e-07 AS=1.9440e-12 PS=8.2800e-06 AD=9.7200e-13 PD=7.7400e-06
Mp2 c4b a3 xp1 vdd CMOSP W=3.6000e-06 L=1.8000e-07 AS=9.7200e-13 PS=7.7400e-06 AD=1.9440e-12 PD=8.2800e-06
Mp3 xp2 a3 vdd vdd CMOSP W=5.4000e-06 L=1.8000e-07 AS=2.9160e-12 PS=1.1880e-05 AD=2.9160e-12 PD=1.1880e-05
Mp4 xp2 b3 vdd vdd CMOSP W=5.4000e-06 L=1.8000e-07 AS=2.9160e-12 PS=1.1880e-05 AD=2.9160e-12 PD=1.1880e-05
Mp5 xp3 b2 xp2 vdd CMOSP W=5.4000e-06 L=1.8000e-07 AS=2.9160e-12 PS=1.1880e-05 AD=1.4580e-12 PD=1.1340e-05
Mp6 c4b a2 xp3 vdd CMOSP W=5.4000e-06 L=1.8000e-07 AS=1.4580e-12 PS=1.1340e-05 AD=2.9160e-12 PD=1.1880e-05
Mp7 xp4 a2 xp2 vdd CMOSP W=5.4000e-06 L=1.8000e-07 AS=2.9160e-12 PS=1.1880e-05 AD=2.9160e-12 PD=1.1880e-05
Mp8 xp4 b2 xp2 vdd CMOSP W=5.4000e-06 L=1.8000e-07 AS=2.9160e-12 PS=1.1880e-05 AD=2.9160e-12 PD=1.1880e-05
Mp9 c4b c2 xp4 vdd CMOSP W=5.4000e-06 L=1.8000e-07 AS=2.9160e-12 PS=1.1880e-05 AD=2.9160e-12 PD=1.1880e-05
Mn1 c4b a3 xn1 gnd CMOSN W=1.8000e-06 L=1.8000e-07 AS=4.8600e-13 PS=4.1400e-06 AD=9.7200e-13 PD=4.6800e-06
Mn2 xn1 b3 gnd gnd CMOSN W=1.8000e-06 L=1.8000e-07 AS=9.7200e-13 PS=4.6800e-06 AD=4.8600e-13 PD=4.1400e-06
Mn3 c4b a2 xn3 gnd CMOSN W=2.7000e-06 L=1.8000e-07 AS=7.2900e-13 PS=5.9400e-06 AD=1.4580e-12 PD=6.4800e-06
Mn4 xn3 b2 xn2 gnd CMOSN W=2.7000e-06 L=1.8000e-07 AS=1.4580e-12 PS=6.4800e-06 AD=7.2900e-13 PD=5.9400e-06
Mn5 c4b c2 xn4 gnd CMOSN W=2.7000e-06 L=1.8000e-07 AS=1.4580e-12 PS=6.4800e-06 AD=1.4580e-12 PD=6.4800e-06
Mn6 xn4 a2 xn2 gnd CMOSN W=2.7000e-06 L=1.8000e-07 AS=1.4580e-12 PS=6.4800e-06 AD=1.4580e-12 PD=6.4800e-06
Mn7 xn4 b2 xn2 gnd CMOSN W=2.7000e-06 L=1.8000e-07 AS=1.4580e-12 PS=6.4800e-06 AD=1.4580e-12 PD=6.4800e-06
Mn8 xn2 a3 gnd gnd CMOSN W=2.7000e-06 L=1.8000e-07 AS=1.4580e-12 PS=6.4800e-06 AD=1.4580e-12 PD=6.4800e-06
Mn9 xn2 b3 gnd gnd CMOSN W=2.7000e-06 L=1.8000e-07 AS=1.4580e-12 PS=6.4800e-06 AD=1.4580e-12 PD=6.4800e-06
.ends c4b_mirror_x1
* carry_r_x1: candidate R carry generator
* GENERATED from part1/cells/library.py. Do not edit by hand.
.subckt carry_r_x1 g0b t0b g1b t1b g2b t2b c0 a2 b2 a3 b3 c1 c2 c3 c4 vdd gnd
Xinvc0 c0 c0b vdd gnd inv_x1
Xc1 g0b t0b c0b c1 vdd gnd c1_x1
Xc2 g0b t0b g1b t1b c0b c2 vdd gnd c2_x1
Xc3 g0b t0b g1b t1b g2b t2b c0b c3 vdd gnd c3_x1
Xc4m a3 b3 a2 b2 c2 c4b vdd gnd c4b_mirror_x1
Xinvc4 c4b c4 vdd gnd inv_x1
.ends carry_r_x1
.subckt tb_inv a y vdd gnd
mp y a vdd vdd CMOSP W=1.8e-06 L=1.8e-07 AS=9.72e-13 PS=4.68e-06 AD=9.72e-13 PD=4.68e-06
mn y a gnd gnd CMOSN W=9.0e-07 L=1.8e-07 AS=4.86e-13 PS=2.88e-06 AD=4.86e-13 PD=2.88e-06
.ends
Vg0b src_g0b gnd PWL(
+ 0.00000e+00 1.800 1.02400e-06 1.800 1.02405e-06 0.000 2.05100e-06 0.000 2.05105e-06 1.800 2.05300e-06 1.800
+ 2.05305e-06 0.000 2.05400e-06 0.000 2.05405e-06 1.800 2.05500e-06 1.800 2.05505e-06 0.000 2.05600e-06 0.000
+ 2.05605e-06 1.800 2.05900e-06 1.800 2.05905e-06 0.000 2.06200e-06 0.000 2.06205e-06 1.800 2.06300e-06 1.800
+ 2.06305e-06 0.000 2.06400e-06 0.000 2.06405e-06 1.800 2.06500e-06 1.800 2.06505e-06 0.000 2.07000e-06 0.000
+ 2.07005e-06 1.800 2.07100e-06 1.800 2.07105e-06 0.000 2.07200e-06 0.000 2.07205e-06 1.800 2.07300e-06 1.800
+ 2.07305e-06 0.000 2.07400e-06 0.000 2.07405e-06 1.800 2.07500e-06 1.800 2.07505e-06 0.000 2.07600e-06 0.000
+ 2.07605e-06 1.800 2.07700e-06 1.800 2.07705e-06 0.000 2.07800e-06 0.000 2.07805e-06 1.800 2.08000e-06 1.800
+ 2.08005e-06 0.000 2.08100e-06 0.000 2.08105e-06 1.800 2.08300e-06 1.800 2.08305e-06 0.000 2.08400e-06 0.000
+ 2.08405e-06 1.800 2.08600e-06 1.800 2.08605e-06 0.000 2.08900e-06 0.000 2.08905e-06 1.800 2.09000e-06 1.800
+ 2.09005e-06 0.000 2.09100e-06 0.000 2.09105e-06 1.800 2.09600e-06 1.800 2.09605e-06 0.000 2.10100e-06 0.000
+ 2.10105e-06 1.800 2.10200e-06 1.800 2.10205e-06 0.000 2.10300e-06 0.000 2.10305e-06 1.800 2.10400e-06 1.800
+ 2.10405e-06 0.000 2.10800e-06 0.000 2.10805e-06 1.800 2.11100e-06 1.800 2.11105e-06 0.000 2.11300e-06 0.000
+ 2.11305e-06 1.800 2.11400e-06 1.800 2.11405e-06 0.000 2.11600e-06 0.000 2.11605e-06 1.800 2.12300e-06 1.800
+ 2.12305e-06 0.000 2.12400e-06 0.000 2.12405e-06 1.800 2.12800e-06 1.800 2.12805e-06 0.000 2.13200e-06 0.000
+ 2.13205e-06 1.800 2.13300e-06 1.800 2.13305e-06 0.000 2.13400e-06 0.000 2.13405e-06 1.800 2.13900e-06 1.800
+ 2.13905e-06 0.000 2.14300e-06 0.000 2.14305e-06 1.800 2.14900e-06 1.800 2.14905e-06 0.000 2.15000e-06 0.000
+ 2.15005e-06 1.800 2.15100e-06 1.800 2.15105e-06 0.000 2.15400e-06 0.000 2.15405e-06 1.800 2.15600e-06 1.800
+ 2.15605e-06 0.000 2.15800e-06 0.000 2.15805e-06 1.800 2.16000e-06 1.800 2.16005e-06 0.000 2.16100e-06 0.000
+ 2.16105e-06 1.800 2.16600e-06 1.800 2.16605e-06 0.000 2.16700e-06 0.000 2.16705e-06 1.800 2.17100e-06 1.800
+ 2.17105e-06 0.000 2.17300e-06 0.000 2.17305e-06 1.800 2.17500e-06 1.800 2.17505e-06 0.000 2.17800e-06 0.000
+ 2.17805e-06 1.800 2.18000e-06 1.800 2.18005e-06 0.000 2.18200e-06 0.000 2.18205e-06 1.800 2.18500e-06 1.800
+ 2.18505e-06 0.000 2.19400e-06 0.000 2.19405e-06 1.800 2.19500e-06 1.800 2.19505e-06 0.000 2.19600e-06 0.000
+ 2.19605e-06 1.800 2.19700e-06 1.800 2.19705e-06 0.000 2.19800e-06 0.000 2.19805e-06 1.800 2.20000e-06 1.800
+ 2.20005e-06 0.000 2.20100e-06 0.000 2.20105e-06 1.800 2.20200e-06 1.800 2.20205e-06 0.000 2.20300e-06 0.000
+ 2.20305e-06 1.800 2.20400e-06 1.800 2.20405e-06 0.000 2.20700e-06 0.000 2.20705e-06 1.800 2.20900e-06 1.800
+ 2.20905e-06 0.000 2.21000e-06 0.000 2.21005e-06 1.800 2.21100e-06 1.800 2.21105e-06 0.000 2.21200e-06 0.000
+ 2.21205e-06 1.800 2.21300e-06 1.800 2.21305e-06 0.000 2.21700e-06 0.000 2.21705e-06 1.800 2.21800e-06 1.800
+ 2.21805e-06 0.000 2.22200e-06 0.000 2.22205e-06 1.800 2.22600e-06 1.800 2.22605e-06 0.000 2.22900e-06 0.000
+ 2.22905e-06 1.800 2.23100e-06 1.800 2.23105e-06 0.000 2.23300e-06 0.000 2.23305e-06 1.800 2.23400e-06 1.800
+ 2.23405e-06 0.000 2.23600e-06 0.000 2.23605e-06 1.800 2.23700e-06 1.800 2.23705e-06 0.000 2.24100e-06 0.000
+ 2.24105e-06 1.800 2.24400e-06 1.800 2.24405e-06 0.000 2.24500e-06 0.000 2.24505e-06 1.800 2.24600e-06 1.800
+ 2.24605e-06 0.000 2.24800e-06 0.000 2.24805e-06 1.800 2.25100e-06 1.800 2.25105e-06 0.000 2.25200e-06 0.000
+ 2.25205e-06 1.800 2.25400e-06 1.800 2.25405e-06 0.000 2.25500e-06 0.000 2.25505e-06 1.800 2.25600e-06 1.800
+ 2.25605e-06 0.000 2.25700e-06 0.000 2.25705e-06 1.800 2.25900e-06 1.800 2.25905e-06 0.000 2.26200e-06 0.000
+ 2.26205e-06 1.800 2.26300e-06 1.800 2.26305e-06 0.000 2.26400e-06 0.000 2.26405e-06 1.800 2.26900e-06 1.800
+ 2.26905e-06 0.000 2.27100e-06 0.000 2.27105e-06 1.800 2.27400e-06 1.800 2.27405e-06 0.000 2.27500e-06 0.000
+ 2.27505e-06 1.800 2.27600e-06 1.800 2.27605e-06 0.000 2.27700e-06 0.000 2.27705e-06 1.800 2.27900e-06 1.800
+ 2.27905e-06 0.000 2.28500e-06 0.000 2.28505e-06 1.800 2.28700e-06 1.800 2.28705e-06 0.000 2.29100e-06 0.000
+ 2.29105e-06 1.800 2.29600e-06 1.800 2.29605e-06 0.000 2.30100e-06 0.000 2.30105e-06 1.800 2.30600e-06 1.800
+ 2.30605e-06 0.000 2.30700e-06 0.000 2.30705e-06 1.800 2.30900e-06 1.800 2.30905e-06 0.000 2.31000e-06 0.000
+ 2.31005e-06 1.800 2.31200e-06 1.800 2.31205e-06 0.000 2.31300e-06 0.000 2.31305e-06 1.800 2.31400e-06 1.800
+ 2.31405e-06 0.000 2.32000e-06 0.000 2.32005e-06 1.800 2.32200e-06 1.800 2.32205e-06 0.000 2.32300e-06 0.000
+ 2.32305e-06 1.800 2.32500e-06 1.800 2.32505e-06 0.000 2.32600e-06 0.000 2.32605e-06 1.800 2.32800e-06 1.800
+ 2.32805e-06 0.000 2.32900e-06 0.000 2.32905e-06 1.800 2.33300e-06 1.800 2.33305e-06 0.000 2.33500e-06 0.000
+ 2.33505e-06 1.800 2.33700e-06 1.800 2.33705e-06 0.000 2.34100e-06 0.000 2.34105e-06 1.800 2.34200e-06 1.800
+ 2.34205e-06 0.000 2.34400e-06 0.000 2.34405e-06 1.800 2.34800e-06 1.800 2.34805e-06 0.000 2.35100e-06 0.000
+ 2.35105e-06 1.800 2.35200e-06 1.800 2.35205e-06 0.000 2.35300e-06 0.000 2.35305e-06 1.800 2.35400e-06 1.800
+ 2.35405e-06 0.000 2.35500e-06 0.000 2.35505e-06 1.800 2.35800e-06 1.800 2.35805e-06 0.000 2.35900e-06 0.000
+ 2.35905e-06 1.800 2.36000e-06 1.800 2.36005e-06 0.000 2.36100e-06 0.000 2.36105e-06 1.800 2.36400e-06 1.800
+ 2.36405e-06 0.000 2.36500e-06 0.000 2.36505e-06 1.800 2.36700e-06 1.800 2.36705e-06 0.000 2.36800e-06 0.000
+ 2.36805e-06 1.800 2.37100e-06 1.800 2.37105e-06 0.000 2.37200e-06 0.000 2.37205e-06 1.800 2.37300e-06 1.800
+ 2.37305e-06 0.000 2.37400e-06 0.000 2.37405e-06 1.800 2.37600e-06 1.800 2.37605e-06 0.000 2.37900e-06 0.000
+ 2.37905e-06 1.800 2.38000e-06 1.800 2.38005e-06 0.000 2.38200e-06 0.000 2.38205e-06 1.800 2.38500e-06 1.800
+ 2.38505e-06 0.000 2.39000e-06 0.000 2.39005e-06 1.800 2.39200e-06 1.800 2.39205e-06 0.000 2.39300e-06 0.000
+ 2.39305e-06 1.800 2.39500e-06 1.800 2.39505e-06 0.000 2.39600e-06 0.000 2.39605e-06 1.800 2.39800e-06 1.800
+ 2.39805e-06 0.000 2.39900e-06 0.000 2.39905e-06 1.800 2.40100e-06 1.800 2.40105e-06 0.000 2.40400e-06 0.000
+ 2.40405e-06 1.800 2.40500e-06 1.800 2.40505e-06 0.000 2.40900e-06 0.000 2.40905e-06 1.800 2.41000e-06 1.800
+ 2.41005e-06 0.000 2.41100e-06 0.000 2.41105e-06 1.800 2.41400e-06 1.800 2.41405e-06 0.000 2.41500e-06 0.000
+ 2.41505e-06 1.800 2.41700e-06 1.800 2.41705e-06 0.000 2.41800e-06 0.000 2.41805e-06 1.800 2.42000e-06 1.800
+ 2.42005e-06 0.000 2.42200e-06 0.000 2.42205e-06 1.800 2.42600e-06 1.800 2.42605e-06 0.000 2.42700e-06 0.000
+ 2.42705e-06 1.800 2.43000e-06 1.800 2.43005e-06 0.000 2.43800e-06 0.000 2.43805e-06 1.800 2.43900e-06 1.800
+ 2.43905e-06 0.000 2.44000e-06 0.000 2.44005e-06 1.800 2.44100e-06 1.800 2.44105e-06 0.000 2.44300e-06 0.000
+ 2.44305e-06 1.800 2.44500e-06 1.800 2.44505e-06 0.000 2.44600e-06 0.000 2.44605e-06 1.800 2.44900e-06 1.800
+ 2.44905e-06 0.000 2.45100e-06 0.000 2.45105e-06 1.800 2.45200e-06 1.800 2.45205e-06 0.000 2.45300e-06 0.000
+ 2.45305e-06 1.800 2.45400e-06 1.800 2.45405e-06 0.000 2.45600e-06 0.000 2.45605e-06 1.800 2.45900e-06 1.800
+ 2.45905e-06 0.000 2.46200e-06 0.000 2.46205e-06 1.800 2.46300e-06 1.800 2.46305e-06 0.000 2.46500e-06 0.000
+ 2.46505e-06 1.800 2.46700e-06 1.800 2.46705e-06 0.000 2.47000e-06 0.000 2.47005e-06 1.800 2.47100e-06 1.800
+ 2.47105e-06 0.000 2.47200e-06 0.000 2.47205e-06 1.800 2.47400e-06 1.800 2.47405e-06 0.000 2.47500e-06 0.000
+ 2.47505e-06 1.800 2.47600e-06 1.800 2.47605e-06 0.000 2.48000e-06 0.000 2.48005e-06 1.800 2.48200e-06 1.800
+ 2.48205e-06 0.000 2.48500e-06 0.000 2.48505e-06 1.800 2.48700e-06 1.800 2.48705e-06 0.000 2.49600e-06 0.000
+ 2.49605e-06 1.800 2.49800e-06 1.800 2.49805e-06 0.000 2.49900e-06 0.000 2.49905e-06 1.800 2.50200e-06 1.800
+ 2.50205e-06 0.000 2.50400e-06 0.000 2.50405e-06 1.800 2.50500e-06 1.800 2.50505e-06 0.000 2.50600e-06 0.000
+ 2.50605e-06 1.800 2.50700e-06 1.800 2.50705e-06 0.000 2.50800e-06 0.000 2.50805e-06 1.800 2.51000e-06 1.800
+ 2.51005e-06 0.000 2.51300e-06 0.000 2.51305e-06 1.800 2.51400e-06 1.800 2.51405e-06 0.000 2.51600e-06 0.000
+ 2.51605e-06 1.800 2.51800e-06 1.800 2.51805e-06 0.000 2.52000e-06 0.000 2.52005e-06 1.800 2.52100e-06 1.800
+ 2.52105e-06 0.000 2.52200e-06 0.000 2.52205e-06 1.800 2.52400e-06 1.800 2.52405e-06 0.000 2.52500e-06 0.000
+ 2.52505e-06 1.800 2.53000e-06 1.800 2.53005e-06 0.000 2.53200e-06 0.000 2.53205e-06 1.800 2.53400e-06 1.800
+ 2.53405e-06 0.000 2.53600e-06 0.000 2.53605e-06 1.800 2.53900e-06 1.800 2.53905e-06 0.000 2.54500e-06 0.000
+ 2.54505e-06 1.800 2.54600e-06 1.800 2.54605e-06 0.000 2.54900e-06 0.000 2.54905e-06 1.800 2.55100e-06 1.800
+ 2.55105e-06 0.000 2.55200e-06 0.000 2.55205e-06 1.800 2.55400e-06 1.800 2.55405e-06 0.000 2.55500e-06 0.000
+ 2.55505e-06 1.800 2.56000e-06 1.800 2.56005e-06 0.000 2.56100e-06 0.000 2.56105e-06 1.800 2.56200e-06 1.800
+ 2.56205e-06 0.000 2.56300e-06 0.000 2.56305e-06 1.800 2.56400e-06 1.800 2.56405e-06 0.000 2.56600e-06 0.000
+ 2.56605e-06 1.800 2.56700e-06 1.800 2.56705e-06 0.000 2.56800e-06 0.000 2.56805e-06 1.800 2.57000e-06 1.800
+ 2.57005e-06 0.000 2.57700e-06 0.000 2.57705e-06 1.800 2.57800e-06 1.800 2.57805e-06 0.000 2.57900e-06 0.000
+ 2.57905e-06 1.800 2.58100e-06 1.800 2.58105e-06 0.000 2.58200e-06 0.000 2.58205e-06 1.800 2.58300e-06 1.800
+ 2.58305e-06 0.000 2.58400e-06 0.000 2.58405e-06 1.800 2.58500e-06 1.800 2.58505e-06 0.000 2.58700e-06 0.000
+ 2.58705e-06 1.800 2.58900e-06 1.800 2.58905e-06 0.000 2.59100e-06 0.000 2.59105e-06 1.800 2.59200e-06 1.800
+ 2.59205e-06 0.000 2.59500e-06 0.000 2.59505e-06 1.800 2.59800e-06 1.800 2.59805e-06 0.000 2.59900e-06 0.000
+ 2.59905e-06 1.800 2.60000e-06 1.800 2.60005e-06 0.000 2.60100e-06 0.000 2.60105e-06 1.800 2.60200e-06 1.800
+ 2.60205e-06 0.000 2.60300e-06 0.000 2.60305e-06 1.800 2.60700e-06 1.800 2.60705e-06 0.000 2.61100e-06 0.000
+ 2.61105e-06 1.800 2.61200e-06 1.800 2.61205e-06 0.000 2.61300e-06 0.000 2.61305e-06 1.800 2.61400e-06 1.800
+ 2.61405e-06 0.000 2.61600e-06 0.000 2.61605e-06 1.800 2.61700e-06 1.800 2.61705e-06 0.000 2.61900e-06 0.000
+ 2.61905e-06 1.800 2.62100e-06 1.800 2.62105e-06 0.000 2.62200e-06 0.000 2.62205e-06 1.800 2.62500e-06 1.800
+ 2.62505e-06 0.000 2.62800e-06 0.000 2.62805e-06 1.800 2.62900e-06 1.800 2.62905e-06 0.000 2.63200e-06 0.000
+ 2.63205e-06 1.800 2.63300e-06 1.800 2.63305e-06 0.000 2.63500e-06 0.000 2.63505e-06 1.800 2.63600e-06 1.800
+ 2.63605e-06 0.000 2.63900e-06 0.000 2.63905e-06 1.800 2.64100e-06 1.800 2.64105e-06 0.000 2.64400e-06 0.000
+ 2.64405e-06 1.800 2.64600e-06 1.800 2.64605e-06 0.000 2.64800e-06 0.000 2.64805e-06 1.800 2.64900e-06 1.800
+ 2.64905e-06 0.000 2.65000e-06 0.000 2.65005e-06 1.800 2.65200e-06 1.800 2.65205e-06 0.000 2.65600e-06 0.000
+ 2.65605e-06 1.800 2.65800e-06 1.800 2.65805e-06 0.000 2.65900e-06 0.000 2.65905e-06 1.800 2.66400e-06 1.800
+ 2.66405e-06 0.000 2.66600e-06 0.000 2.66605e-06 1.800 2.66700e-06 1.800 2.66705e-06 0.000 2.66900e-06 0.000
+ 2.66905e-06 1.800 2.67100e-06 1.800 2.67105e-06 0.000 2.67400e-06 0.000 2.67405e-06 1.800 2.67600e-06 1.800
+ 2.67605e-06 0.000 2.67700e-06 0.000 2.67705e-06 1.800 2.67800e-06 1.800 2.67805e-06 0.000 2.68100e-06 0.000
+ 2.68105e-06 1.800 2.68200e-06 1.800 2.68205e-06 0.000 2.68300e-06 0.000 2.68305e-06 1.800 2.68700e-06 1.800
+ 2.68705e-06 0.000 2.68800e-06 0.000 2.68805e-06 1.800 2.69000e-06 1.800 2.69005e-06 0.000 2.69100e-06 0.000
+ 2.69105e-06 1.800 2.69200e-06 1.800 2.69205e-06 0.000 2.69600e-06 0.000 2.69605e-06 1.800 2.69900e-06 1.800
+ 2.69905e-06 0.000 2.70200e-06 0.000 2.70205e-06 1.800 2.70400e-06 1.800 2.70405e-06 0.000 2.70500e-06 0.000
+ 2.70505e-06 1.800 2.70700e-06 1.800 2.70705e-06 0.000 2.70900e-06 0.000 2.70905e-06 1.800 2.71200e-06 1.800
+ 2.71205e-06 0.000 2.71300e-06 0.000 2.71305e-06 1.800 2.71600e-06 1.800 2.71605e-06 0.000 2.71700e-06 0.000
+ 2.71705e-06 1.800 2.71900e-06 1.800 2.71905e-06 0.000 2.72000e-06 0.000 2.72005e-06 1.800 2.72100e-06 1.800
+ 2.72105e-06 0.000 2.72300e-06 0.000 2.72305e-06 1.800 2.72400e-06 1.800 2.72405e-06 0.000 2.72700e-06 0.000
+ 2.72705e-06 1.800 2.72900e-06 1.800 2.72905e-06 0.000 2.73000e-06 0.000 2.73005e-06 1.800 2.73600e-06 1.800
+ 2.73605e-06 0.000 2.73800e-06 0.000 2.73805e-06 1.800 2.74000e-06 1.800 2.74005e-06 0.000 2.74100e-06 0.000
+ 2.74105e-06 1.800 2.74200e-06 1.800 2.74205e-06 0.000 2.74300e-06 0.000 2.74305e-06 1.800 2.74500e-06 1.800
+ 2.74505e-06 0.000 2.74700e-06 0.000 2.74705e-06 1.800 2.74800e-06 1.800 2.74805e-06 0.000 2.74900e-06 0.000
+ 2.74905e-06 1.800 2.75000e-06 1.800 2.75005e-06 0.000 2.75200e-06 0.000 2.75205e-06 1.800 2.75300e-06 1.800
+ 2.75305e-06 0.000 2.75500e-06 0.000 2.75505e-06 1.800 2.75600e-06 1.800 2.75605e-06 0.000 2.75700e-06 0.000
+ 2.75705e-06 1.800 2.75800e-06 1.800 2.75805e-06 0.000 2.75900e-06 0.000 2.75905e-06 1.800 2.76300e-06 1.800
+ 2.76305e-06 0.000 2.76600e-06 0.000 2.76605e-06 1.800 2.76900e-06 1.800 2.76905e-06 0.000 2.77100e-06 0.000
+ 2.77105e-06 1.800 2.77500e-06 1.800 2.77505e-06 0.000 2.77600e-06 0.000 2.77605e-06 1.800 2.77800e-06 1.800
+ 2.77805e-06 0.000 2.77900e-06 0.000 2.77905e-06 1.800 2.78000e-06 1.800 2.78005e-06 0.000 2.78200e-06 0.000
+ 2.78205e-06 1.800 2.78500e-06 1.800 2.78505e-06 0.000 2.78600e-06 0.000 2.78605e-06 1.800 2.78800e-06 1.800
+ 2.78805e-06 0.000 2.78900e-06 0.000 2.78905e-06 1.800 2.79100e-06 1.800 2.79105e-06 0.000 2.79200e-06 0.000
+ 2.79205e-06 1.800 2.79400e-06 1.800 2.79405e-06 0.000 2.79800e-06 0.000 2.79805e-06 1.800 2.79900e-06 1.800
+ 2.79905e-06 0.000 2.80100e-06 0.000 2.80105e-06 1.800 2.80200e-06 1.800 2.80205e-06 0.000 2.80500e-06 0.000
+ 2.80505e-06 1.800 2.80900e-06 1.800 2.80905e-06 0.000 2.81000e-06 0.000 2.81005e-06 1.800 2.81100e-06 1.800
+ 2.81105e-06 0.000 2.81500e-06 0.000 2.81505e-06 1.800 2.81800e-06 1.800 2.81805e-06 0.000 2.82000e-06 0.000
+ 2.82005e-06 1.800 2.82300e-06 1.800 2.82305e-06 0.000 2.82400e-06 0.000 2.82405e-06 1.800 2.82500e-06 1.800
+ 2.82505e-06 0.000 2.82900e-06 0.000 2.82905e-06 1.800 2.83500e-06 1.800 2.83505e-06 0.000 2.83800e-06 0.000
+ 2.83805e-06 1.800 2.84600e-06 1.800 2.84605e-06 0.000 2.85000e-06 0.000 2.85005e-06 1.800 2.85100e-06 1.800
+ 2.85105e-06 0.000 2.85200e-06 0.000 2.85205e-06 1.800 2.85300e-06 1.800 2.85305e-06 0.000 2.85400e-06 0.000
+ 2.85405e-06 1.800 2.85600e-06 1.800 2.85605e-06 0.000 2.85700e-06 0.000 2.85705e-06 1.800 2.86000e-06 1.800
+ 2.86005e-06 0.000 2.86100e-06 0.000 2.86105e-06 1.800 2.86300e-06 1.800 2.86305e-06 0.000 2.86400e-06 0.000
+ 2.86405e-06 1.800 2.86500e-06 1.800 2.86505e-06 0.000 2.86700e-06 0.000 2.86705e-06 1.800 2.87000e-06 1.800
+ 2.87005e-06 0.000 2.87100e-06 0.000 2.87105e-06 1.800 2.87300e-06 1.800 2.87305e-06 0.000 2.87600e-06 0.000
+ 2.87605e-06 1.800 2.87900e-06 1.800 2.87905e-06 0.000 2.88000e-06 0.000 2.88005e-06 1.800 2.88200e-06 1.800
+ 2.88205e-06 0.000 2.88300e-06 0.000 2.88305e-06 1.800 2.88500e-06 1.800 2.88505e-06 0.000 2.88600e-06 0.000
+ 2.88605e-06 1.800 2.88700e-06 1.800 2.88705e-06 0.000 2.88900e-06 0.000 2.88905e-06 1.800 2.89000e-06 1.800
+ 2.89005e-06 0.000 2.89200e-06 0.000 2.89205e-06 1.800 2.89400e-06 1.800 2.89405e-06 0.000 2.89500e-06 0.000
+ 2.89505e-06 1.800 2.89600e-06 1.800 2.89605e-06 0.000 2.89800e-06 0.000 2.89805e-06 1.800 2.90100e-06 1.800
+ 2.90105e-06 0.000 2.90200e-06 0.000 2.90205e-06 1.800 2.90300e-06 1.800 2.90305e-06 0.000 2.90500e-06 0.000
+ 2.90505e-06 1.800 2.90600e-06 1.800 2.90605e-06 0.000 2.91300e-06 0.000 2.91305e-06 1.800 2.91500e-06 1.800
+ 2.91505e-06 0.000 2.92000e-06 0.000 2.92005e-06 1.800 2.92300e-06 1.800 2.92305e-06 0.000 2.92400e-06 0.000
+ 2.92405e-06 1.800 2.92500e-06 1.800 2.92505e-06 0.000 2.92700e-06 0.000 2.92705e-06 1.800 2.92800e-06 1.800
+ 2.92805e-06 0.000 2.92900e-06 0.000 2.92905e-06 1.800 2.93000e-06 1.800 2.93005e-06 0.000 2.93400e-06 0.000
+ 2.93405e-06 1.800 2.93500e-06 1.800 2.93505e-06 0.000 2.93600e-06 0.000 2.93605e-06 1.800 2.93700e-06 1.800
+ 2.93705e-06 0.000 2.93800e-06 0.000 2.93805e-06 1.800 2.94000e-06 1.800 2.94005e-06 0.000 2.94100e-06 0.000
+ 2.94105e-06 1.800 2.94300e-06 1.800 2.94305e-06 0.000 2.94500e-06 0.000 2.94505e-06 1.800 2.94600e-06 1.800
+ 2.94605e-06 0.000 2.94900e-06 0.000 2.94905e-06 1.800 2.95000e-06 1.800 2.95005e-06 0.000 2.95100e-06 0.000
+ 2.95105e-06 1.800 2.95200e-06 1.800 2.95205e-06 0.000 2.95300e-06 0.000 2.95305e-06 1.800 2.95400e-06 1.800
+ 2.95405e-06 0.000 2.95600e-06 0.000 2.95605e-06 1.800 2.95900e-06 1.800 2.95905e-06 0.000 2.96300e-06 0.000
+ 2.96305e-06 1.800 2.96400e-06 1.800 2.96405e-06 0.000 2.97000e-06 0.000 2.97005e-06 1.800 2.97100e-06 1.800
+ 2.97105e-06 0.000 2.98000e-06 0.000 2.98005e-06 1.800 2.98100e-06 1.800 2.98105e-06 0.000 2.98300e-06 0.000
+ 2.98305e-06 1.800 2.98400e-06 1.800 2.98405e-06 0.000 2.98500e-06 0.000 2.98505e-06 1.800 2.98900e-06 1.800
+ 2.98905e-06 0.000 2.99100e-06 0.000 2.99105e-06 1.800 2.99200e-06 1.800 2.99205e-06 0.000 2.99300e-06 0.000
+ 2.99305e-06 1.800 2.99400e-06 1.800 2.99405e-06 0.000 2.99600e-06 0.000 2.99605e-06 1.800 2.99700e-06 1.800
+ 2.99705e-06 0.000 2.99800e-06 0.000 2.99805e-06 1.800 3.00300e-06 1.800 3.00305e-06 0.000 3.00400e-06 0.000
+ 3.00405e-06 1.800 3.00500e-06 1.800 3.00505e-06 0.000 3.00600e-06 0.000 3.00605e-06 1.800 3.01000e-06 1.800
+ 3.01005e-06 0.000 3.01300e-06 0.000 3.01305e-06 1.800 3.01900e-06 1.800 3.01905e-06 0.000 3.02200e-06 0.000
+ 3.02205e-06 1.800 3.02400e-06 1.800 3.02405e-06 0.000 3.02800e-06 0.000 3.02805e-06 1.800 3.02900e-06 1.800
+ 3.02905e-06 0.000 3.03100e-06 0.000 3.03105e-06 1.800 3.03200e-06 1.800 3.03205e-06 0.000 3.03800e-06 0.000
+ 3.03805e-06 1.800 3.03900e-06 1.800 3.03905e-06 0.000 3.04300e-06 0.000 3.04305e-06 1.800 3.04400e-06 1.800
+ 3.04405e-06 0.000 3.04600e-06 0.000 3.04605e-06 1.800 3.04800e-06 1.800 3.04805e-06 0.000 3.04900e-06 0.000
+ 3.04905e-06 1.800 3.05100e-06 1.800 3.05105e-06 0.000 3.05500e-06 0.000 3.05505e-06 1.800 3.05800e-06 1.800
+ 3.05805e-06 0.000 3.06000e-06 0.000 3.06005e-06 1.800 3.06100e-06 1.800 3.06105e-06 0.000 3.06300e-06 0.000
+ 3.06305e-06 1.800 3.06400e-06 1.800 3.06405e-06 0.000 3.06600e-06 0.000 3.06605e-06 1.800 3.06700e-06 1.800
+ 3.06705e-06 0.000 3.06800e-06 0.000 3.06805e-06 1.800 3.06900e-06 1.800 3.06905e-06 0.000 3.07000e-06 0.000
+ 3.07005e-06 1.800 3.07500e-06 1.800 3.07505e-06 0.000 3.07600e-06 0.000 3.07605e-06 1.800 3.07700e-06 1.800
+ 3.07705e-06 0.000 3.07900e-06 0.000 3.07905e-06 1.800 3.08000e-06 1.800 3.08005e-06 0.000 3.08200e-06 0.000
+ 3.08205e-06 1.800 3.08400e-06 1.800 3.08405e-06 0.000 3.08500e-06 0.000 3.08505e-06 1.800 3.08600e-06 1.800
+ 3.08605e-06 0.000 3.08800e-06 0.000 3.08805e-06 1.800 3.09300e-06 1.800 3.09305e-06 0.000 3.09400e-06 0.000
+ 3.09405e-06 1.800 3.09500e-06 1.800 3.09505e-06 0.000 3.09800e-06 0.000 3.09805e-06 1.800 3.10100e-06 1.800
+ 3.10105e-06 0.000 3.10300e-06 0.000 3.10305e-06 1.800 3.11000e-06 1.800 3.11005e-06 0.000 3.11100e-06 0.000
+ 3.11105e-06 1.800 3.11200e-06 1.800 3.11205e-06 0.000 3.11600e-06 0.000 3.11605e-06 1.800 3.11900e-06 1.800
+ 3.11905e-06 0.000 3.12000e-06 0.000 3.12005e-06 1.800 3.12300e-06 1.800 3.12305e-06 0.000 3.12600e-06 0.000
+ 3.12605e-06 1.800 3.13000e-06 1.800 3.13005e-06 0.000 3.13300e-06 0.000 3.13305e-06 1.800 3.13900e-06 1.800
+ 3.13905e-06 0.000 3.14000e-06 0.000 3.14005e-06 1.800 3.14100e-06 1.800 3.14105e-06 0.000 3.14200e-06 0.000
+ 3.14205e-06 1.800 3.14400e-06 1.800 3.14405e-06 0.000 3.14500e-06 0.000 3.14505e-06 1.800 3.14900e-06 1.800
+ 3.14905e-06 0.000 3.15600e-06 0.000 3.15605e-06 1.800 3.15800e-06 1.800 3.15805e-06 0.000 3.15900e-06 0.000
+ 3.15905e-06 1.800 3.16100e-06 1.800 3.16105e-06 0.000 3.16300e-06 0.000 3.16305e-06 1.800 3.16500e-06 1.800
+ 3.16505e-06 0.000 3.16600e-06 0.000 3.16605e-06 1.800 3.16800e-06 1.800 3.16805e-06 0.000 3.17200e-06 0.000
+ 3.17205e-06 1.800 3.17300e-06 1.800 3.17305e-06 0.000 3.17400e-06 0.000 3.17405e-06 1.800 3.17700e-06 1.800
+ 3.17705e-06 0.000 3.17800e-06 0.000 3.17805e-06 1.800 3.18600e-06 1.800 3.18605e-06 0.000 3.18700e-06 0.000
+ 3.18705e-06 1.800 3.18800e-06 1.800 3.18805e-06 0.000 3.19000e-06 0.000 3.19005e-06 1.800 3.19100e-06 1.800
+ 3.19105e-06 0.000 3.19200e-06 0.000 3.19205e-06 1.800 3.19400e-06 1.800 3.19405e-06 0.000 3.20000e-06 0.000
+ 3.20005e-06 1.800 3.20100e-06 1.800 3.20105e-06 0.000 3.20200e-06 0.000 3.20205e-06 1.800 3.20300e-06 1.800
+ 3.20305e-06 0.000 3.20400e-06 0.000 3.20405e-06 1.800 3.20600e-06 1.800 3.20605e-06 0.000 3.20700e-06 0.000
+ 3.20705e-06 1.800 3.20800e-06 1.800 3.20805e-06 0.000 3.20900e-06 0.000 3.20905e-06 1.800 3.21000e-06 1.800
+ 3.21005e-06 0.000 3.21100e-06 0.000 3.21105e-06 1.800 3.21200e-06 1.800 3.21205e-06 0.000 3.21400e-06 0.000
+ 3.21405e-06 1.800 3.21500e-06 1.800 3.21505e-06 0.000 3.21600e-06 0.000 3.21605e-06 1.800 3.21700e-06 1.800
+ 3.21705e-06 0.000 3.21800e-06 0.000 3.21805e-06 1.800 3.21900e-06 1.800 3.21905e-06 0.000 3.22100e-06 0.000
+ 3.22105e-06 1.800 3.22300e-06 1.800 3.22305e-06 0.000 3.22500e-06 0.000 3.22505e-06 1.800 3.22600e-06 1.800
+ 3.22605e-06 0.000 3.22700e-06 0.000 3.22705e-06 1.800 3.22900e-06 1.800 3.22905e-06 0.000 3.23200e-06 0.000
+ 3.23205e-06 1.800 3.23400e-06 1.800 3.23405e-06 0.000 3.23500e-06 0.000 3.23505e-06 1.800 3.23600e-06 1.800
+ 3.23605e-06 0.000 3.23800e-06 0.000 3.23805e-06 1.800 3.24300e-06 1.800 3.24305e-06 0.000 3.24400e-06 0.000
+ 3.24405e-06 1.800 3.24600e-06 1.800 3.24605e-06 0.000 3.24700e-06 0.000 3.24705e-06 1.800 3.24900e-06 1.800
+ 3.24905e-06 0.000 3.25000e-06 0.000 3.25005e-06 1.800 3.25100e-06 1.800 3.25105e-06 0.000 3.25300e-06 0.000
+ 3.25305e-06 1.800 3.25600e-06 1.800 3.25605e-06 0.000 3.25800e-06 0.000 3.25805e-06 1.800 3.26100e-06 1.800
+ 3.26105e-06 0.000 3.26200e-06 0.000 3.26205e-06 1.800 3.26300e-06 1.800 3.26305e-06 0.000 3.26400e-06 0.000
+ 3.26405e-06 1.800 3.26500e-06 1.800 3.26505e-06 0.000 3.26700e-06 0.000 3.26705e-06 1.800 3.26800e-06 1.800
+ 3.26805e-06 0.000 3.27000e-06 0.000 3.27005e-06 1.800 3.27300e-06 1.800 3.27305e-06 0.000 3.27400e-06 0.000
+ 3.27405e-06 1.800 3.27600e-06 1.800 3.27605e-06 0.000 3.27800e-06 0.000 3.27805e-06 1.800 3.27900e-06 1.800
+ 3.27905e-06 0.000 3.28100e-06 0.000 3.28105e-06 1.800 3.28300e-06 1.800 3.28305e-06 0.000 3.28700e-06 0.000
+ 3.28705e-06 1.800 3.28800e-06 1.800 3.28805e-06 0.000 3.29000e-06 0.000 3.29005e-06 1.800 3.29100e-06 1.800
+ 3.29105e-06 0.000 3.29500e-06 0.000 3.29505e-06 1.800 3.29600e-06 1.800 3.29605e-06 0.000 3.29900e-06 0.000
+ 3.29905e-06 1.800 3.30100e-06 1.800 3.30105e-06 0.000 3.30300e-06 0.000 3.30305e-06 1.800 3.30500e-06 1.800
+ 3.30505e-06 0.000 3.30600e-06 0.000 3.30605e-06 1.800 3.30800e-06 1.800 3.30805e-06 0.000 3.30900e-06 0.000
+ 3.30905e-06 1.800 3.31300e-06 1.800 3.31305e-06 0.000 3.31600e-06 0.000 3.31605e-06 1.800 3.31700e-06 1.800
+ 3.31705e-06 0.000 3.31900e-06 0.000 3.31905e-06 1.800 3.32000e-06 1.800 3.32005e-06 0.000 3.32200e-06 0.000
+ 3.32205e-06 1.800 3.32300e-06 1.800 3.32305e-06 0.000 3.32500e-06 0.000 3.32505e-06 1.800 3.32600e-06 1.800
+ 3.32605e-06 0.000 3.33100e-06 0.000 3.33105e-06 1.800 3.33300e-06 1.800 3.33305e-06 0.000 3.33400e-06 0.000
+ 3.33405e-06 1.800 3.33900e-06 1.800 3.33905e-06 0.000 3.34400e-06 0.000 3.34405e-06 1.800 3.34600e-06 1.800
+ 3.34605e-06 0.000 3.34800e-06 0.000 3.34805e-06 1.800 3.35000e-06 1.800 3.35005e-06 0.000 3.35200e-06 0.000
+ 3.35205e-06 1.800 3.35400e-06 1.800 3.35405e-06 0.000 3.35600e-06 0.000 3.35605e-06 1.800 3.35800e-06 1.800
+ 3.35805e-06 0.000 3.36200e-06 0.000 3.36205e-06 1.800 3.36300e-06 1.800 3.36305e-06 0.000 3.36400e-06 0.000
+ 3.36405e-06 1.800 3.36700e-06 1.800 3.36705e-06 0.000 3.36900e-06 0.000 3.36905e-06 1.800 3.37000e-06 1.800
+ 3.37005e-06 0.000 3.37200e-06 0.000 3.37205e-06 1.800 3.37400e-06 1.800 3.37405e-06 0.000 3.38300e-06 0.000
+ 3.38305e-06 1.800 3.38600e-06 1.800 3.38605e-06 0.000 3.38800e-06 0.000 3.38805e-06 1.800 3.39100e-06 1.800
+ 3.39105e-06 0.000 3.39600e-06 0.000 3.39605e-06 1.800 3.39700e-06 1.800 3.39705e-06 0.000 3.39800e-06 0.000
+ 3.39805e-06 1.800 3.39900e-06 1.800 3.39905e-06 0.000 3.40000e-06 0.000 3.40005e-06 1.800 3.40200e-06 1.800
+ 3.40205e-06 0.000 3.40500e-06 0.000 3.40505e-06 1.800 3.40600e-06 1.800 3.40605e-06 0.000 3.40900e-06 0.000
+ 3.40905e-06 1.800 3.41300e-06 1.800 3.41305e-06 0.000 3.41600e-06 0.000 3.41605e-06 1.800 3.41800e-06 1.800
+ 3.41805e-06 0.000 3.41900e-06 0.000 3.41905e-06 1.800 3.42200e-06 1.800 3.42205e-06 0.000 3.42300e-06 0.000
+ 3.42305e-06 1.800 3.42400e-06 1.800 3.42405e-06 0.000 3.42600e-06 0.000 3.42605e-06 1.800 3.42700e-06 1.800
+ 3.42705e-06 0.000 3.42900e-06 0.000 3.42905e-06 1.800 3.43000e-06 1.800 3.43005e-06 0.000 3.43200e-06 0.000
+ 3.43205e-06 1.800 3.43500e-06 1.800 3.43505e-06 0.000 3.43600e-06 0.000 3.43605e-06 1.800 3.43700e-06 1.800
+ 3.43705e-06 0.000 3.44000e-06 0.000 3.44005e-06 1.800 3.44800e-06 1.800 3.44805e-06 0.000 3.44900e-06 0.000
+ 3.44905e-06 1.800 3.45000e-06 1.800 3.45005e-06 0.000 3.45400e-06 0.000 3.45405e-06 1.800 3.45900e-06 1.800
+ 3.45905e-06 0.000 3.46000e-06 0.000 3.46005e-06 1.800 3.46200e-06 1.800 3.46205e-06 0.000 3.46300e-06 0.000
+ 3.46305e-06 1.800 3.46400e-06 1.800 3.46405e-06 0.000 3.46900e-06 0.000 3.46905e-06 1.800 3.47000e-06 1.800
+ 3.47005e-06 0.000 3.47100e-06 0.000 3.47105e-06 1.800 3.47200e-06 1.800 3.47205e-06 0.000 3.47300e-06 0.000
+ 3.47305e-06 1.800 3.47500e-06 1.800 3.47505e-06 0.000 3.47600e-06 0.000 3.47605e-06 1.800 3.47700e-06 1.800
+ 3.47705e-06 0.000 3.47800e-06 0.000 3.47805e-06 1.800 3.48100e-06 1.800 3.48105e-06 0.000 3.48300e-06 0.000
+ 3.48305e-06 1.800 3.48600e-06 1.800 3.48605e-06 0.000 3.48700e-06 0.000 3.48705e-06 1.800 3.48800e-06 1.800
+ 3.48805e-06 0.000 3.49100e-06 0.000 3.49105e-06 1.800 3.49300e-06 1.800 3.49305e-06 0.000 3.49500e-06 0.000
+ 3.49505e-06 1.800 3.49700e-06 1.800 3.49705e-06 0.000 3.49800e-06 0.000 3.49805e-06 1.800 3.50000e-06 1.800
+ 3.50005e-06 0.000 3.50200e-06 0.000 3.50205e-06 1.800 3.50400e-06 1.800 3.50405e-06 0.000 3.50900e-06 0.000
+ 3.50905e-06 1.800 3.51100e-06 1.800 3.51105e-06 0.000 3.51200e-06 0.000 3.51205e-06 1.800 3.51600e-06 1.800
+ 3.51605e-06 0.000 3.51900e-06 0.000 3.51905e-06 1.800 3.52500e-06 1.800 3.52505e-06 0.000 3.52800e-06 0.000
+ 3.52805e-06 1.800 3.52900e-06 1.800 3.52905e-06 0.000 3.53200e-06 0.000 3.53205e-06 1.800 3.53300e-06 1.800
+ 3.53305e-06 0.000 3.53400e-06 0.000 3.53405e-06 1.800 3.53800e-06 1.800 3.53805e-06 0.000 3.54000e-06 0.000
+ 3.54005e-06 1.800 3.54100e-06 1.800 3.54105e-06 0.000 3.54200e-06 0.000 3.54205e-06 1.800 3.54300e-06 1.800
+ 3.54305e-06 0.000 3.54500e-06 0.000 3.54505e-06 1.800 3.55200e-06 1.800 3.55205e-06 0.000 3.55600e-06 0.000
+ 3.55605e-06 1.800 3.56000e-06 1.800 3.56005e-06 0.000 3.56100e-06 0.000 3.56105e-06 1.800 3.56800e-06 1.800
+ 3.56805e-06 0.000 3.57200e-06 0.000 3.57205e-06 1.800 3.57500e-06 1.800 3.57505e-06 0.000 3.57600e-06 0.000
+ 3.57605e-06 1.800 3.58100e-06 1.800 3.58105e-06 0.000 3.58300e-06 0.000 3.58305e-06 1.800 3.58600e-06 1.800
+ 3.58605e-06 0.000 3.58700e-06 0.000 3.58705e-06 1.800 3.58800e-06 1.800 3.58805e-06 0.000 3.59100e-06 0.000
+ 3.59105e-06 1.800 3.59500e-06 1.800 3.59505e-06 0.000 3.59600e-06 0.000 3.59605e-06 1.800 3.60400e-06 1.800
+ 3.60405e-06 0.000 3.60700e-06 0.000 3.60705e-06 1.800 3.60900e-06 1.800 3.60905e-06 0.000 3.61200e-06 0.000
+ 3.61205e-06 1.800 3.61600e-06 1.800 3.61605e-06 0.000 3.61700e-06 0.000 3.61705e-06 1.800 3.61800e-06 1.800
+ 3.61805e-06 0.000 3.61900e-06 0.000 3.61905e-06 1.800 3.62000e-06 1.800 3.62005e-06 0.000 3.62200e-06 0.000
+ 3.62205e-06 1.800 3.62400e-06 1.800 3.62405e-06 0.000 3.62500e-06 0.000 3.62505e-06 1.800 3.62700e-06 1.800
+ 3.62705e-06 0.000 3.63000e-06 0.000 3.63005e-06 1.800 3.63200e-06 1.800 3.63205e-06 0.000 3.63400e-06 0.000
+ 3.63405e-06 1.800 3.63800e-06 1.800 3.63805e-06 0.000 3.64500e-06 0.000 3.64505e-06 1.800 3.64900e-06 1.800
+ 3.64905e-06 0.000 3.65200e-06 0.000 3.65205e-06 1.800 3.65600e-06 1.800 3.65605e-06 0.000 3.65700e-06 0.000
+ 3.65705e-06 1.800 3.65800e-06 1.800 3.65805e-06 0.000 3.66500e-06 0.000 3.66505e-06 1.800 3.66900e-06 1.800
+ 3.66905e-06 0.000 3.67000e-06 0.000 3.67005e-06 1.800 3.67500e-06 1.800 3.67505e-06 0.000 3.67900e-06 0.000
+ 3.67905e-06 1.800 3.68100e-06 1.800 3.68105e-06 0.000 3.68400e-06 0.000 3.68405e-06 1.800 3.68600e-06 1.800
+ 3.68605e-06 0.000 3.68700e-06 0.000 3.68705e-06 1.800 3.69000e-06 1.800 3.69005e-06 0.000 3.69300e-06 0.000
+ 3.69305e-06 1.800 3.69400e-06 1.800 3.69405e-06 0.000 3.69500e-06 0.000 3.69505e-06 1.800 3.69600e-06 1.800
+ 3.69605e-06 0.000 3.69800e-06 0.000 3.69805e-06 1.800 3.70300e-06 1.800 3.70305e-06 0.000 3.70400e-06 0.000
+ 3.70405e-06 1.800 3.70600e-06 1.800 3.70605e-06 0.000 3.70800e-06 0.000 3.70805e-06 1.800 3.70900e-06 1.800
+ 3.70905e-06 0.000 3.71300e-06 0.000 3.71305e-06 1.800 3.71500e-06 1.800 3.71505e-06 0.000 3.71700e-06 0.000
+ 3.71705e-06 1.800 3.72100e-06 1.800 3.72105e-06 0.000 3.72400e-06 0.000 3.72405e-06 1.800 3.73000e-06 1.800
+ 3.73005e-06 0.000 3.73100e-06 0.000 3.73105e-06 1.800 3.73400e-06 1.800 3.73405e-06 0.000 3.73500e-06 0.000
+ 3.73505e-06 1.800 3.73600e-06 1.800 3.73605e-06 0.000 3.73800e-06 0.000 3.73805e-06 1.800 3.74100e-06 1.800
+ 3.74105e-06 0.000 3.74500e-06 0.000 3.74505e-06 1.800 3.75100e-06 1.800 3.75105e-06 0.000 3.75600e-06 0.000
+ 3.75605e-06 1.800 3.75800e-06 1.800 3.75805e-06 0.000 3.75900e-06 0.000 3.75905e-06 1.800 3.76000e-06 1.800
+ 3.76005e-06 0.000 3.76200e-06 0.000 3.76205e-06 1.800 3.76300e-06 1.800 3.76305e-06 0.000 3.76400e-06 0.000
+ 3.76405e-06 1.800 3.76700e-06 1.800 3.76705e-06 0.000 3.76900e-06 0.000 3.76905e-06 1.800 3.77000e-06 1.800
+ 3.77005e-06 0.000 3.77100e-06 0.000 3.77105e-06 1.800 3.77400e-06 1.800 3.77405e-06 0.000 3.77500e-06 0.000
+ 3.77505e-06 1.800 3.78000e-06 1.800 3.78005e-06 0.000 3.78100e-06 0.000 3.78105e-06 1.800 3.78200e-06 1.800
+ 3.78205e-06 0.000 3.78500e-06 0.000 3.78505e-06 1.800 3.78600e-06 1.800 3.78605e-06 0.000 3.78900e-06 0.000
+ 3.78905e-06 1.800 3.79000e-06 1.800 3.79005e-06 0.000 3.79300e-06 0.000 3.79305e-06 1.800 3.79500e-06 1.800
+ 3.79505e-06 0.000 3.79900e-06 0.000 3.79905e-06 1.800 3.80000e-06 1.800 3.80005e-06 0.000 3.80200e-06 0.000
+ 3.80205e-06 1.800 3.80300e-06 1.800 3.80305e-06 0.000 3.80700e-06 0.000 3.80705e-06 1.800 3.80800e-06 1.800
+ 3.80805e-06 0.000 3.80900e-06 0.000 3.80905e-06 1.800 3.81500e-06 1.800 3.81505e-06 0.000 3.81600e-06 0.000
+ 3.81605e-06 1.800 3.81700e-06 1.800 3.81705e-06 0.000 3.81800e-06 0.000 3.81805e-06 1.800 3.81900e-06 1.800
+ 3.81905e-06 0.000 3.82100e-06 0.000 3.82105e-06 1.800 3.82500e-06 1.800 3.82505e-06 0.000 3.82600e-06 0.000
+ 3.82605e-06 1.800 3.83500e-06 1.800 3.83505e-06 0.000 3.83600e-06 0.000 3.83605e-06 1.800 3.83800e-06 1.800
+ 3.83805e-06 0.000 3.84000e-06 0.000 3.84005e-06 1.800 3.84100e-06 1.800 3.84105e-06 0.000 3.84200e-06 0.000
+ 3.84205e-06 1.800 3.84300e-06 1.800 3.84305e-06 0.000 3.84500e-06 0.000 3.84505e-06 1.800 3.85100e-06 1.800
+ 3.85105e-06 0.000 3.85300e-06 0.000 3.85305e-06 1.800 3.85400e-06 1.800 3.85405e-06 0.000 3.85500e-06 0.000
+ 3.85505e-06 1.800 3.85700e-06 1.800 3.85705e-06 0.000 3.85900e-06 0.000 3.85905e-06 1.800 3.86200e-06 1.800
+ 3.86205e-06 0.000 3.86300e-06 0.000 3.86305e-06 1.800 3.86500e-06 1.800 3.86505e-06 0.000 3.86700e-06 0.000
+ 3.86705e-06 1.800 3.86800e-06 1.800 3.86805e-06 0.000 3.87400e-06 0.000 3.87405e-06 1.800 3.87500e-06 1.800
+ 3.87505e-06 0.000 3.87600e-06 0.000 3.87605e-06 1.800 3.87700e-06 1.800 3.87705e-06 0.000 3.87900e-06 0.000
+ 3.87905e-06 1.800 3.88000e-06 1.800 3.88005e-06 0.000 3.88100e-06 0.000 3.88105e-06 1.800 3.88200e-06 1.800
+ 3.88205e-06 0.000 3.88300e-06 0.000 3.88305e-06 1.800 3.88400e-06 1.800 3.88405e-06 0.000 3.88500e-06 0.000
+ 3.88505e-06 1.800 3.88700e-06 1.800 3.88705e-06 0.000 3.89200e-06 0.000 3.89205e-06 1.800 3.89400e-06 1.800
+ 3.89405e-06 0.000 3.89500e-06 0.000 3.89505e-06 1.800 3.89600e-06 1.800 3.89605e-06 0.000 3.89700e-06 0.000
+ 3.89705e-06 1.800 3.89900e-06 1.800 3.89905e-06 0.000 3.90000e-06 0.000 3.90005e-06 1.800 3.90100e-06 1.800
+ 3.90105e-06 0.000 3.90300e-06 0.000 3.90305e-06 1.800 3.90400e-06 1.800 3.90405e-06 0.000 3.90500e-06 0.000
+ 3.90505e-06 1.800 3.90900e-06 1.800 3.90905e-06 0.000 3.91200e-06 0.000 3.91205e-06 1.800 3.91300e-06 1.800
+ 3.91305e-06 0.000 3.92000e-06 0.000 3.92005e-06 1.800 3.92200e-06 1.800 3.92205e-06 0.000 3.92600e-06 0.000
+ 3.92605e-06 1.800 3.92700e-06 1.800 3.92705e-06 0.000 3.92800e-06 0.000 3.92805e-06 1.800 3.93000e-06 1.800
+ 3.93005e-06 0.000 3.93200e-06 0.000 3.93205e-06 1.800 3.93300e-06 1.800 3.93305e-06 0.000 3.93400e-06 0.000
+ 3.93405e-06 1.800 3.93600e-06 1.800 3.93605e-06 0.000 3.94000e-06 0.000 3.94005e-06 1.800 3.94100e-06 1.800
+ 3.94105e-06 0.000 3.94200e-06 0.000 3.94205e-06 1.800 3.94400e-06 1.800 3.94405e-06 0.000 3.94500e-06 0.000
+ 3.94505e-06 1.800 3.94700e-06 1.800 3.94705e-06 0.000 3.94800e-06 0.000 3.94805e-06 1.800 3.94900e-06 1.800
+ 3.94905e-06 0.000 3.95400e-06 0.000 3.95405e-06 1.800 3.95800e-06 1.800 3.95805e-06 0.000 3.95900e-06 0.000
+ 3.95905e-06 1.800 3.96100e-06 1.800 3.96105e-06 0.000 3.96400e-06 0.000 3.96405e-06 1.800 3.96500e-06 1.800
+ 3.96505e-06 0.000 3.96600e-06 0.000 3.96605e-06 1.800 3.96700e-06 1.800 3.96705e-06 0.000 3.96900e-06 0.000
+ 3.96905e-06 1.800 3.97200e-06 1.800 3.97205e-06 0.000 3.97800e-06 0.000 3.97805e-06 1.800 3.98000e-06 1.800
+ 3.98005e-06 0.000 3.98100e-06 0.000 3.98105e-06 1.800 3.98300e-06 1.800 3.98305e-06 0.000 3.98500e-06 0.000
+ 3.98505e-06 1.800 3.98800e-06 1.800 3.98805e-06 0.000 3.99000e-06 0.000 3.99005e-06 1.800 3.99100e-06 1.800
+ 3.99105e-06 0.000 3.99400e-06 0.000 3.99405e-06 1.800 3.99500e-06 1.800 3.99505e-06 0.000 3.99700e-06 0.000
+ 3.99705e-06 1.800 4.00000e-06 1.800 4.00005e-06 0.000 4.01000e-06 0.000 4.01005e-06 1.800 4.01100e-06 1.800
+ 4.01105e-06 0.000 4.01200e-06 0.000 4.01205e-06 1.800 4.01400e-06 1.800 4.01405e-06 0.000 4.01700e-06 0.000
+ 4.01705e-06 1.800 4.01900e-06 1.800 4.01905e-06 0.000 4.02400e-06 0.000 4.02405e-06 1.800 4.02600e-06 1.800
+ 4.02605e-06 0.000 4.02700e-06 0.000 4.02705e-06 1.800 4.02800e-06 1.800 4.02805e-06 0.000 4.02900e-06 0.000
+ 4.02905e-06 1.800 4.03000e-06 1.800 4.03005e-06 0.000 4.03100e-06 0.000 4.03105e-06 1.800 4.03200e-06 1.800
+ 4.03205e-06 0.000 4.03300e-06 0.000 4.03305e-06 1.800 4.03600e-06 1.800 4.03605e-06 0.000 4.03700e-06 0.000
+ 4.03705e-06 1.800 4.03800e-06 1.800 4.03805e-06 0.000 4.03900e-06 0.000 4.03905e-06 1.800 4.04000e-06 1.800
+ 4.04005e-06 0.000 4.04100e-06 0.000 4.04105e-06 1.800 4.04200e-06 1.800 4.04205e-06 0.000 4.04300e-06 0.000
+ 4.04305e-06 1.800 4.04400e-06 1.800 4.04405e-06 0.000 4.04500e-06 0.000 4.04505e-06 1.800 4.04600e-06 1.800
+ 4.04605e-06 0.000 4.04700e-06 0.000 4.04705e-06 1.800 4.04800e-06 1.800 4.04805e-06 0.000 4.04900e-06 0.000
+ 4.04905e-06 1.800 4.05000e-06 1.800 4.05005e-06 0.000 4.05200e-06 0.000 4.05205e-06 1.800 4.05300e-06 1.800
+ 4.05305e-06 0.000 4.05500e-06 0.000 4.05505e-06 1.800 4.05900e-06 1.800 4.05905e-06 0.000 4.06000e-06 0.000
+ 4.06005e-06 1.800 4.06100e-06 1.800 4.06105e-06 0.000 4.06300e-06 0.000 4.06305e-06 1.800 4.06400e-06 1.800
+ 4.06405e-06 0.000 4.06600e-06 0.000 4.06605e-06 1.800 4.06800e-06 1.800 4.06805e-06 0.000 4.06900e-06 0.000
+ 4.06905e-06 1.800 4.07000e-06 1.800 4.07005e-06 0.000 4.07300e-06 0.000 4.07305e-06 1.800 4.07500e-06 1.800
+ 4.07505e-06 0.000 4.07700e-06 0.000 4.07705e-06 1.800 4.08100e-06 1.800 4.08105e-06 0.000 4.08200e-06 0.000
+ 4.08205e-06 1.800 4.08300e-06 1.800 4.08305e-06 0.000 4.08400e-06 0.000 4.08405e-06 1.800 4.08600e-06 1.800
+ 4.08605e-06 0.000 4.08700e-06 0.000 4.08705e-06 1.800 4.09100e-06 1.800 4.09105e-06 0.000 4.09500e-06 0.000
+ 4.09505e-06 1.800 4.09600e-06 1.800
+ )
Xd_g0b src_g0b g0b vdd gnd tb_inv
Vt0b src_t0b gnd PWL(
+ 0.00000e+00 1.800 5.12000e-07 1.800 5.12050e-07 0.000 1.02400e-06 0.000 1.02405e-06 1.800 1.53600e-06 1.800
+ 1.53605e-06 0.000 2.05000e-06 0.000 2.05005e-06 1.800 2.05100e-06 1.800 2.05105e-06 0.000 2.05200e-06 0.000
+ 2.05205e-06 1.800 2.05500e-06 1.800 2.05505e-06 0.000 2.05800e-06 0.000 2.05805e-06 1.800 2.06500e-06 1.800
+ 2.06505e-06 0.000 2.06600e-06 0.000 2.06605e-06 1.800 2.06700e-06 1.800 2.06705e-06 0.000 2.07000e-06 0.000
+ 2.07005e-06 1.800 2.07100e-06 1.800 2.07105e-06 0.000 2.07300e-06 0.000 2.07305e-06 1.800 2.07400e-06 1.800
+ 2.07405e-06 0.000 2.07600e-06 0.000 2.07605e-06 1.800 2.07900e-06 1.800 2.07905e-06 0.000 2.08000e-06 0.000
+ 2.08005e-06 1.800 2.08300e-06 1.800 2.08305e-06 0.000 2.08400e-06 0.000 2.08405e-06 1.800 2.08600e-06 1.800
+ 2.08605e-06 0.000 2.08700e-06 0.000 2.08705e-06 1.800 2.08800e-06 1.800 2.08805e-06 0.000 2.09000e-06 0.000
+ 2.09005e-06 1.800 2.09100e-06 1.800 2.09105e-06 0.000 2.09200e-06 0.000 2.09205e-06 1.800 2.09300e-06 1.800
+ 2.09305e-06 0.000 2.09600e-06 0.000 2.09605e-06 1.800 2.09700e-06 1.800 2.09705e-06 0.000 2.09800e-06 0.000
+ 2.09805e-06 1.800 2.09900e-06 1.800 2.09905e-06 0.000 2.10000e-06 0.000 2.10005e-06 1.800 2.10200e-06 1.800
+ 2.10205e-06 0.000 2.10600e-06 0.000 2.10605e-06 1.800 2.10800e-06 1.800 2.10805e-06 0.000 2.10900e-06 0.000
+ 2.10905e-06 1.800 2.11000e-06 1.800 2.11005e-06 0.000 2.11200e-06 0.000 2.11205e-06 1.800 2.11300e-06 1.800
+ 2.11305e-06 0.000 2.11600e-06 0.000 2.11605e-06 1.800 2.11800e-06 1.800 2.11805e-06 0.000 2.11900e-06 0.000
+ 2.11905e-06 1.800 2.12400e-06 1.800 2.12405e-06 0.000 2.12600e-06 0.000 2.12605e-06 1.800 2.12800e-06 1.800
+ 2.12805e-06 0.000 2.13000e-06 0.000 2.13005e-06 1.800 2.13100e-06 1.800 2.13105e-06 0.000 2.13200e-06 0.000
+ 2.13205e-06 1.800 2.13300e-06 1.800 2.13305e-06 0.000 2.13400e-06 0.000 2.13405e-06 1.800 2.13600e-06 1.800
+ 2.13605e-06 0.000 2.13800e-06 0.000 2.13805e-06 1.800 2.13900e-06 1.800 2.13905e-06 0.000 2.14000e-06 0.000
+ 2.14005e-06 1.800 2.14100e-06 1.800 2.14105e-06 0.000 2.14500e-06 0.000 2.14505e-06 1.800 2.14600e-06 1.800
+ 2.14605e-06 0.000 2.14800e-06 0.000 2.14805e-06 1.800 2.14900e-06 1.800 2.14905e-06 0.000 2.15000e-06 0.000
+ 2.15005e-06 1.800 2.15100e-06 1.800 2.15105e-06 0.000 2.15500e-06 0.000 2.15505e-06 1.800 2.15600e-06 1.800
+ 2.15605e-06 0.000 2.15700e-06 0.000 2.15705e-06 1.800 2.15900e-06 1.800 2.15905e-06 0.000 2.16000e-06 0.000
+ 2.16005e-06 1.800 2.16300e-06 1.800 2.16305e-06 0.000 2.16500e-06 0.000 2.16505e-06 1.800 2.16600e-06 1.800
+ 2.16605e-06 0.000 2.16800e-06 0.000 2.16805e-06 1.800 2.16900e-06 1.800 2.16905e-06 0.000 2.17100e-06 0.000
+ 2.17105e-06 1.800 2.17400e-06 1.800 2.17405e-06 0.000 2.17500e-06 0.000 2.17505e-06 1.800 2.17800e-06 1.800
+ 2.17805e-06 0.000 2.17900e-06 0.000 2.17905e-06 1.800 2.18300e-06 1.800 2.18305e-06 0.000 2.18500e-06 0.000
+ 2.18505e-06 1.800 2.18700e-06 1.800 2.18705e-06 0.000 2.18800e-06 0.000 2.18805e-06 1.800 2.19100e-06 1.800
+ 2.19105e-06 0.000 2.19300e-06 0.000 2.19305e-06 1.800 2.19400e-06 1.800 2.19405e-06 0.000 2.19500e-06 0.000
+ 2.19505e-06 1.800 2.19800e-06 1.800 2.19805e-06 0.000 2.19900e-06 0.000 2.19905e-06 1.800 2.20000e-06 1.800
+ 2.20005e-06 0.000 2.20300e-06 0.000 2.20305e-06 1.800 2.20400e-06 1.800 2.20405e-06 0.000 2.20500e-06 0.000
+ 2.20505e-06 1.800 2.21000e-06 1.800 2.21005e-06 0.000 2.21200e-06 0.000 2.21205e-06 1.800 2.21300e-06 1.800
+ 2.21305e-06 0.000 2.21700e-06 0.000 2.21705e-06 1.800 2.21800e-06 1.800 2.21805e-06 0.000 2.21900e-06 0.000
+ 2.21905e-06 1.800 2.22000e-06 1.800 2.22005e-06 0.000 2.22200e-06 0.000 2.22205e-06 1.800 2.22600e-06 1.800
+ 2.22605e-06 0.000 2.23200e-06 0.000 2.23205e-06 1.800 2.23500e-06 1.800 2.23505e-06 0.000 2.23700e-06 0.000
+ 2.23705e-06 1.800 2.24200e-06 1.800 2.24205e-06 0.000 2.24600e-06 0.000 2.24605e-06 1.800 2.24700e-06 1.800
+ 2.24705e-06 0.000 2.25000e-06 0.000 2.25005e-06 1.800 2.25100e-06 1.800 2.25105e-06 0.000 2.25300e-06 0.000
+ 2.25305e-06 1.800 2.25400e-06 1.800 2.25405e-06 0.000 2.25500e-06 0.000 2.25505e-06 1.800 2.25800e-06 1.800
+ 2.25805e-06 0.000 2.26100e-06 0.000 2.26105e-06 1.800 2.26200e-06 1.800 2.26205e-06 0.000 2.26500e-06 0.000
+ 2.26505e-06 1.800 2.26700e-06 1.800 2.26705e-06 0.000 2.26900e-06 0.000 2.26905e-06 1.800 2.27000e-06 1.800
+ 2.27005e-06 0.000 2.27300e-06 0.000 2.27305e-06 1.800 2.27500e-06 1.800 2.27505e-06 0.000 2.27600e-06 0.000
+ 2.27605e-06 1.800 2.27700e-06 1.800 2.27705e-06 0.000 2.28000e-06 0.000 2.28005e-06 1.800 2.28100e-06 1.800
+ 2.28105e-06 0.000 2.28200e-06 0.000 2.28205e-06 1.800 2.28600e-06 1.800 2.28605e-06 0.000 2.28800e-06 0.000
+ 2.28805e-06 1.800 2.29100e-06 1.800 2.29105e-06 0.000 2.29200e-06 0.000 2.29205e-06 1.800 2.29300e-06 1.800
+ 2.29305e-06 0.000 2.29900e-06 0.000 2.29905e-06 1.800 2.30000e-06 1.800 2.30005e-06 0.000 2.30200e-06 0.000
+ 2.30205e-06 1.800 2.30300e-06 1.800 2.30305e-06 0.000 2.30400e-06 0.000 2.30405e-06 1.800 2.30500e-06 1.800
+ 2.30505e-06 0.000 2.30700e-06 0.000 2.30705e-06 1.800 2.30900e-06 1.800 2.30905e-06 0.000 2.31000e-06 0.000
+ 2.31005e-06 1.800 2.31400e-06 1.800 2.31405e-06 0.000 2.31800e-06 0.000 2.31805e-06 1.800 2.32100e-06 1.800
+ 2.32105e-06 0.000 2.32300e-06 0.000 2.32305e-06 1.800 2.32400e-06 1.800 2.32405e-06 0.000 2.32600e-06 0.000
+ 2.32605e-06 1.800 2.32800e-06 1.800 2.32805e-06 0.000 2.32900e-06 0.000 2.32905e-06 1.800 2.33000e-06 1.800
+ 2.33005e-06 0.000 2.33100e-06 0.000 2.33105e-06 1.800 2.33300e-06 1.800 2.33305e-06 0.000 2.33500e-06 0.000
+ 2.33505e-06 1.800 2.34100e-06 1.800 2.34105e-06 0.000 2.34200e-06 0.000 2.34205e-06 1.800 2.34300e-06 1.800
+ 2.34305e-06 0.000 2.34400e-06 0.000 2.34405e-06 1.800 2.34500e-06 1.800 2.34505e-06 0.000 2.34700e-06 0.000
+ 2.34705e-06 1.800 2.34900e-06 1.800 2.34905e-06 0.000 2.35000e-06 0.000 2.35005e-06 1.800 2.35100e-06 1.800
+ 2.35105e-06 0.000 2.35200e-06 0.000 2.35205e-06 1.800 2.35400e-06 1.800 2.35405e-06 0.000 2.35600e-06 0.000
+ 2.35605e-06 1.800 2.35700e-06 1.800 2.35705e-06 0.000 2.35900e-06 0.000 2.35905e-06 1.800 2.36000e-06 1.800
+ 2.36005e-06 0.000 2.36100e-06 0.000 2.36105e-06 1.800 2.36400e-06 1.800 2.36405e-06 0.000 2.36600e-06 0.000
+ 2.36605e-06 1.800 2.36700e-06 1.800 2.36705e-06 0.000 2.37400e-06 0.000 2.37405e-06 1.800 2.37600e-06 1.800
+ 2.37605e-06 0.000 2.37800e-06 0.000 2.37805e-06 1.800 2.38300e-06 1.800 2.38305e-06 0.000 2.38400e-06 0.000
+ 2.38405e-06 1.800 2.38500e-06 1.800 2.38505e-06 0.000 2.38700e-06 0.000 2.38705e-06 1.800 2.38900e-06 1.800
+ 2.38905e-06 0.000 2.39000e-06 0.000 2.39005e-06 1.800 2.39100e-06 1.800 2.39105e-06 0.000 2.39200e-06 0.000
+ 2.39205e-06 1.800 2.39400e-06 1.800 2.39405e-06 0.000 2.39800e-06 0.000 2.39805e-06 1.800 2.40100e-06 1.800
+ 2.40105e-06 0.000 2.40300e-06 0.000 2.40305e-06 1.800 2.40600e-06 1.800 2.40605e-06 0.000 2.40900e-06 0.000
+ 2.40905e-06 1.800 2.41000e-06 1.800 2.41005e-06 0.000 2.41200e-06 0.000 2.41205e-06 1.800 2.41300e-06 1.800
+ 2.41305e-06 0.000 2.41400e-06 0.000 2.41405e-06 1.800 2.41500e-06 1.800 2.41505e-06 0.000 2.42000e-06 0.000
+ 2.42005e-06 1.800 2.42100e-06 1.800 2.42105e-06 0.000 2.42200e-06 0.000 2.42205e-06 1.800 2.42300e-06 1.800
+ 2.42305e-06 0.000 2.42500e-06 0.000 2.42505e-06 1.800 2.42600e-06 1.800 2.42605e-06 0.000 2.42700e-06 0.000
+ 2.42705e-06 1.800 2.43100e-06 1.800 2.43105e-06 0.000 2.43400e-06 0.000 2.43405e-06 1.800 2.44200e-06 1.800
+ 2.44205e-06 0.000 2.44300e-06 0.000 2.44305e-06 1.800 2.44800e-06 1.800 2.44805e-06 0.000 2.44900e-06 0.000
+ 2.44905e-06 1.800 2.45100e-06 1.800 2.45105e-06 0.000 2.45300e-06 0.000 2.45305e-06 1.800 2.45600e-06 1.800
+ 2.45605e-06 0.000 2.45700e-06 0.000 2.45705e-06 1.800 2.45900e-06 1.800 2.45905e-06 0.000 2.46100e-06 0.000
+ 2.46105e-06 1.800 2.46200e-06 1.800 2.46205e-06 0.000 2.46600e-06 0.000 2.46605e-06 1.800 2.46700e-06 1.800
+ 2.46705e-06 0.000 2.47200e-06 0.000 2.47205e-06 1.800 2.47300e-06 1.800 2.47305e-06 0.000 2.47400e-06 0.000
+ 2.47405e-06 1.800 2.47500e-06 1.800 2.47505e-06 0.000 2.47600e-06 0.000 2.47605e-06 1.800 2.47700e-06 1.800
+ 2.47705e-06 0.000 2.47800e-06 0.000 2.47805e-06 1.800 2.47900e-06 1.800 2.47905e-06 0.000 2.48100e-06 0.000
+ 2.48105e-06 1.800 2.48200e-06 1.800 2.48205e-06 0.000 2.48500e-06 0.000 2.48505e-06 1.800 2.48600e-06 1.800
+ 2.48605e-06 0.000 2.48700e-06 0.000 2.48705e-06 1.800 2.48800e-06 1.800 2.48805e-06 0.000 2.48900e-06 0.000
+ 2.48905e-06 1.800 2.49000e-06 1.800 2.49005e-06 0.000 2.49500e-06 0.000 2.49505e-06 1.800 2.49600e-06 1.800
+ 2.49605e-06 0.000 2.49800e-06 0.000 2.49805e-06 1.800 2.49900e-06 1.800 2.49905e-06 0.000 2.50200e-06 0.000
+ 2.50205e-06 1.800 2.50300e-06 1.800 2.50305e-06 0.000 2.50500e-06 0.000 2.50505e-06 1.800 2.50800e-06 1.800
+ 2.50805e-06 0.000 2.50900e-06 0.000 2.50905e-06 1.800 2.51100e-06 1.800 2.51105e-06 0.000 2.51200e-06 0.000
+ 2.51205e-06 1.800 2.51400e-06 1.800 2.51405e-06 0.000 2.51500e-06 0.000 2.51505e-06 1.800 2.51700e-06 1.800
+ 2.51705e-06 0.000 2.51800e-06 0.000 2.51805e-06 1.800 2.52000e-06 1.800 2.52005e-06 0.000 2.52100e-06 0.000
+ 2.52105e-06 1.800 2.52300e-06 1.800 2.52305e-06 0.000 2.52900e-06 0.000 2.52905e-06 1.800 2.53000e-06 1.800
+ 2.53005e-06 0.000 2.53200e-06 0.000 2.53205e-06 1.800 2.53400e-06 1.800 2.53405e-06 0.000 2.53500e-06 0.000
+ 2.53505e-06 1.800 2.53700e-06 1.800 2.53705e-06 0.000 2.53900e-06 0.000 2.53905e-06 1.800 2.54100e-06 1.800
+ 2.54105e-06 0.000 2.54200e-06 0.000 2.54205e-06 1.800 2.54300e-06 1.800 2.54305e-06 0.000 2.54500e-06 0.000
+ 2.54505e-06 1.800 2.55000e-06 1.800 2.55005e-06 0.000 2.55100e-06 0.000 2.55105e-06 1.800 2.55200e-06 1.800
+ 2.55205e-06 0.000 2.55600e-06 0.000 2.55605e-06 1.800 2.55700e-06 1.800 2.55705e-06 0.000 2.55800e-06 0.000
+ 2.55805e-06 1.800 2.56000e-06 1.800 2.56005e-06 0.000 2.56100e-06 0.000 2.56105e-06 1.800 2.56400e-06 1.800
+ 2.56405e-06 0.000 2.56800e-06 0.000 2.56805e-06 1.800 2.56900e-06 1.800 2.56905e-06 0.000 2.57000e-06 0.000
+ 2.57005e-06 1.800 2.57200e-06 1.800 2.57205e-06 0.000 2.57800e-06 0.000 2.57805e-06 1.800 2.57900e-06 1.800
+ 2.57905e-06 0.000 2.58000e-06 0.000 2.58005e-06 1.800 2.58400e-06 1.800 2.58405e-06 0.000 2.58500e-06 0.000
+ 2.58505e-06 1.800 2.58800e-06 1.800 2.58805e-06 0.000 2.58900e-06 0.000 2.58905e-06 1.800 2.59100e-06 1.800
+ 2.59105e-06 0.000 2.59300e-06 0.000 2.59305e-06 1.800 2.59400e-06 1.800 2.59405e-06 0.000 2.59700e-06 0.000
+ 2.59705e-06 1.800 2.59900e-06 1.800 2.59905e-06 0.000 2.60000e-06 0.000 2.60005e-06 1.800 2.60200e-06 1.800
+ 2.60205e-06 0.000 2.60300e-06 0.000 2.60305e-06 1.800 2.60500e-06 1.800 2.60505e-06 0.000 2.60600e-06 0.000
+ 2.60605e-06 1.800 2.61100e-06 1.800 2.61105e-06 0.000 2.61200e-06 0.000 2.61205e-06 1.800 2.61300e-06 1.800
+ 2.61305e-06 0.000 2.61400e-06 0.000 2.61405e-06 1.800 2.61600e-06 1.800 2.61605e-06 0.000 2.61700e-06 0.000
+ 2.61705e-06 1.800 2.61800e-06 1.800 2.61805e-06 0.000 2.61900e-06 0.000 2.61905e-06 1.800 2.62200e-06 1.800
+ 2.62205e-06 0.000 2.62500e-06 0.000 2.62505e-06 1.800 2.62700e-06 1.800 2.62705e-06 0.000 2.62800e-06 0.000
+ 2.62805e-06 1.800 2.63100e-06 1.800 2.63105e-06 0.000 2.63400e-06 0.000 2.63405e-06 1.800 2.63500e-06 1.800
+ 2.63505e-06 0.000 2.63600e-06 0.000 2.63605e-06 1.800 2.63700e-06 1.800 2.63705e-06 0.000 2.63800e-06 0.000
+ 2.63805e-06 1.800 2.64000e-06 1.800 2.64005e-06 0.000 2.64400e-06 0.000 2.64405e-06 1.800 2.64500e-06 1.800
+ 2.64505e-06 0.000 2.64700e-06 0.000 2.64705e-06 1.800 2.64900e-06 1.800 2.64905e-06 0.000 2.65200e-06 0.000
+ 2.65205e-06 1.800 2.65300e-06 1.800 2.65305e-06 0.000 2.65900e-06 0.000 2.65905e-06 1.800 2.66000e-06 1.800
+ 2.66005e-06 0.000 2.66400e-06 0.000 2.66405e-06 1.800 2.66700e-06 1.800 2.66705e-06 0.000 2.66800e-06 0.000
+ 2.66805e-06 1.800 2.67000e-06 1.800 2.67005e-06 0.000 2.67100e-06 0.000 2.67105e-06 1.800 2.67500e-06 1.800
+ 2.67505e-06 0.000 2.67600e-06 0.000 2.67605e-06 1.800 2.67700e-06 1.800 2.67705e-06 0.000 2.68000e-06 0.000
+ 2.68005e-06 1.800 2.68100e-06 1.800 2.68105e-06 0.000 2.68200e-06 0.000 2.68205e-06 1.800 2.68400e-06 1.800
+ 2.68405e-06 0.000 2.68500e-06 0.000 2.68505e-06 1.800 2.68700e-06 1.800 2.68705e-06 0.000 2.69000e-06 0.000
+ 2.69005e-06 1.800 2.69200e-06 1.800 2.69205e-06 0.000 2.69600e-06 0.000 2.69605e-06 1.800 2.70000e-06 1.800
+ 2.70005e-06 0.000 2.70200e-06 0.000 2.70205e-06 1.800 2.70400e-06 1.800 2.70405e-06 0.000 2.70500e-06 0.000
+ 2.70505e-06 1.800 2.70600e-06 1.800 2.70605e-06 0.000 2.70800e-06 0.000 2.70805e-06 1.800 2.71200e-06 1.800
+ 2.71205e-06 0.000 2.71700e-06 0.000 2.71705e-06 1.800 2.71900e-06 1.800 2.71905e-06 0.000 2.72000e-06 0.000
+ 2.72005e-06 1.800 2.72100e-06 1.800 2.72105e-06 0.000 2.72400e-06 0.000 2.72405e-06 1.800 2.72600e-06 1.800
+ 2.72605e-06 0.000 2.72700e-06 0.000 2.72705e-06 1.800 2.72800e-06 1.800 2.72805e-06 0.000 2.73200e-06 0.000
+ 2.73205e-06 1.800 2.73600e-06 1.800 2.73605e-06 0.000 2.73700e-06 0.000 2.73705e-06 1.800 2.73900e-06 1.800
+ 2.73905e-06 0.000 2.74000e-06 0.000 2.74005e-06 1.800 2.74100e-06 1.800 2.74105e-06 0.000 2.74200e-06 0.000
+ 2.74205e-06 1.800 2.74300e-06 1.800 2.74305e-06 0.000 2.74600e-06 0.000 2.74605e-06 1.800 2.75100e-06 1.800
+ 2.75105e-06 0.000 2.75400e-06 0.000 2.75405e-06 1.800 2.75600e-06 1.800 2.75605e-06 0.000 2.75700e-06 0.000
+ 2.75705e-06 1.800 2.75900e-06 1.800 2.75905e-06 0.000 2.76000e-06 0.000 2.76005e-06 1.800 2.76100e-06 1.800
+ 2.76105e-06 0.000 2.76300e-06 0.000 2.76305e-06 1.800 2.76400e-06 1.800 2.76405e-06 0.000 2.76500e-06 0.000
+ 2.76505e-06 1.800 2.76700e-06 1.800 2.76705e-06 0.000 2.76800e-06 0.000 2.76805e-06 1.800 2.76900e-06 1.800
+ 2.76905e-06 0.000 2.77300e-06 0.000 2.77305e-06 1.800 2.77500e-06 1.800 2.77505e-06 0.000 2.77600e-06 0.000
+ 2.77605e-06 1.800 2.77800e-06 1.800 2.77805e-06 0.000 2.78400e-06 0.000 2.78405e-06 1.800 2.78500e-06 1.800
+ 2.78505e-06 0.000 2.78600e-06 0.000 2.78605e-06 1.800 2.78800e-06 1.800 2.78805e-06 0.000 2.79100e-06 0.000
+ 2.79105e-06 1.800 2.79300e-06 1.800 2.79305e-06 0.000 2.79400e-06 0.000 2.79405e-06 1.800 2.79600e-06 1.800
+ 2.79605e-06 0.000 2.79900e-06 0.000 2.79905e-06 1.800 2.80000e-06 1.800 2.80005e-06 0.000 2.80100e-06 0.000
+ 2.80105e-06 1.800 2.80200e-06 1.800 2.80205e-06 0.000 2.80300e-06 0.000 2.80305e-06 1.800 2.80500e-06 1.800
+ 2.80505e-06 0.000 2.80800e-06 0.000 2.80805e-06 1.800 2.81000e-06 1.800 2.81005e-06 0.000 2.81200e-06 0.000
+ 2.81205e-06 1.800 2.81500e-06 1.800 2.81505e-06 0.000 2.81800e-06 0.000 2.81805e-06 1.800 2.81900e-06 1.800
+ 2.81905e-06 0.000 2.82200e-06 0.000 2.82205e-06 1.800 2.82500e-06 1.800 2.82505e-06 0.000 2.82700e-06 0.000
+ 2.82705e-06 1.800 2.83300e-06 1.800 2.83305e-06 0.000 2.83500e-06 0.000 2.83505e-06 1.800 2.83600e-06 1.800
+ 2.83605e-06 0.000 2.83700e-06 0.000 2.83705e-06 1.800 2.83800e-06 1.800 2.83805e-06 0.000 2.83900e-06 0.000
+ 2.83905e-06 1.800 2.84100e-06 1.800 2.84105e-06 0.000 2.84700e-06 0.000 2.84705e-06 1.800 2.85200e-06 1.800
+ 2.85205e-06 0.000 2.85300e-06 0.000 2.85305e-06 1.800 2.85500e-06 1.800 2.85505e-06 0.000 2.85600e-06 0.000
+ 2.85605e-06 1.800 2.85700e-06 1.800 2.85705e-06 0.000 2.85800e-06 0.000 2.85805e-06 1.800 2.85900e-06 1.800
+ 2.85905e-06 0.000 2.86000e-06 0.000 2.86005e-06 1.800 2.86200e-06 1.800 2.86205e-06 0.000 2.86400e-06 0.000
+ 2.86405e-06 1.800 2.86500e-06 1.800 2.86505e-06 0.000 2.86600e-06 0.000 2.86605e-06 1.800 2.86900e-06 1.800
+ 2.86905e-06 0.000 2.87000e-06 0.000 2.87005e-06 1.800 2.87200e-06 1.800 2.87205e-06 0.000 2.87400e-06 0.000
+ 2.87405e-06 1.800 2.87500e-06 1.800 2.87505e-06 0.000 2.87700e-06 0.000 2.87705e-06 1.800 2.87800e-06 1.800
+ 2.87805e-06 0.000 2.88200e-06 0.000 2.88205e-06 1.800 2.88400e-06 1.800 2.88405e-06 0.000 2.88600e-06 0.000
+ 2.88605e-06 1.800 2.88800e-06 1.800 2.88805e-06 0.000 2.89300e-06 0.000 2.89305e-06 1.800 2.89500e-06 1.800
+ 2.89505e-06 0.000 2.89800e-06 0.000 2.89805e-06 1.800 2.90100e-06 1.800 2.90105e-06 0.000 2.90200e-06 0.000
+ 2.90205e-06 1.800 2.90300e-06 1.800 2.90305e-06 0.000 2.90400e-06 0.000 2.90405e-06 1.800 2.90800e-06 1.800
+ 2.90805e-06 0.000 2.90900e-06 0.000 2.90905e-06 1.800 2.91500e-06 1.800 2.91505e-06 0.000 2.91600e-06 0.000
+ 2.91605e-06 1.800 2.91700e-06 1.800 2.91705e-06 0.000 2.92600e-06 0.000 2.92605e-06 1.800 2.92700e-06 1.800
+ 2.92705e-06 0.000 2.93000e-06 0.000 2.93005e-06 1.800 2.93200e-06 1.800 2.93205e-06 0.000 2.93300e-06 0.000
+ 2.93305e-06 1.800 2.93400e-06 1.800 2.93405e-06 0.000 2.93900e-06 0.000 2.93905e-06 1.800 2.94400e-06 1.800
+ 2.94405e-06 0.000 2.94700e-06 0.000 2.94705e-06 1.800 2.94900e-06 1.800 2.94905e-06 0.000 2.95100e-06 0.000
+ 2.95105e-06 1.800 2.95200e-06 1.800 2.95205e-06 0.000 2.95400e-06 0.000 2.95405e-06 1.800 2.95600e-06 1.800
+ 2.95605e-06 0.000 2.96000e-06 0.000 2.96005e-06 1.800 2.96100e-06 1.800 2.96105e-06 0.000 2.96300e-06 0.000
+ 2.96305e-06 1.800 2.96400e-06 1.800 2.96405e-06 0.000 2.96700e-06 0.000 2.96705e-06 1.800 2.96800e-06 1.800
+ 2.96805e-06 0.000 2.96900e-06 0.000 2.96905e-06 1.800 2.97200e-06 1.800 2.97205e-06 0.000 2.97300e-06 0.000
+ 2.97305e-06 1.800 2.97400e-06 1.800 2.97405e-06 0.000 2.97500e-06 0.000 2.97505e-06 1.800 2.97800e-06 1.800
+ 2.97805e-06 0.000 2.97900e-06 0.000 2.97905e-06 1.800 2.98100e-06 1.800 2.98105e-06 0.000 2.98300e-06 0.000
+ 2.98305e-06 1.800 2.98400e-06 1.800 2.98405e-06 0.000 2.98500e-06 0.000 2.98505e-06 1.800 2.98600e-06 1.800
+ 2.98605e-06 0.000 2.98800e-06 0.000 2.98805e-06 1.800 2.99000e-06 1.800 2.99005e-06 0.000 2.99500e-06 0.000
+ 2.99505e-06 1.800 2.99600e-06 1.800 2.99605e-06 0.000 2.99700e-06 0.000 2.99705e-06 1.800 2.99900e-06 1.800
+ 2.99905e-06 0.000 3.00100e-06 0.000 3.00105e-06 1.800 3.00400e-06 1.800 3.00405e-06 0.000 3.00500e-06 0.000
+ 3.00505e-06 1.800 3.00700e-06 1.800 3.00705e-06 0.000 3.00900e-06 0.000 3.00905e-06 1.800 3.01100e-06 1.800
+ 3.01105e-06 0.000 3.01500e-06 0.000 3.01505e-06 1.800 3.01600e-06 1.800 3.01605e-06 0.000 3.01700e-06 0.000
+ 3.01705e-06 1.800 3.02300e-06 1.800 3.02305e-06 0.000 3.02400e-06 0.000 3.02405e-06 1.800 3.02700e-06 1.800
+ 3.02705e-06 0.000 3.03300e-06 0.000 3.03305e-06 1.800 3.03400e-06 1.800 3.03405e-06 0.000 3.03700e-06 0.000
+ 3.03705e-06 1.800 3.04200e-06 1.800 3.04205e-06 0.000 3.04600e-06 0.000 3.04605e-06 1.800 3.04700e-06 1.800
+ 3.04705e-06 0.000 3.05100e-06 0.000 3.05105e-06 1.800 3.05400e-06 1.800 3.05405e-06 0.000 3.05500e-06 0.000
+ 3.05505e-06 1.800 3.05700e-06 1.800 3.05705e-06 0.000 3.06000e-06 0.000 3.06005e-06 1.800 3.06100e-06 1.800
+ 3.06105e-06 0.000 3.06200e-06 0.000 3.06205e-06 1.800 3.06500e-06 1.800 3.06505e-06 0.000 3.07100e-06 0.000
+ 3.07105e-06 1.800 3.07300e-06 1.800 3.07305e-06 0.000 3.07400e-06 0.000 3.07405e-06 1.800 3.07500e-06 1.800
+ 3.07505e-06 0.000 3.07600e-06 0.000 3.07605e-06 1.800 3.07700e-06 1.800 3.07705e-06 0.000 3.07800e-06 0.000
+ 3.07805e-06 1.800 3.07900e-06 1.800 3.07905e-06 0.000 3.08000e-06 0.000 3.08005e-06 1.800 3.08300e-06 1.800
+ 3.08305e-06 0.000 3.08700e-06 0.000 3.08705e-06 1.800 3.08800e-06 1.800 3.08805e-06 0.000 3.09000e-06 0.000
+ 3.09005e-06 1.800 3.09300e-06 1.800 3.09305e-06 0.000 3.09500e-06 0.000 3.09505e-06 1.800 3.09700e-06 1.800
+ 3.09705e-06 0.000 3.09900e-06 0.000 3.09905e-06 1.800 3.10000e-06 1.800 3.10005e-06 0.000 3.10100e-06 0.000
+ 3.10105e-06 1.800 3.10200e-06 1.800 3.10205e-06 0.000 3.10300e-06 0.000 3.10305e-06 1.800 3.10600e-06 1.800
+ 3.10605e-06 0.000 3.10700e-06 0.000 3.10705e-06 1.800 3.10800e-06 1.800 3.10805e-06 0.000 3.10900e-06 0.000
+ 3.10905e-06 1.800 3.11000e-06 1.800 3.11005e-06 0.000 3.11100e-06 0.000 3.11105e-06 1.800 3.11200e-06 1.800
+ 3.11205e-06 0.000 3.11400e-06 0.000 3.11405e-06 1.800 3.11800e-06 1.800 3.11805e-06 0.000 3.12000e-06 0.000
+ 3.12005e-06 1.800 3.12200e-06 1.800 3.12205e-06 0.000 3.12300e-06 0.000 3.12305e-06 1.800 3.12400e-06 1.800
+ 3.12405e-06 0.000 3.12500e-06 0.000 3.12505e-06 1.800 3.12700e-06 1.800 3.12705e-06 0.000 3.12800e-06 0.000
+ 3.12805e-06 1.800 3.12900e-06 1.800 3.12905e-06 0.000 3.13000e-06 0.000 3.13005e-06 1.800 3.13200e-06 1.800
+ 3.13205e-06 0.000 3.13300e-06 0.000 3.13305e-06 1.800 3.13900e-06 1.800 3.13905e-06 0.000 3.14100e-06 0.000
+ 3.14105e-06 1.800 3.14200e-06 1.800 3.14205e-06 0.000 3.14300e-06 0.000 3.14305e-06 1.800 3.14500e-06 1.800
+ 3.14505e-06 0.000 3.14700e-06 0.000 3.14705e-06 1.800 3.15100e-06 1.800 3.15105e-06 0.000 3.15200e-06 0.000
+ 3.15205e-06 1.800 3.15300e-06 1.800 3.15305e-06 0.000 3.15400e-06 0.000 3.15405e-06 1.800 3.15500e-06 1.800
+ 3.15505e-06 0.000 3.15600e-06 0.000 3.15605e-06 1.800 3.15800e-06 1.800 3.15805e-06 0.000 3.16100e-06 0.000
+ 3.16105e-06 1.800 3.16200e-06 1.800 3.16205e-06 0.000 3.16400e-06 0.000 3.16405e-06 1.800 3.16500e-06 1.800
+ 3.16505e-06 0.000 3.16600e-06 0.000 3.16605e-06 1.800 3.17000e-06 1.800 3.17005e-06 0.000 3.17300e-06 0.000
+ 3.17305e-06 1.800 3.18100e-06 1.800 3.18105e-06 0.000 3.18500e-06 0.000 3.18505e-06 1.800 3.18900e-06 1.800
+ 3.18905e-06 0.000 3.19100e-06 0.000 3.19105e-06 1.800 3.19200e-06 1.800 3.19205e-06 0.000 3.19300e-06 0.000
+ 3.19305e-06 1.800 3.19700e-06 1.800 3.19705e-06 0.000 3.19900e-06 0.000 3.19905e-06 1.800 3.20000e-06 1.800
+ 3.20005e-06 0.000 3.20200e-06 0.000 3.20205e-06 1.800 3.20300e-06 1.800 3.20305e-06 0.000 3.20400e-06 0.000
+ 3.20405e-06 1.800 3.20500e-06 1.800 3.20505e-06 0.000 3.20600e-06 0.000 3.20605e-06 1.800 3.20700e-06 1.800
+ 3.20705e-06 0.000 3.21800e-06 0.000 3.21805e-06 1.800 3.22100e-06 1.800 3.22105e-06 0.000 3.22300e-06 0.000
+ 3.22305e-06 1.800 3.22600e-06 1.800 3.22605e-06 0.000 3.22800e-06 0.000 3.22805e-06 1.800 3.23200e-06 1.800
+ 3.23205e-06 0.000 3.23500e-06 0.000 3.23505e-06 1.800 3.23600e-06 1.800 3.23605e-06 0.000 3.23700e-06 0.000
+ 3.23705e-06 1.800 3.24000e-06 1.800 3.24005e-06 0.000 3.24100e-06 0.000 3.24105e-06 1.800 3.24200e-06 1.800
+ 3.24205e-06 0.000 3.24500e-06 0.000 3.24505e-06 1.800 3.24600e-06 1.800 3.24605e-06 0.000 3.24800e-06 0.000
+ 3.24805e-06 1.800 3.25000e-06 1.800 3.25005e-06 0.000 3.25500e-06 0.000 3.25505e-06 1.800 3.25600e-06 1.800
+ 3.25605e-06 0.000 3.25700e-06 0.000 3.25705e-06 1.800 3.25800e-06 1.800 3.25805e-06 0.000 3.26100e-06 0.000
+ 3.26105e-06 1.800 3.26400e-06 1.800 3.26405e-06 0.000 3.26500e-06 0.000 3.26505e-06 1.800 3.26700e-06 1.800
+ 3.26705e-06 0.000 3.26900e-06 0.000 3.26905e-06 1.800 3.27100e-06 1.800 3.27105e-06 0.000 3.27200e-06 0.000
+ 3.27205e-06 1.800 3.27300e-06 1.800 3.27305e-06 0.000 3.27700e-06 0.000 3.27705e-06 1.800 3.27800e-06 1.800
+ 3.27805e-06 0.000 3.28000e-06 0.000 3.28005e-06 1.800 3.28100e-06 1.800 3.28105e-06 0.000 3.28200e-06 0.000
+ 3.28205e-06 1.800 3.28500e-06 1.800 3.28505e-06 0.000 3.28800e-06 0.000 3.28805e-06 1.800 3.29000e-06 1.800
+ 3.29005e-06 0.000 3.29100e-06 0.000 3.29105e-06 1.800 3.29700e-06 1.800 3.29705e-06 0.000 3.30000e-06 0.000
+ 3.30005e-06 1.800 3.30100e-06 1.800 3.30105e-06 0.000 3.30200e-06 0.000 3.30205e-06 1.800 3.30300e-06 1.800
+ 3.30305e-06 0.000 3.30500e-06 0.000 3.30505e-06 1.800 3.30600e-06 1.800 3.30605e-06 0.000 3.31000e-06 0.000
+ 3.31005e-06 1.800 3.31200e-06 1.800 3.31205e-06 0.000 3.31300e-06 0.000 3.31305e-06 1.800 3.31400e-06 1.800
+ 3.31405e-06 0.000 3.31500e-06 0.000 3.31505e-06 1.800 3.31600e-06 1.800 3.31605e-06 0.000 3.31700e-06 0.000
+ 3.31705e-06 1.800 3.31900e-06 1.800 3.31905e-06 0.000 3.32000e-06 0.000 3.32005e-06 1.800 3.32300e-06 1.800
+ 3.32305e-06 0.000 3.32500e-06 0.000 3.32505e-06 1.800 3.32600e-06 1.800 3.32605e-06 0.000 3.32700e-06 0.000
+ 3.32705e-06 1.800 3.32900e-06 1.800 3.32905e-06 0.000 3.33100e-06 0.000 3.33105e-06 1.800 3.33200e-06 1.800
+ 3.33205e-06 0.000 3.33300e-06 0.000 3.33305e-06 1.800 3.33600e-06 1.800 3.33605e-06 0.000 3.33900e-06 0.000
+ 3.33905e-06 1.800 3.34000e-06 1.800 3.34005e-06 0.000 3.34100e-06 0.000 3.34105e-06 1.800 3.34200e-06 1.800
+ 3.34205e-06 0.000 3.34300e-06 0.000 3.34305e-06 1.800 3.34400e-06 1.800 3.34405e-06 0.000 3.34700e-06 0.000
+ 3.34705e-06 1.800 3.34900e-06 1.800 3.34905e-06 0.000 3.35100e-06 0.000 3.35105e-06 1.800 3.35200e-06 1.800
+ 3.35205e-06 0.000 3.35300e-06 0.000 3.35305e-06 1.800 3.35400e-06 1.800 3.35405e-06 0.000 3.35500e-06 0.000
+ 3.35505e-06 1.800 3.35900e-06 1.800 3.35905e-06 0.000 3.36200e-06 0.000 3.36205e-06 1.800 3.36400e-06 1.800
+ 3.36405e-06 0.000 3.36500e-06 0.000 3.36505e-06 1.800 3.36600e-06 1.800 3.36605e-06 0.000 3.37000e-06 0.000
+ 3.37005e-06 1.800 3.37200e-06 1.800 3.37205e-06 0.000 3.37300e-06 0.000 3.37305e-06 1.800 3.37400e-06 1.800
+ 3.37405e-06 0.000 3.37600e-06 0.000 3.37605e-06 1.800 3.37900e-06 1.800 3.37905e-06 0.000 3.38200e-06 0.000
+ 3.38205e-06 1.800 3.38300e-06 1.800 3.38305e-06 0.000 3.38400e-06 0.000 3.38405e-06 1.800 3.38500e-06 1.800
+ 3.38505e-06 0.000 3.38700e-06 0.000 3.38705e-06 1.800 3.39000e-06 1.800 3.39005e-06 0.000 3.39100e-06 0.000
+ 3.39105e-06 1.800 3.39300e-06 1.800 3.39305e-06 0.000 3.39400e-06 0.000 3.39405e-06 1.800 3.40000e-06 1.800
+ 3.40005e-06 0.000 3.40200e-06 0.000 3.40205e-06 1.800 3.40300e-06 1.800 3.40305e-06 0.000 3.40400e-06 0.000
+ 3.40405e-06 1.800 3.40700e-06 1.800 3.40705e-06 0.000 3.41000e-06 0.000 3.41005e-06 1.800 3.41200e-06 1.800
+ 3.41205e-06 0.000 3.41300e-06 0.000 3.41305e-06 1.800 3.41400e-06 1.800 3.41405e-06 0.000 3.41500e-06 0.000
+ 3.41505e-06 1.800 3.41900e-06 1.800 3.41905e-06 0.000 3.42000e-06 0.000 3.42005e-06 1.800 3.42100e-06 1.800
+ 3.42105e-06 0.000 3.42200e-06 0.000 3.42205e-06 1.800 3.42300e-06 1.800 3.42305e-06 0.000 3.42600e-06 0.000
+ 3.42605e-06 1.800 3.42800e-06 1.800 3.42805e-06 0.000 3.43000e-06 0.000 3.43005e-06 1.800 3.43600e-06 1.800
+ 3.43605e-06 0.000 3.43700e-06 0.000 3.43705e-06 1.800 3.44000e-06 1.800 3.44005e-06 0.000 3.44200e-06 0.000
+ 3.44205e-06 1.800 3.44300e-06 1.800 3.44305e-06 0.000 3.44600e-06 0.000 3.44605e-06 1.800 3.44900e-06 1.800
+ 3.44905e-06 0.000 3.45300e-06 0.000 3.45305e-06 1.800 3.45600e-06 1.800 3.45605e-06 0.000 3.45700e-06 0.000
+ 3.45705e-06 1.800 3.45900e-06 1.800 3.45905e-06 0.000 3.46000e-06 0.000 3.46005e-06 1.800 3.46100e-06 1.800
+ 3.46105e-06 0.000 3.46600e-06 0.000 3.46605e-06 1.800 3.46700e-06 1.800 3.46705e-06 0.000 3.46800e-06 0.000
+ 3.46805e-06 1.800 3.47000e-06 1.800 3.47005e-06 0.000 3.47200e-06 0.000 3.47205e-06 1.800 3.47500e-06 1.800
+ 3.47505e-06 0.000 3.47700e-06 0.000 3.47705e-06 1.800 3.47900e-06 1.800 3.47905e-06 0.000 3.48400e-06 0.000
+ 3.48405e-06 1.800 3.48500e-06 1.800 3.48505e-06 0.000 3.48600e-06 0.000 3.48605e-06 1.800 3.48700e-06 1.800
+ 3.48705e-06 0.000 3.49000e-06 0.000 3.49005e-06 1.800 3.49100e-06 1.800 3.49105e-06 0.000 3.49300e-06 0.000
+ 3.49305e-06 1.800 3.49400e-06 1.800 3.49405e-06 0.000 3.49600e-06 0.000 3.49605e-06 1.800 3.50100e-06 1.800
+ 3.50105e-06 0.000 3.50300e-06 0.000 3.50305e-06 1.800 3.50400e-06 1.800 3.50405e-06 0.000 3.50500e-06 0.000
+ 3.50505e-06 1.800 3.50600e-06 1.800 3.50605e-06 0.000 3.50700e-06 0.000 3.50705e-06 1.800 3.50800e-06 1.800
+ 3.50805e-06 0.000 3.51000e-06 0.000 3.51005e-06 1.800 3.51500e-06 1.800 3.51505e-06 0.000 3.51600e-06 0.000
+ 3.51605e-06 1.800 3.52000e-06 1.800 3.52005e-06 0.000 3.52200e-06 0.000 3.52205e-06 1.800 3.52500e-06 1.800
+ 3.52505e-06 0.000 3.52600e-06 0.000 3.52605e-06 1.800 3.52700e-06 1.800 3.52705e-06 0.000 3.52800e-06 0.000
+ 3.52805e-06 1.800 3.52900e-06 1.800 3.52905e-06 0.000 3.53000e-06 0.000 3.53005e-06 1.800 3.53300e-06 1.800
+ 3.53305e-06 0.000 3.53700e-06 0.000 3.53705e-06 1.800 3.53800e-06 1.800 3.53805e-06 0.000 3.54000e-06 0.000
+ 3.54005e-06 1.800 3.54100e-06 1.800 3.54105e-06 0.000 3.54200e-06 0.000 3.54205e-06 1.800 3.54300e-06 1.800
+ 3.54305e-06 0.000 3.54500e-06 0.000 3.54505e-06 1.800 3.54600e-06 1.800 3.54605e-06 0.000 3.54700e-06 0.000
+ 3.54705e-06 1.800 3.55700e-06 1.800 3.55705e-06 0.000 3.55800e-06 0.000 3.55805e-06 1.800 3.55900e-06 1.800
+ 3.55905e-06 0.000 3.56000e-06 0.000 3.56005e-06 1.800 3.56100e-06 1.800 3.56105e-06 0.000 3.56200e-06 0.000
+ 3.56205e-06 1.800 3.56300e-06 1.800 3.56305e-06 0.000 3.56400e-06 0.000 3.56405e-06 1.800 3.56500e-06 1.800
+ 3.56505e-06 0.000 3.56700e-06 0.000 3.56705e-06 1.800 3.56800e-06 1.800 3.56805e-06 0.000 3.56900e-06 0.000
+ 3.56905e-06 1.800 3.57100e-06 1.800 3.57105e-06 0.000 3.57200e-06 0.000 3.57205e-06 1.800 3.57300e-06 1.800
+ 3.57305e-06 0.000 3.57400e-06 0.000 3.57405e-06 1.800 3.57500e-06 1.800 3.57505e-06 0.000 3.57600e-06 0.000
+ 3.57605e-06 1.800 3.57700e-06 1.800 3.57705e-06 0.000 3.57800e-06 0.000 3.57805e-06 1.800 3.58000e-06 1.800
+ 3.58005e-06 0.000 3.58200e-06 0.000 3.58205e-06 1.800 3.58400e-06 1.800 3.58405e-06 0.000 3.58600e-06 0.000
+ 3.58605e-06 1.800 3.58700e-06 1.800 3.58705e-06 0.000 3.58800e-06 0.000 3.58805e-06 1.800 3.58900e-06 1.800
+ 3.58905e-06 0.000 3.59000e-06 0.000 3.59005e-06 1.800 3.59200e-06 1.800 3.59205e-06 0.000 3.59300e-06 0.000
+ 3.59305e-06 1.800 3.59400e-06 1.800 3.59405e-06 0.000 3.59500e-06 0.000 3.59505e-06 1.800 3.59600e-06 1.800
+ 3.59605e-06 0.000 3.59700e-06 0.000 3.59705e-06 1.800 3.59900e-06 1.800 3.59905e-06 0.000 3.60400e-06 0.000
+ 3.60405e-06 1.800 3.60600e-06 1.800 3.60605e-06 0.000 3.60700e-06 0.000 3.60705e-06 1.800 3.60900e-06 1.800
+ 3.60905e-06 0.000 3.61100e-06 0.000 3.61105e-06 1.800 3.61400e-06 1.800 3.61405e-06 0.000 3.62000e-06 0.000
+ 3.62005e-06 1.800 3.62100e-06 1.800 3.62105e-06 0.000 3.62300e-06 0.000 3.62305e-06 1.800 3.62400e-06 1.800
+ 3.62405e-06 0.000 3.62500e-06 0.000 3.62505e-06 1.800 3.62800e-06 1.800 3.62805e-06 0.000 3.63000e-06 0.000
+ 3.63005e-06 1.800 3.63200e-06 1.800 3.63205e-06 0.000 3.63300e-06 0.000 3.63305e-06 1.800 3.63800e-06 1.800
+ 3.63805e-06 0.000 3.64100e-06 0.000 3.64105e-06 1.800 3.64300e-06 1.800 3.64305e-06 0.000 3.64500e-06 0.000
+ 3.64505e-06 1.800 3.64700e-06 1.800 3.64705e-06 0.000 3.65100e-06 0.000 3.65105e-06 1.800 3.65200e-06 1.800
+ 3.65205e-06 0.000 3.65500e-06 0.000 3.65505e-06 1.800 3.66000e-06 1.800 3.66005e-06 0.000 3.66500e-06 0.000
+ 3.66505e-06 1.800 3.66600e-06 1.800 3.66605e-06 0.000 3.66700e-06 0.000 3.66705e-06 1.800 3.66900e-06 1.800
+ 3.66905e-06 0.000 3.67100e-06 0.000 3.67105e-06 1.800 3.67200e-06 1.800 3.67205e-06 0.000 3.67300e-06 0.000
+ 3.67305e-06 1.800 3.67400e-06 1.800 3.67405e-06 0.000 3.67800e-06 0.000 3.67805e-06 1.800 3.68000e-06 1.800
+ 3.68005e-06 0.000 3.68100e-06 0.000 3.68105e-06 1.800 3.68200e-06 1.800 3.68205e-06 0.000 3.68300e-06 0.000
+ 3.68305e-06 1.800 3.68500e-06 1.800 3.68505e-06 0.000 3.69200e-06 0.000 3.69205e-06 1.800 3.69300e-06 1.800
+ 3.69305e-06 0.000 3.69800e-06 0.000 3.69805e-06 1.800 3.70700e-06 1.800 3.70705e-06 0.000 3.70900e-06 0.000
+ 3.70905e-06 1.800 3.71100e-06 1.800 3.71105e-06 0.000 3.71200e-06 0.000 3.71205e-06 1.800 3.71300e-06 1.800
+ 3.71305e-06 0.000 3.71400e-06 0.000 3.71405e-06 1.800 3.71500e-06 1.800 3.71505e-06 0.000 3.71700e-06 0.000
+ 3.71705e-06 1.800 3.71800e-06 1.800 3.71805e-06 0.000 3.72000e-06 0.000 3.72005e-06 1.800 3.72100e-06 1.800
+ 3.72105e-06 0.000 3.72200e-06 0.000 3.72205e-06 1.800 3.72300e-06 1.800 3.72305e-06 0.000 3.72500e-06 0.000
+ 3.72505e-06 1.800 3.72800e-06 1.800 3.72805e-06 0.000 3.73000e-06 0.000 3.73005e-06 1.800 3.73100e-06 1.800
+ 3.73105e-06 0.000 3.73200e-06 0.000 3.73205e-06 1.800 3.73300e-06 1.800 3.73305e-06 0.000 3.73400e-06 0.000
+ 3.73405e-06 1.800 3.73500e-06 1.800 3.73505e-06 0.000 3.73700e-06 0.000 3.73705e-06 1.800 3.73900e-06 1.800
+ 3.73905e-06 0.000 3.74000e-06 0.000 3.74005e-06 1.800 3.74200e-06 1.800 3.74205e-06 0.000 3.74300e-06 0.000
+ 3.74305e-06 1.800 3.74700e-06 1.800 3.74705e-06 0.000 3.74800e-06 0.000 3.74805e-06 1.800 3.74900e-06 1.800
+ 3.74905e-06 0.000 3.75000e-06 0.000 3.75005e-06 1.800 3.75400e-06 1.800 3.75405e-06 0.000 3.75600e-06 0.000
+ 3.75605e-06 1.800 3.75700e-06 1.800 3.75705e-06 0.000 3.75900e-06 0.000 3.75905e-06 1.800 3.76000e-06 1.800
+ 3.76005e-06 0.000 3.76100e-06 0.000 3.76105e-06 1.800 3.76600e-06 1.800 3.76605e-06 0.000 3.76700e-06 0.000
+ 3.76705e-06 1.800 3.76800e-06 1.800 3.76805e-06 0.000 3.76900e-06 0.000 3.76905e-06 1.800 3.77000e-06 1.800
+ 3.77005e-06 0.000 3.77300e-06 0.000 3.77305e-06 1.800 3.77400e-06 1.800 3.77405e-06 0.000 3.77600e-06 0.000
+ 3.77605e-06 1.800 3.77900e-06 1.800 3.77905e-06 0.000 3.78000e-06 0.000 3.78005e-06 1.800 3.78200e-06 1.800
+ 3.78205e-06 0.000 3.78300e-06 0.000 3.78305e-06 1.800 3.78500e-06 1.800 3.78505e-06 0.000 3.78700e-06 0.000
+ 3.78705e-06 1.800 3.78900e-06 1.800 3.78905e-06 0.000 3.79100e-06 0.000 3.79105e-06 1.800 3.79400e-06 1.800
+ 3.79405e-06 0.000 3.79500e-06 0.000 3.79505e-06 1.800 3.79700e-06 1.800 3.79705e-06 0.000 3.79800e-06 0.000
+ 3.79805e-06 1.800 3.80000e-06 1.800 3.80005e-06 0.000 3.80100e-06 0.000 3.80105e-06 1.800 3.80200e-06 1.800
+ 3.80205e-06 0.000 3.80300e-06 0.000 3.80305e-06 1.800 3.80600e-06 1.800 3.80605e-06 0.000 3.80700e-06 0.000
+ 3.80705e-06 1.800 3.81100e-06 1.800 3.81105e-06 0.000 3.81200e-06 0.000 3.81205e-06 1.800 3.81500e-06 1.800
+ 3.81505e-06 0.000 3.81700e-06 0.000 3.81705e-06 1.800 3.82100e-06 1.800 3.82105e-06 0.000 3.82200e-06 0.000
+ 3.82205e-06 1.800 3.82300e-06 1.800 3.82305e-06 0.000 3.82400e-06 0.000 3.82405e-06 1.800 3.82500e-06 1.800
+ 3.82505e-06 0.000 3.83000e-06 0.000 3.83005e-06 1.800 3.83200e-06 1.800 3.83205e-06 0.000 3.83500e-06 0.000
+ 3.83505e-06 1.800 3.83600e-06 1.800 3.83605e-06 0.000 3.83800e-06 0.000 3.83805e-06 1.800 3.84000e-06 1.800
+ 3.84005e-06 0.000 3.84100e-06 0.000 3.84105e-06 1.800 3.84300e-06 1.800 3.84305e-06 0.000 3.84500e-06 0.000
+ 3.84505e-06 1.800 3.84800e-06 1.800 3.84805e-06 0.000 3.85000e-06 0.000 3.85005e-06 1.800 3.85200e-06 1.800
+ 3.85205e-06 0.000 3.85300e-06 0.000 3.85305e-06 1.800 3.85400e-06 1.800 3.85405e-06 0.000 3.85500e-06 0.000
+ 3.85505e-06 1.800 3.85600e-06 1.800 3.85605e-06 0.000 3.85900e-06 0.000 3.85905e-06 1.800 3.86000e-06 1.800
+ 3.86005e-06 0.000 3.86100e-06 0.000 3.86105e-06 1.800 3.86200e-06 1.800 3.86205e-06 0.000 3.86300e-06 0.000
+ 3.86305e-06 1.800 3.86600e-06 1.800 3.86605e-06 0.000 3.86700e-06 0.000 3.86705e-06 1.800 3.86800e-06 1.800
+ 3.86805e-06 0.000 3.87200e-06 0.000 3.87205e-06 1.800 3.87300e-06 1.800 3.87305e-06 0.000 3.87400e-06 0.000
+ 3.87405e-06 1.800 3.87500e-06 1.800 3.87505e-06 0.000 3.87600e-06 0.000 3.87605e-06 1.800 3.88200e-06 1.800
+ 3.88205e-06 0.000 3.88300e-06 0.000 3.88305e-06 1.800 3.88500e-06 1.800 3.88505e-06 0.000 3.88700e-06 0.000
+ 3.88705e-06 1.800 3.88800e-06 1.800 3.88805e-06 0.000 3.88900e-06 0.000 3.88905e-06 1.800 3.89300e-06 1.800
+ 3.89305e-06 0.000 3.89900e-06 0.000 3.89905e-06 1.800 3.90300e-06 1.800 3.90305e-06 0.000 3.90600e-06 0.000
+ 3.90605e-06 1.800 3.90700e-06 1.800 3.90705e-06 0.000 3.90800e-06 0.000 3.90805e-06 1.800 3.91000e-06 1.800
+ 3.91005e-06 0.000 3.91100e-06 0.000 3.91105e-06 1.800 3.91300e-06 1.800 3.91305e-06 0.000 3.91400e-06 0.000
+ 3.91405e-06 1.800 3.91600e-06 1.800 3.91605e-06 0.000 3.92100e-06 0.000 3.92105e-06 1.800 3.92400e-06 1.800
+ 3.92405e-06 0.000 3.92500e-06 0.000 3.92505e-06 1.800 3.92600e-06 1.800 3.92605e-06 0.000 3.93000e-06 0.000
+ 3.93005e-06 1.800 3.93100e-06 1.800 3.93105e-06 0.000 3.93300e-06 0.000 3.93305e-06 1.800 3.93400e-06 1.800
+ 3.93405e-06 0.000 3.93500e-06 0.000 3.93505e-06 1.800 3.93700e-06 1.800 3.93705e-06 0.000 3.93900e-06 0.000
+ 3.93905e-06 1.800 3.94100e-06 1.800 3.94105e-06 0.000 3.94200e-06 0.000 3.94205e-06 1.800 3.94800e-06 1.800
+ 3.94805e-06 0.000 3.94900e-06 0.000 3.94905e-06 1.800 3.95200e-06 1.800 3.95205e-06 0.000 3.95300e-06 0.000
+ 3.95305e-06 1.800 3.95400e-06 1.800 3.95405e-06 0.000 3.95500e-06 0.000 3.95505e-06 1.800 3.95600e-06 1.800
+ 3.95605e-06 0.000 3.95700e-06 0.000 3.95705e-06 1.800 3.95900e-06 1.800 3.95905e-06 0.000 3.96300e-06 0.000
+ 3.96305e-06 1.800 3.96500e-06 1.800 3.96505e-06 0.000 3.96600e-06 0.000 3.96605e-06 1.800 3.96900e-06 1.800
+ 3.96905e-06 0.000 3.97000e-06 0.000 3.97005e-06 1.800 3.97100e-06 1.800 3.97105e-06 0.000 3.97200e-06 0.000
+ 3.97205e-06 1.800 3.97400e-06 1.800 3.97405e-06 0.000 3.97500e-06 0.000 3.97505e-06 1.800 3.97600e-06 1.800
+ 3.97605e-06 0.000 3.97700e-06 0.000 3.97705e-06 1.800 3.97800e-06 1.800 3.97805e-06 0.000 3.97900e-06 0.000
+ 3.97905e-06 1.800 3.98100e-06 1.800 3.98105e-06 0.000 3.98400e-06 0.000 3.98405e-06 1.800 3.98600e-06 1.800
+ 3.98605e-06 0.000 3.98700e-06 0.000 3.98705e-06 1.800 3.98800e-06 1.800 3.98805e-06 0.000 3.98900e-06 0.000
+ 3.98905e-06 1.800 3.99000e-06 1.800 3.99005e-06 0.000 3.99100e-06 0.000 3.99105e-06 1.800 3.99200e-06 1.800
+ 3.99205e-06 0.000 3.99600e-06 0.000 3.99605e-06 1.800 3.99700e-06 1.800 3.99705e-06 0.000 3.99900e-06 0.000
+ 3.99905e-06 1.800 4.00100e-06 1.800 4.00105e-06 0.000 4.00300e-06 0.000 4.00305e-06 1.800 4.00400e-06 1.800
+ 4.00405e-06 0.000 4.00600e-06 0.000 4.00605e-06 1.800 4.00800e-06 1.800 4.00805e-06 0.000 4.01100e-06 0.000
+ 4.01105e-06 1.800 4.01300e-06 1.800 4.01305e-06 0.000 4.01500e-06 0.000 4.01505e-06 1.800 4.02000e-06 1.800
+ 4.02005e-06 0.000 4.02100e-06 0.000 4.02105e-06 1.800 4.02200e-06 1.800 4.02205e-06 0.000 4.02500e-06 0.000
+ 4.02505e-06 1.800 4.02600e-06 1.800 4.02605e-06 0.000 4.03100e-06 0.000 4.03105e-06 1.800 4.03400e-06 1.800
+ 4.03405e-06 0.000 4.03500e-06 0.000 4.03505e-06 1.800 4.03700e-06 1.800 4.03705e-06 0.000 4.04100e-06 0.000
+ 4.04105e-06 1.800 4.04500e-06 1.800 4.04505e-06 0.000 4.04700e-06 0.000 4.04705e-06 1.800 4.04900e-06 1.800
+ 4.04905e-06 0.000 4.05200e-06 0.000 4.05205e-06 1.800 4.05800e-06 1.800 4.05805e-06 0.000 4.06000e-06 0.000
+ 4.06005e-06 1.800 4.06100e-06 1.800 4.06105e-06 0.000 4.06200e-06 0.000 4.06205e-06 1.800 4.06400e-06 1.800
+ 4.06405e-06 0.000 4.06500e-06 0.000 4.06505e-06 1.800 4.06600e-06 1.800 4.06605e-06 0.000 4.06800e-06 0.000
+ 4.06805e-06 1.800 4.07000e-06 1.800 4.07005e-06 0.000 4.07200e-06 0.000 4.07205e-06 1.800 4.07300e-06 1.800
+ 4.07305e-06 0.000 4.07700e-06 0.000 4.07705e-06 1.800 4.07800e-06 1.800 4.07805e-06 0.000 4.07900e-06 0.000
+ 4.07905e-06 1.800 4.08100e-06 1.800 4.08105e-06 0.000 4.08300e-06 0.000 4.08305e-06 1.800 4.08400e-06 1.800
+ 4.08405e-06 0.000 4.08800e-06 0.000 4.08805e-06 1.800 4.08900e-06 1.800 4.08905e-06 0.000 4.09000e-06 0.000
+ 4.09005e-06 1.800 4.09100e-06 1.800 4.09105e-06 0.000 4.09400e-06 0.000 4.09405e-06 1.800 4.09500e-06 1.800
+ 4.09505e-06 0.000 4.09600e-06 0.000
+ )
Xd_t0b src_t0b t0b vdd gnd tb_inv
Vg1b src_g1b gnd PWL(
+ 0.00000e+00 1.800 2.56000e-07 1.800 2.56050e-07 0.000 5.12000e-07 0.000 5.12050e-07 1.800 7.68000e-07 1.800
+ 7.68050e-07 0.000 1.02400e-06 0.000 1.02405e-06 1.800 1.28000e-06 1.800 1.28005e-06 0.000 1.53600e-06 0.000
+ 1.53605e-06 1.800 1.79200e-06 1.800 1.79205e-06 0.000 2.04800e-06 0.000 2.04805e-06 1.800 2.05100e-06 1.800
+ 2.05105e-06 0.000 2.05400e-06 0.000 2.05405e-06 1.800 2.05600e-06 1.800 2.05605e-06 0.000 2.05700e-06 0.000
+ 2.05705e-06 1.800 2.05800e-06 1.800 2.05805e-06 0.000 2.06100e-06 0.000 2.06105e-06 1.800 2.06200e-06 1.800
+ 2.06205e-06 0.000 2.06400e-06 0.000 2.06405e-06 1.800 2.06600e-06 1.800 2.06605e-06 0.000 2.07200e-06 0.000
+ 2.07205e-06 1.800 2.07400e-06 1.800 2.07405e-06 0.000 2.07800e-06 0.000 2.07805e-06 1.800 2.08200e-06 1.800
+ 2.08205e-06 0.000 2.08500e-06 0.000 2.08505e-06 1.800 2.08600e-06 1.800 2.08605e-06 0.000 2.08700e-06 0.000
+ 2.08705e-06 1.800 2.09000e-06 1.800 2.09005e-06 0.000 2.09100e-06 0.000 2.09105e-06 1.800 2.09300e-06 1.800
+ 2.09305e-06 0.000 2.09400e-06 0.000 2.09405e-06 1.800 2.09500e-06 1.800 2.09505e-06 0.000 2.09600e-06 0.000
+ 2.09605e-06 1.800 2.09900e-06 1.800 2.09905e-06 0.000 2.10100e-06 0.000 2.10105e-06 1.800 2.10200e-06 1.800
+ 2.10205e-06 0.000 2.10300e-06 0.000 2.10305e-06 1.800 2.10600e-06 1.800 2.10605e-06 0.000 2.10700e-06 0.000
+ 2.10705e-06 1.800 2.10800e-06 1.800 2.10805e-06 0.000 2.11100e-06 0.000 2.11105e-06 1.800 2.11200e-06 1.800
+ 2.11205e-06 0.000 2.11800e-06 0.000 2.11805e-06 1.800 2.11900e-06 1.800 2.11905e-06 0.000 2.12000e-06 0.000
+ 2.12005e-06 1.800 2.12300e-06 1.800 2.12305e-06 0.000 2.12600e-06 0.000 2.12605e-06 1.800 2.12900e-06 1.800
+ 2.12905e-06 0.000 2.13000e-06 0.000 2.13005e-06 1.800 2.13100e-06 1.800 2.13105e-06 0.000 2.13300e-06 0.000
+ 2.13305e-06 1.800 2.13400e-06 1.800 2.13405e-06 0.000 2.13500e-06 0.000 2.13505e-06 1.800 2.13600e-06 1.800
+ 2.13605e-06 0.000 2.13700e-06 0.000 2.13705e-06 1.800 2.13900e-06 1.800 2.13905e-06 0.000 2.14000e-06 0.000
+ 2.14005e-06 1.800 2.14100e-06 1.800 2.14105e-06 0.000 2.14200e-06 0.000 2.14205e-06 1.800 2.14300e-06 1.800
+ 2.14305e-06 0.000 2.14500e-06 0.000 2.14505e-06 1.800 2.15300e-06 1.800 2.15305e-06 0.000 2.15500e-06 0.000
+ 2.15505e-06 1.800 2.15600e-06 1.800 2.15605e-06 0.000 2.15900e-06 0.000 2.15905e-06 1.800 2.16000e-06 1.800
+ 2.16005e-06 0.000 2.16200e-06 0.000 2.16205e-06 1.800 2.16300e-06 1.800 2.16305e-06 0.000 2.16500e-06 0.000
+ 2.16505e-06 1.800 2.16600e-06 1.800 2.16605e-06 0.000 2.16900e-06 0.000 2.16905e-06 1.800 2.17000e-06 1.800
+ 2.17005e-06 0.000 2.17500e-06 0.000 2.17505e-06 1.800 2.17700e-06 1.800 2.17705e-06 0.000 2.17900e-06 0.000
+ 2.17905e-06 1.800 2.18600e-06 1.800 2.18605e-06 0.000 2.18800e-06 0.000 2.18805e-06 1.800 2.18900e-06 1.800
+ 2.18905e-06 0.000 2.19100e-06 0.000 2.19105e-06 1.800 2.19300e-06 1.800 2.19305e-06 0.000 2.19800e-06 0.000
+ 2.19805e-06 1.800 2.19900e-06 1.800 2.19905e-06 0.000 2.20200e-06 0.000 2.20205e-06 1.800 2.20600e-06 1.800
+ 2.20605e-06 0.000 2.20900e-06 0.000 2.20905e-06 1.800 2.21000e-06 1.800 2.21005e-06 0.000 2.21200e-06 0.000
+ 2.21205e-06 1.800 2.21500e-06 1.800 2.21505e-06 0.000 2.21700e-06 0.000 2.21705e-06 1.800 2.21800e-06 1.800
+ 2.21805e-06 0.000 2.21900e-06 0.000 2.21905e-06 1.800 2.22100e-06 1.800 2.22105e-06 0.000 2.22400e-06 0.000
+ 2.22405e-06 1.800 2.22900e-06 1.800 2.22905e-06 0.000 2.23100e-06 0.000 2.23105e-06 1.800 2.23400e-06 1.800
+ 2.23405e-06 0.000 2.23600e-06 0.000 2.23605e-06 1.800 2.23700e-06 1.800 2.23705e-06 0.000 2.23800e-06 0.000
+ 2.23805e-06 1.800 2.24500e-06 1.800 2.24505e-06 0.000 2.24900e-06 0.000 2.24905e-06 1.800 2.25200e-06 1.800
+ 2.25205e-06 0.000 2.25400e-06 0.000 2.25405e-06 1.800 2.25500e-06 1.800 2.25505e-06 0.000 2.25700e-06 0.000
+ 2.25705e-06 1.800 2.25800e-06 1.800 2.25805e-06 0.000 2.25900e-06 0.000 2.25905e-06 1.800 2.26000e-06 1.800
+ 2.26005e-06 0.000 2.26500e-06 0.000 2.26505e-06 1.800 2.26600e-06 1.800 2.26605e-06 0.000 2.26700e-06 0.000
+ 2.26705e-06 1.800 2.26900e-06 1.800 2.26905e-06 0.000 2.27000e-06 0.000 2.27005e-06 1.800 2.27100e-06 1.800
+ 2.27105e-06 0.000 2.27200e-06 0.000 2.27205e-06 1.800 2.27600e-06 1.800 2.27605e-06 0.000 2.27800e-06 0.000
+ 2.27805e-06 1.800 2.27900e-06 1.800 2.27905e-06 0.000 2.28000e-06 0.000 2.28005e-06 1.800 2.28100e-06 1.800
+ 2.28105e-06 0.000 2.28200e-06 0.000 2.28205e-06 1.800 2.28400e-06 1.800 2.28405e-06 0.000 2.28500e-06 0.000
+ 2.28505e-06 1.800 2.28700e-06 1.800 2.28705e-06 0.000 2.29500e-06 0.000 2.29505e-06 1.800 2.29600e-06 1.800
+ 2.29605e-06 0.000 2.30000e-06 0.000 2.30005e-06 1.800 2.30100e-06 1.800 2.30105e-06 0.000 2.30200e-06 0.000
+ 2.30205e-06 1.800 2.30400e-06 1.800 2.30405e-06 0.000 2.30700e-06 0.000 2.30705e-06 1.800 2.31100e-06 1.800
+ 2.31105e-06 0.000 2.31200e-06 0.000 2.31205e-06 1.800 2.31400e-06 1.800 2.31405e-06 0.000 2.31500e-06 0.000
+ 2.31505e-06 1.800 2.31600e-06 1.800 2.31605e-06 0.000 2.31700e-06 0.000 2.31705e-06 1.800 2.31900e-06 1.800
+ 2.31905e-06 0.000 2.32000e-06 0.000 2.32005e-06 1.800 2.32100e-06 1.800 2.32105e-06 0.000 2.32200e-06 0.000
+ 2.32205e-06 1.800 2.32300e-06 1.800 2.32305e-06 0.000 2.32500e-06 0.000 2.32505e-06 1.800 2.32600e-06 1.800
+ 2.32605e-06 0.000 2.32900e-06 0.000 2.32905e-06 1.800 2.33100e-06 1.800 2.33105e-06 0.000 2.33300e-06 0.000
+ 2.33305e-06 1.800 2.34000e-06 1.800 2.34005e-06 0.000 2.34600e-06 0.000 2.34605e-06 1.800 2.35100e-06 1.800
+ 2.35105e-06 0.000 2.35300e-06 0.000 2.35305e-06 1.800 2.35500e-06 1.800 2.35505e-06 0.000 2.35800e-06 0.000
+ 2.35805e-06 1.800 2.35900e-06 1.800 2.35905e-06 0.000 2.36300e-06 0.000 2.36305e-06 1.800 2.36400e-06 1.800
+ 2.36405e-06 0.000 2.36500e-06 0.000 2.36505e-06 1.800 2.36600e-06 1.800 2.36605e-06 0.000 2.36700e-06 0.000
+ 2.36705e-06 1.800 2.36800e-06 1.800 2.36805e-06 0.000 2.36900e-06 0.000 2.36905e-06 1.800 2.37100e-06 1.800
+ 2.37105e-06 0.000 2.37300e-06 0.000 2.37305e-06 1.800 2.37500e-06 1.800 2.37505e-06 0.000 2.37800e-06 0.000
+ 2.37805e-06 1.800 2.38000e-06 1.800 2.38005e-06 0.000 2.38100e-06 0.000 2.38105e-06 1.800 2.38300e-06 1.800
+ 2.38305e-06 0.000 2.38400e-06 0.000 2.38405e-06 1.800 2.38500e-06 1.800 2.38505e-06 0.000 2.38600e-06 0.000
+ 2.38605e-06 1.800 2.38900e-06 1.800 2.38905e-06 0.000 2.39100e-06 0.000 2.39105e-06 1.800 2.39200e-06 1.800
+ 2.39205e-06 0.000 2.39300e-06 0.000 2.39305e-06 1.800 2.39500e-06 1.800 2.39505e-06 0.000 2.39600e-06 0.000
+ 2.39605e-06 1.800 2.39700e-06 1.800 2.39705e-06 0.000 2.39900e-06 0.000 2.39905e-06 1.800 2.40000e-06 1.800
+ 2.40005e-06 0.000 2.40200e-06 0.000 2.40205e-06 1.800 2.40300e-06 1.800 2.40305e-06 0.000 2.40700e-06 0.000
+ 2.40705e-06 1.800 2.40800e-06 1.800 2.40805e-06 0.000 2.40900e-06 0.000 2.40905e-06 1.800 2.41300e-06 1.800
+ 2.41305e-06 0.000 2.41400e-06 0.000 2.41405e-06 1.800 2.41500e-06 1.800 2.41505e-06 0.000 2.41700e-06 0.000
+ 2.41705e-06 1.800 2.41800e-06 1.800 2.41805e-06 0.000 2.41900e-06 0.000 2.41905e-06 1.800 2.42000e-06 1.800
+ 2.42005e-06 0.000 2.42400e-06 0.000 2.42405e-06 1.800 2.42700e-06 1.800 2.42705e-06 0.000 2.42800e-06 0.000
+ 2.42805e-06 1.800 2.42900e-06 1.800 2.42905e-06 0.000 2.43000e-06 0.000 2.43005e-06 1.800 2.43100e-06 1.800
+ 2.43105e-06 0.000 2.43400e-06 0.000 2.43405e-06 1.800 2.43600e-06 1.800 2.43605e-06 0.000 2.44100e-06 0.000
+ 2.44105e-06 1.800 2.44400e-06 1.800 2.44405e-06 0.000 2.44700e-06 0.000 2.44705e-06 1.800 2.44800e-06 1.800
+ 2.44805e-06 0.000 2.45000e-06 0.000 2.45005e-06 1.800 2.45100e-06 1.800 2.45105e-06 0.000 2.45200e-06 0.000
+ 2.45205e-06 1.800 2.45300e-06 1.800 2.45305e-06 0.000 2.45400e-06 0.000 2.45405e-06 1.800 2.45600e-06 1.800
+ 2.45605e-06 0.000 2.45700e-06 0.000 2.45705e-06 1.800 2.45900e-06 1.800 2.45905e-06 0.000 2.46300e-06 0.000
+ 2.46305e-06 1.800 2.46600e-06 1.800 2.46605e-06 0.000 2.46700e-06 0.000 2.46705e-06 1.800 2.46800e-06 1.800
+ 2.46805e-06 0.000 2.46900e-06 0.000 2.46905e-06 1.800 2.47100e-06 1.800 2.47105e-06 0.000 2.47300e-06 0.000
+ 2.47305e-06 1.800 2.47500e-06 1.800 2.47505e-06 0.000 2.47600e-06 0.000 2.47605e-06 1.800 2.47700e-06 1.800
+ 2.47705e-06 0.000 2.47900e-06 0.000 2.47905e-06 1.800 2.48100e-06 1.800 2.48105e-06 0.000 2.48300e-06 0.000
+ 2.48305e-06 1.800 2.48400e-06 1.800 2.48405e-06 0.000 2.48500e-06 0.000 2.48505e-06 1.800 2.48800e-06 1.800
+ 2.48805e-06 0.000 2.48900e-06 0.000 2.48905e-06 1.800 2.49000e-06 1.800 2.49005e-06 0.000 2.49100e-06 0.000
+ 2.49105e-06 1.800 2.49200e-06 1.800 2.49205e-06 0.000 2.49300e-06 0.000 2.49305e-06 1.800 2.49400e-06 1.800
+ 2.49405e-06 0.000 2.49600e-06 0.000 2.49605e-06 1.800 2.49700e-06 1.800 2.49705e-06 0.000 2.49900e-06 0.000
+ 2.49905e-06 1.800 2.50000e-06 1.800 2.50005e-06 0.000 2.50500e-06 0.000 2.50505e-06 1.800 2.50600e-06 1.800
+ 2.50605e-06 0.000 2.50900e-06 0.000 2.50905e-06 1.800 2.51200e-06 1.800 2.51205e-06 0.000 2.51400e-06 0.000
+ 2.51405e-06 1.800 2.51500e-06 1.800 2.51505e-06 0.000 2.51700e-06 0.000 2.51705e-06 1.800 2.52100e-06 1.800
+ 2.52105e-06 0.000 2.52300e-06 0.000 2.52305e-06 1.800 2.52600e-06 1.800 2.52605e-06 0.000 2.52700e-06 0.000
+ 2.52705e-06 1.800 2.53000e-06 1.800 2.53005e-06 0.000 2.53100e-06 0.000 2.53105e-06 1.800 2.53600e-06 1.800
+ 2.53605e-06 0.000 2.53700e-06 0.000 2.53705e-06 1.800 2.53900e-06 1.800 2.53905e-06 0.000 2.54000e-06 0.000
+ 2.54005e-06 1.800 2.54300e-06 1.800 2.54305e-06 0.000 2.54400e-06 0.000 2.54405e-06 1.800 2.54700e-06 1.800
+ 2.54705e-06 0.000 2.54800e-06 0.000 2.54805e-06 1.800 2.54900e-06 1.800 2.54905e-06 0.000 2.55100e-06 0.000
+ 2.55105e-06 1.800 2.55200e-06 1.800 2.55205e-06 0.000 2.55300e-06 0.000 2.55305e-06 1.800 2.55500e-06 1.800
+ 2.55505e-06 0.000 2.55600e-06 0.000 2.55605e-06 1.800 2.55700e-06 1.800 2.55705e-06 0.000 2.55800e-06 0.000
+ 2.55805e-06 1.800 2.55900e-06 1.800 2.55905e-06 0.000 2.56000e-06 0.000 2.56005e-06 1.800 2.56100e-06 1.800
+ 2.56105e-06 0.000 2.56400e-06 0.000 2.56405e-06 1.800 2.56600e-06 1.800 2.56605e-06 0.000 2.56900e-06 0.000
+ 2.56905e-06 1.800 2.57300e-06 1.800 2.57305e-06 0.000 2.57600e-06 0.000 2.57605e-06 1.800 2.57700e-06 1.800
+ 2.57705e-06 0.000 2.57800e-06 0.000 2.57805e-06 1.800 2.57900e-06 1.800 2.57905e-06 0.000 2.58000e-06 0.000
+ 2.58005e-06 1.800 2.58100e-06 1.800 2.58105e-06 0.000 2.58200e-06 0.000 2.58205e-06 1.800 2.58500e-06 1.800
+ 2.58505e-06 0.000 2.58600e-06 0.000 2.58605e-06 1.800 2.58800e-06 1.800 2.58805e-06 0.000 2.59200e-06 0.000
+ 2.59205e-06 1.800 2.59600e-06 1.800 2.59605e-06 0.000 2.59700e-06 0.000 2.59705e-06 1.800 2.59800e-06 1.800
+ 2.59805e-06 0.000 2.60000e-06 0.000 2.60005e-06 1.800 2.60100e-06 1.800 2.60105e-06 0.000 2.60300e-06 0.000
+ 2.60305e-06 1.800 2.60500e-06 1.800 2.60505e-06 0.000 2.60700e-06 0.000 2.60705e-06 1.800 2.60900e-06 1.800
+ 2.60905e-06 0.000 2.61100e-06 0.000 2.61105e-06 1.800 2.61300e-06 1.800 2.61305e-06 0.000 2.61500e-06 0.000
+ 2.61505e-06 1.800 2.61600e-06 1.800 2.61605e-06 0.000 2.61700e-06 0.000 2.61705e-06 1.800 2.61800e-06 1.800
+ 2.61805e-06 0.000 2.61900e-06 0.000 2.61905e-06 1.800 2.62100e-06 1.800 2.62105e-06 0.000 2.62200e-06 0.000
+ 2.62205e-06 1.800 2.62500e-06 1.800 2.62505e-06 0.000 2.63000e-06 0.000 2.63005e-06 1.800 2.63200e-06 1.800
+ 2.63205e-06 0.000 2.63300e-06 0.000 2.63305e-06 1.800 2.63400e-06 1.800 2.63405e-06 0.000 2.63500e-06 0.000
+ 2.63505e-06 1.800 2.63600e-06 1.800 2.63605e-06 0.000 2.63700e-06 0.000 2.63705e-06 1.800 2.63800e-06 1.800
+ 2.63805e-06 0.000 2.63900e-06 0.000 2.63905e-06 1.800 2.64000e-06 1.800 2.64005e-06 0.000 2.64200e-06 0.000
+ 2.64205e-06 1.800 2.64300e-06 1.800 2.64305e-06 0.000 2.64500e-06 0.000 2.64505e-06 1.800 2.64800e-06 1.800
+ 2.64805e-06 0.000 2.64900e-06 0.000 2.64905e-06 1.800 2.65000e-06 1.800 2.65005e-06 0.000 2.65300e-06 0.000
+ 2.65305e-06 1.800 2.65600e-06 1.800 2.65605e-06 0.000 2.65700e-06 0.000 2.65705e-06 1.800 2.66000e-06 1.800
+ 2.66005e-06 0.000 2.66200e-06 0.000 2.66205e-06 1.800 2.66400e-06 1.800 2.66405e-06 0.000 2.66800e-06 0.000
+ 2.66805e-06 1.800 2.67000e-06 1.800 2.67005e-06 0.000 2.67300e-06 0.000 2.67305e-06 1.800 2.67400e-06 1.800
+ 2.67405e-06 0.000 2.67500e-06 0.000 2.67505e-06 1.800 2.67600e-06 1.800 2.67605e-06 0.000 2.67800e-06 0.000
+ 2.67805e-06 1.800 2.68100e-06 1.800 2.68105e-06 0.000 2.68400e-06 0.000 2.68405e-06 1.800 2.68500e-06 1.800
+ 2.68505e-06 0.000 2.68700e-06 0.000 2.68705e-06 1.800 2.68800e-06 1.800 2.68805e-06 0.000 2.69200e-06 0.000
+ 2.69205e-06 1.800 2.69500e-06 1.800 2.69505e-06 0.000 2.69600e-06 0.000 2.69605e-06 1.800 2.69700e-06 1.800
+ 2.69705e-06 0.000 2.69900e-06 0.000 2.69905e-06 1.800 2.70300e-06 1.800 2.70305e-06 0.000 2.70500e-06 0.000
+ 2.70505e-06 1.800 2.70600e-06 1.800 2.70605e-06 0.000 2.70700e-06 0.000 2.70705e-06 1.800 2.70800e-06 1.800
+ 2.70805e-06 0.000 2.71100e-06 0.000 2.71105e-06 1.800 2.71200e-06 1.800 2.71205e-06 0.000 2.71300e-06 0.000
+ 2.71305e-06 1.800 2.71700e-06 1.800 2.71705e-06 0.000 2.72000e-06 0.000 2.72005e-06 1.800 2.72200e-06 1.800
+ 2.72205e-06 0.000 2.72300e-06 0.000 2.72305e-06 1.800 2.72600e-06 1.800 2.72605e-06 0.000 2.72700e-06 0.000
+ 2.72705e-06 1.800 2.72900e-06 1.800 2.72905e-06 0.000 2.73200e-06 0.000 2.73205e-06 1.800 2.73300e-06 1.800
+ 2.73305e-06 0.000 2.73400e-06 0.000 2.73405e-06 1.800 2.73700e-06 1.800 2.73705e-06 0.000 2.73800e-06 0.000
+ 2.73805e-06 1.800 2.73900e-06 1.800 2.73905e-06 0.000 2.74300e-06 0.000 2.74305e-06 1.800 2.74400e-06 1.800
+ 2.74405e-06 0.000 2.74500e-06 0.000 2.74505e-06 1.800 2.74700e-06 1.800 2.74705e-06 0.000 2.75100e-06 0.000
+ 2.75105e-06 1.800 2.75200e-06 1.800 2.75205e-06 0.000 2.75400e-06 0.000 2.75405e-06 1.800 2.75500e-06 1.800
+ 2.75505e-06 0.000 2.75600e-06 0.000 2.75605e-06 1.800 2.75800e-06 1.800 2.75805e-06 0.000 2.76000e-06 0.000
+ 2.76005e-06 1.800 2.76200e-06 1.800 2.76205e-06 0.000 2.76300e-06 0.000 2.76305e-06 1.800 2.76600e-06 1.800
+ 2.76605e-06 0.000 2.76900e-06 0.000 2.76905e-06 1.800 2.77000e-06 1.800 2.77005e-06 0.000 2.77900e-06 0.000
+ 2.77905e-06 1.800 2.78000e-06 1.800 2.78005e-06 0.000 2.78200e-06 0.000 2.78205e-06 1.800 2.78400e-06 1.800
+ 2.78405e-06 0.000 2.78500e-06 0.000 2.78505e-06 1.800 2.78600e-06 1.800 2.78605e-06 0.000 2.78800e-06 0.000
+ 2.78805e-06 1.800 2.79100e-06 1.800 2.79105e-06 0.000 2.79200e-06 0.000 2.79205e-06 1.800 2.79400e-06 1.800
+ 2.79405e-06 0.000 2.79800e-06 0.000 2.79805e-06 1.800 2.80300e-06 1.800 2.80305e-06 0.000 2.80600e-06 0.000
+ 2.80605e-06 1.800 2.80800e-06 1.800 2.80805e-06 0.000 2.81000e-06 0.000 2.81005e-06 1.800 2.81300e-06 1.800
+ 2.81305e-06 0.000 2.81500e-06 0.000 2.81505e-06 1.800 2.81800e-06 1.800 2.81805e-06 0.000 2.82000e-06 0.000
+ 2.82005e-06 1.800 2.82100e-06 1.800 2.82105e-06 0.000 2.82200e-06 0.000 2.82205e-06 1.800 2.82500e-06 1.800
+ 2.82505e-06 0.000 2.82900e-06 0.000 2.82905e-06 1.800 2.83100e-06 1.800 2.83105e-06 0.000 2.83500e-06 0.000
+ 2.83505e-06 1.800 2.83600e-06 1.800 2.83605e-06 0.000 2.83800e-06 0.000 2.83805e-06 1.800 2.83900e-06 1.800
+ 2.83905e-06 0.000 2.84000e-06 0.000 2.84005e-06 1.800 2.84100e-06 1.800 2.84105e-06 0.000 2.84200e-06 0.000
+ 2.84205e-06 1.800 2.84300e-06 1.800 2.84305e-06 0.000 2.84700e-06 0.000 2.84705e-06 1.800 2.84800e-06 1.800
+ 2.84805e-06 0.000 2.84900e-06 0.000 2.84905e-06 1.800 2.85000e-06 1.800 2.85005e-06 0.000 2.85100e-06 0.000
+ 2.85105e-06 1.800 2.85300e-06 1.800 2.85305e-06 0.000 2.85400e-06 0.000 2.85405e-06 1.800 2.85600e-06 1.800
+ 2.85605e-06 0.000 2.85700e-06 0.000 2.85705e-06 1.800 2.85800e-06 1.800 2.85805e-06 0.000 2.86000e-06 0.000
+ 2.86005e-06 1.800 2.86100e-06 1.800 2.86105e-06 0.000 2.86300e-06 0.000 2.86305e-06 1.800 2.86700e-06 1.800
+ 2.86705e-06 0.000 2.86900e-06 0.000 2.86905e-06 1.800 2.87000e-06 1.800 2.87005e-06 0.000 2.87200e-06 0.000
+ 2.87205e-06 1.800 2.87300e-06 1.800 2.87305e-06 0.000 2.87400e-06 0.000 2.87405e-06 1.800 2.87600e-06 1.800
+ 2.87605e-06 0.000 2.87700e-06 0.000 2.87705e-06 1.800 2.87800e-06 1.800 2.87805e-06 0.000 2.87900e-06 0.000
+ 2.87905e-06 1.800 2.88200e-06 1.800 2.88205e-06 0.000 2.88300e-06 0.000 2.88305e-06 1.800 2.88400e-06 1.800
+ 2.88405e-06 0.000 2.88600e-06 0.000 2.88605e-06 1.800 2.88700e-06 1.800 2.88705e-06 0.000 2.88800e-06 0.000
+ 2.88805e-06 1.800 2.89000e-06 1.800 2.89005e-06 0.000 2.89300e-06 0.000 2.89305e-06 1.800 2.89600e-06 1.800
+ 2.89605e-06 0.000 2.89700e-06 0.000 2.89705e-06 1.800 2.90100e-06 1.800 2.90105e-06 0.000 2.90200e-06 0.000
+ 2.90205e-06 1.800 2.90700e-06 1.800 2.90705e-06 0.000 2.90800e-06 0.000 2.90805e-06 1.800 2.91100e-06 1.800
+ 2.91105e-06 0.000 2.91200e-06 0.000 2.91205e-06 1.800 2.91300e-06 1.800 2.91305e-06 0.000 2.91500e-06 0.000
+ 2.91505e-06 1.800 2.91600e-06 1.800 2.91605e-06 0.000 2.91700e-06 0.000 2.91705e-06 1.800 2.91800e-06 1.800
+ 2.91805e-06 0.000 2.92000e-06 0.000 2.92005e-06 1.800 2.92300e-06 1.800 2.92305e-06 0.000 2.92500e-06 0.000
+ 2.92505e-06 1.800 2.92600e-06 1.800 2.92605e-06 0.000 2.92700e-06 0.000 2.92705e-06 1.800 2.92900e-06 1.800
+ 2.92905e-06 0.000 2.93100e-06 0.000 2.93105e-06 1.800 2.93200e-06 1.800 2.93205e-06 0.000 2.93300e-06 0.000
+ 2.93305e-06 1.800 2.93600e-06 1.800 2.93605e-06 0.000 2.93700e-06 0.000 2.93705e-06 1.800 2.93900e-06 1.800
+ 2.93905e-06 0.000 2.94500e-06 0.000 2.94505e-06 1.800 2.94600e-06 1.800 2.94605e-06 0.000 2.94700e-06 0.000
+ 2.94705e-06 1.800 2.94800e-06 1.800 2.94805e-06 0.000 2.94900e-06 0.000 2.94905e-06 1.800 2.95200e-06 1.800
+ 2.95205e-06 0.000 2.95300e-06 0.000 2.95305e-06 1.800 2.95400e-06 1.800 2.95405e-06 0.000 2.95500e-06 0.000
+ 2.95505e-06 1.800 2.95600e-06 1.800 2.95605e-06 0.000 2.95800e-06 0.000 2.95805e-06 1.800 2.96000e-06 1.800
+ 2.96005e-06 0.000 2.96100e-06 0.000 2.96105e-06 1.800 2.96300e-06 1.800 2.96305e-06 0.000 2.96500e-06 0.000
+ 2.96505e-06 1.800 2.96700e-06 1.800 2.96705e-06 0.000 2.97300e-06 0.000 2.97305e-06 1.800 2.97400e-06 1.800
+ 2.97405e-06 0.000 2.97800e-06 0.000 2.97805e-06 1.800 2.97900e-06 1.800 2.97905e-06 0.000 2.98300e-06 0.000
+ 2.98305e-06 1.800 2.98500e-06 1.800 2.98505e-06 0.000 2.98800e-06 0.000 2.98805e-06 1.800 2.99000e-06 1.800
+ 2.99005e-06 0.000 2.99100e-06 0.000 2.99105e-06 1.800 2.99300e-06 1.800 2.99305e-06 0.000 2.99500e-06 0.000
+ 2.99505e-06 1.800 2.99800e-06 1.800 2.99805e-06 0.000 3.00000e-06 0.000 3.00005e-06 1.800 3.00300e-06 1.800
+ 3.00305e-06 0.000 3.00400e-06 0.000 3.00405e-06 1.800 3.00500e-06 1.800 3.00505e-06 0.000 3.00800e-06 0.000
+ 3.00805e-06 1.800 3.00900e-06 1.800 3.00905e-06 0.000 3.01000e-06 0.000 3.01005e-06 1.800 3.01100e-06 1.800
+ 3.01105e-06 0.000 3.01200e-06 0.000 3.01205e-06 1.800 3.01600e-06 1.800 3.01605e-06 0.000 3.01800e-06 0.000
+ 3.01805e-06 1.800 3.01900e-06 1.800 3.01905e-06 0.000 3.02200e-06 0.000 3.02205e-06 1.800 3.02300e-06 1.800
+ 3.02305e-06 0.000 3.02400e-06 0.000 3.02405e-06 1.800 3.02600e-06 1.800 3.02605e-06 0.000 3.02700e-06 0.000
+ 3.02705e-06 1.800 3.03200e-06 1.800 3.03205e-06 0.000 3.03300e-06 0.000 3.03305e-06 1.800 3.03600e-06 1.800
+ 3.03605e-06 0.000 3.03700e-06 0.000 3.03705e-06 1.800 3.03800e-06 1.800 3.03805e-06 0.000 3.03900e-06 0.000
+ 3.03905e-06 1.800 3.04000e-06 1.800 3.04005e-06 0.000 3.04100e-06 0.000 3.04105e-06 1.800 3.04200e-06 1.800
+ 3.04205e-06 0.000 3.04300e-06 0.000 3.04305e-06 1.800 3.04600e-06 1.800 3.04605e-06 0.000 3.04900e-06 0.000
+ 3.04905e-06 1.800 3.05000e-06 1.800 3.05005e-06 0.000 3.05100e-06 0.000 3.05105e-06 1.800 3.05300e-06 1.800
+ 3.05305e-06 0.000 3.05400e-06 0.000 3.05405e-06 1.800 3.05500e-06 1.800 3.05505e-06 0.000 3.05600e-06 0.000
+ 3.05605e-06 1.800 3.05800e-06 1.800 3.05805e-06 0.000 3.06600e-06 0.000 3.06605e-06 1.800 3.06800e-06 1.800
+ 3.06805e-06 0.000 3.06900e-06 0.000 3.06905e-06 1.800 3.07300e-06 1.800 3.07305e-06 0.000 3.07700e-06 0.000
+ 3.07705e-06 1.800 3.07800e-06 1.800 3.07805e-06 0.000 3.07900e-06 0.000 3.07905e-06 1.800 3.08100e-06 1.800
+ 3.08105e-06 0.000 3.08200e-06 0.000 3.08205e-06 1.800 3.08300e-06 1.800 3.08305e-06 0.000 3.08700e-06 0.000
+ 3.08705e-06 1.800 3.08800e-06 1.800 3.08805e-06 0.000 3.08900e-06 0.000 3.08905e-06 1.800 3.09000e-06 1.800
+ 3.09005e-06 0.000 3.09100e-06 0.000 3.09105e-06 1.800 3.09200e-06 1.800 3.09205e-06 0.000 3.09400e-06 0.000
+ 3.09405e-06 1.800 3.09500e-06 1.800 3.09505e-06 0.000 3.09600e-06 0.000 3.09605e-06 1.800 3.09800e-06 1.800
+ 3.09805e-06 0.000 3.10000e-06 0.000 3.10005e-06 1.800 3.10400e-06 1.800 3.10405e-06 0.000 3.10500e-06 0.000
+ 3.10505e-06 1.800 3.10600e-06 1.800 3.10605e-06 0.000 3.10700e-06 0.000 3.10705e-06 1.800 3.11000e-06 1.800
+ 3.11005e-06 0.000 3.11100e-06 0.000 3.11105e-06 1.800 3.11200e-06 1.800 3.11205e-06 0.000 3.11400e-06 0.000
+ 3.11405e-06 1.800 3.11700e-06 1.800 3.11705e-06 0.000 3.11800e-06 0.000 3.11805e-06 1.800 3.11900e-06 1.800
+ 3.11905e-06 0.000 3.12000e-06 0.000 3.12005e-06 1.800 3.12100e-06 1.800 3.12105e-06 0.000 3.12300e-06 0.000
+ 3.12305e-06 1.800 3.12600e-06 1.800 3.12605e-06 0.000 3.12900e-06 0.000 3.12905e-06 1.800 3.13000e-06 1.800
+ 3.13005e-06 0.000 3.13300e-06 0.000 3.13305e-06 1.800 3.13700e-06 1.800 3.13705e-06 0.000 3.13800e-06 0.000
+ 3.13805e-06 1.800 3.14100e-06 1.800 3.14105e-06 0.000 3.14600e-06 0.000 3.14605e-06 1.800 3.14700e-06 1.800
+ 3.14705e-06 0.000 3.15100e-06 0.000 3.15105e-06 1.800 3.15200e-06 1.800 3.15205e-06 0.000 3.15400e-06 0.000
+ 3.15405e-06 1.800 3.15500e-06 1.800 3.15505e-06 0.000 3.15600e-06 0.000 3.15605e-06 1.800 3.15700e-06 1.800
+ 3.15705e-06 0.000 3.15900e-06 0.000 3.15905e-06 1.800 3.16300e-06 1.800 3.16305e-06 0.000 3.16400e-06 0.000
+ 3.16405e-06 1.800 3.16500e-06 1.800 3.16505e-06 0.000 3.16600e-06 0.000 3.16605e-06 1.800 3.16900e-06 1.800
+ 3.16905e-06 0.000 3.17100e-06 0.000 3.17105e-06 1.800 3.17300e-06 1.800 3.17305e-06 0.000 3.17500e-06 0.000
+ 3.17505e-06 1.800 3.17800e-06 1.800 3.17805e-06 0.000 3.17900e-06 0.000 3.17905e-06 1.800 3.18000e-06 1.800
+ 3.18005e-06 0.000 3.18200e-06 0.000 3.18205e-06 1.800 3.18400e-06 1.800 3.18405e-06 0.000 3.18800e-06 0.000
+ 3.18805e-06 1.800 3.18900e-06 1.800 3.18905e-06 0.000 3.19000e-06 0.000 3.19005e-06 1.800 3.19100e-06 1.800
+ 3.19105e-06 0.000 3.19600e-06 0.000 3.19605e-06 1.800 3.19700e-06 1.800 3.19705e-06 0.000 3.19800e-06 0.000
+ 3.19805e-06 1.800 3.19900e-06 1.800 3.19905e-06 0.000 3.20100e-06 0.000 3.20105e-06 1.800 3.20200e-06 1.800
+ 3.20205e-06 0.000 3.20300e-06 0.000 3.20305e-06 1.800 3.20400e-06 1.800 3.20405e-06 0.000 3.20500e-06 0.000
+ 3.20505e-06 1.800 3.20700e-06 1.800 3.20705e-06 0.000 3.20800e-06 0.000 3.20805e-06 1.800 3.20900e-06 1.800
+ 3.20905e-06 0.000 3.21300e-06 0.000 3.21305e-06 1.800 3.21500e-06 1.800 3.21505e-06 0.000 3.21600e-06 0.000
+ 3.21605e-06 1.800 3.21700e-06 1.800 3.21705e-06 0.000 3.21800e-06 0.000 3.21805e-06 1.800 3.22000e-06 1.800
+ 3.22005e-06 0.000 3.22200e-06 0.000 3.22205e-06 1.800 3.22600e-06 1.800 3.22605e-06 0.000 3.22700e-06 0.000
+ 3.22705e-06 1.800 3.22800e-06 1.800 3.22805e-06 0.000 3.23000e-06 0.000 3.23005e-06 1.800 3.23100e-06 1.800
+ 3.23105e-06 0.000 3.23200e-06 0.000 3.23205e-06 1.800 3.23800e-06 1.800 3.23805e-06 0.000 3.23900e-06 0.000
+ 3.23905e-06 1.800 3.24000e-06 1.800 3.24005e-06 0.000 3.24100e-06 0.000 3.24105e-06 1.800 3.24300e-06 1.800
+ 3.24305e-06 0.000 3.24500e-06 0.000 3.24505e-06 1.800 3.25000e-06 1.800 3.25005e-06 0.000 3.25100e-06 0.000
+ 3.25105e-06 1.800 3.25400e-06 1.800 3.25405e-06 0.000 3.25900e-06 0.000 3.25905e-06 1.800 3.26100e-06 1.800
+ 3.26105e-06 0.000 3.26200e-06 0.000 3.26205e-06 1.800 3.26300e-06 1.800 3.26305e-06 0.000 3.26400e-06 0.000
+ 3.26405e-06 1.800 3.26500e-06 1.800 3.26505e-06 0.000 3.26800e-06 0.000 3.26805e-06 1.800 3.26900e-06 1.800
+ 3.26905e-06 0.000 3.27200e-06 0.000 3.27205e-06 1.800 3.27300e-06 1.800 3.27305e-06 0.000 3.27400e-06 0.000
+ 3.27405e-06 1.800 3.27500e-06 1.800 3.27505e-06 0.000 3.27700e-06 0.000 3.27705e-06 1.800 3.27800e-06 1.800
+ 3.27805e-06 0.000 3.28000e-06 0.000 3.28005e-06 1.800 3.28200e-06 1.800 3.28205e-06 0.000 3.28300e-06 0.000
+ 3.28305e-06 1.800 3.28500e-06 1.800 3.28505e-06 0.000 3.28600e-06 0.000 3.28605e-06 1.800 3.28700e-06 1.800
+ 3.28705e-06 0.000 3.28800e-06 0.000 3.28805e-06 1.800 3.28900e-06 1.800 3.28905e-06 0.000 3.29200e-06 0.000
+ 3.29205e-06 1.800 3.29400e-06 1.800 3.29405e-06 0.000 3.29500e-06 0.000 3.29505e-06 1.800 3.29700e-06 1.800
+ 3.29705e-06 0.000 3.29800e-06 0.000 3.29805e-06 1.800 3.29900e-06 1.800 3.29905e-06 0.000 3.30000e-06 0.000
+ 3.30005e-06 1.800 3.30400e-06 1.800 3.30405e-06 0.000 3.30500e-06 0.000 3.30505e-06 1.800 3.30800e-06 1.800
+ 3.30805e-06 0.000 3.31000e-06 0.000 3.31005e-06 1.800 3.31300e-06 1.800 3.31305e-06 0.000 3.31500e-06 0.000
+ 3.31505e-06 1.800 3.31600e-06 1.800 3.31605e-06 0.000 3.31800e-06 0.000 3.31805e-06 1.800 3.32100e-06 1.800
+ 3.32105e-06 0.000 3.32400e-06 0.000 3.32405e-06 1.800 3.32600e-06 1.800 3.32605e-06 0.000 3.33500e-06 0.000
+ 3.33505e-06 1.800 3.33600e-06 1.800 3.33605e-06 0.000 3.33800e-06 0.000 3.33805e-06 1.800 3.34000e-06 1.800
+ 3.34005e-06 0.000 3.34300e-06 0.000 3.34305e-06 1.800 3.34800e-06 1.800 3.34805e-06 0.000 3.34900e-06 0.000
+ 3.34905e-06 1.800 3.35000e-06 1.800 3.35005e-06 0.000 3.35200e-06 0.000 3.35205e-06 1.800 3.35300e-06 1.800
+ 3.35305e-06 0.000 3.35400e-06 0.000 3.35405e-06 1.800 3.35500e-06 1.800 3.35505e-06 0.000 3.35600e-06 0.000
+ 3.35605e-06 1.800 3.35800e-06 1.800 3.35805e-06 0.000 3.36200e-06 0.000 3.36205e-06 1.800 3.36400e-06 1.800
+ 3.36405e-06 0.000 3.36600e-06 0.000 3.36605e-06 1.800 3.36700e-06 1.800 3.36705e-06 0.000 3.37000e-06 0.000
+ 3.37005e-06 1.800 3.37200e-06 1.800 3.37205e-06 0.000 3.37300e-06 0.000 3.37305e-06 1.800 3.37500e-06 1.800
+ 3.37505e-06 0.000 3.37600e-06 0.000 3.37605e-06 1.800 3.37700e-06 1.800 3.37705e-06 0.000 3.37900e-06 0.000
+ 3.37905e-06 1.800 3.38000e-06 1.800 3.38005e-06 0.000 3.38600e-06 0.000 3.38605e-06 1.800 3.38800e-06 1.800
+ 3.38805e-06 0.000 3.38900e-06 0.000 3.38905e-06 1.800 3.39100e-06 1.800 3.39105e-06 0.000 3.39500e-06 0.000
+ 3.39505e-06 1.800 3.39700e-06 1.800 3.39705e-06 0.000 3.39900e-06 0.000 3.39905e-06 1.800 3.40000e-06 1.800
+ 3.40005e-06 0.000 3.40100e-06 0.000 3.40105e-06 1.800 3.40200e-06 1.800 3.40205e-06 0.000 3.40500e-06 0.000
+ 3.40505e-06 1.800 3.40700e-06 1.800 3.40705e-06 0.000 3.40800e-06 0.000 3.40805e-06 1.800 3.41000e-06 1.800
+ 3.41005e-06 0.000 3.41300e-06 0.000 3.41305e-06 1.800 3.41400e-06 1.800 3.41405e-06 0.000 3.41500e-06 0.000
+ 3.41505e-06 1.800 3.41900e-06 1.800 3.41905e-06 0.000 3.42100e-06 0.000 3.42105e-06 1.800 3.42500e-06 1.800
+ 3.42505e-06 0.000 3.42900e-06 0.000 3.42905e-06 1.800 3.43000e-06 1.800 3.43005e-06 0.000 3.43100e-06 0.000
+ 3.43105e-06 1.800 3.43400e-06 1.800 3.43405e-06 0.000 3.43600e-06 0.000 3.43605e-06 1.800 3.43700e-06 1.800
+ 3.43705e-06 0.000 3.43800e-06 0.000 3.43805e-06 1.800 3.44100e-06 1.800 3.44105e-06 0.000 3.44500e-06 0.000
+ 3.44505e-06 1.800 3.44600e-06 1.800 3.44605e-06 0.000 3.45200e-06 0.000 3.45205e-06 1.800 3.45400e-06 1.800
+ 3.45405e-06 0.000 3.45500e-06 0.000 3.45505e-06 1.800 3.45600e-06 1.800 3.45605e-06 0.000 3.45800e-06 0.000
+ 3.45805e-06 1.800 3.45900e-06 1.800 3.45905e-06 0.000 3.46200e-06 0.000 3.46205e-06 1.800 3.46300e-06 1.800
+ 3.46305e-06 0.000 3.46400e-06 0.000 3.46405e-06 1.800 3.46600e-06 1.800 3.46605e-06 0.000 3.46700e-06 0.000
+ 3.46705e-06 1.800 3.46900e-06 1.800 3.46905e-06 0.000 3.47100e-06 0.000 3.47105e-06 1.800 3.47200e-06 1.800
+ 3.47205e-06 0.000 3.47300e-06 0.000 3.47305e-06 1.800 3.47600e-06 1.800 3.47605e-06 0.000 3.47800e-06 0.000
+ 3.47805e-06 1.800 3.47900e-06 1.800 3.47905e-06 0.000 3.48000e-06 0.000 3.48005e-06 1.800 3.48300e-06 1.800
+ 3.48305e-06 0.000 3.48400e-06 0.000 3.48405e-06 1.800 3.48500e-06 1.800 3.48505e-06 0.000 3.48600e-06 0.000
+ 3.48605e-06 1.800 3.48700e-06 1.800 3.48705e-06 0.000 3.49000e-06 0.000 3.49005e-06 1.800 3.49100e-06 1.800
+ 3.49105e-06 0.000 3.49400e-06 0.000 3.49405e-06 1.800 3.49600e-06 1.800 3.49605e-06 0.000 3.49800e-06 0.000
+ 3.49805e-06 1.800 3.49900e-06 1.800 3.49905e-06 0.000 3.50000e-06 0.000 3.50005e-06 1.800 3.50300e-06 1.800
+ 3.50305e-06 0.000 3.50900e-06 0.000 3.50905e-06 1.800 3.51200e-06 1.800 3.51205e-06 0.000 3.51500e-06 0.000
+ 3.51505e-06 1.800 3.51800e-06 1.800 3.51805e-06 0.000 3.51900e-06 0.000 3.51905e-06 1.800 3.52200e-06 1.800
+ 3.52205e-06 0.000 3.52700e-06 0.000 3.52705e-06 1.800 3.53100e-06 1.800 3.53105e-06 0.000 3.53300e-06 0.000
+ 3.53305e-06 1.800 3.53400e-06 1.800 3.53405e-06 0.000 3.53500e-06 0.000 3.53505e-06 1.800 3.53800e-06 1.800
+ 3.53805e-06 0.000 3.54000e-06 0.000 3.54005e-06 1.800 3.54100e-06 1.800 3.54105e-06 0.000 3.54200e-06 0.000
+ 3.54205e-06 1.800 3.54400e-06 1.800 3.54405e-06 0.000 3.54500e-06 0.000 3.54505e-06 1.800 3.54600e-06 1.800
+ 3.54605e-06 0.000 3.54800e-06 0.000 3.54805e-06 1.800 3.54900e-06 1.800 3.54905e-06 0.000 3.55100e-06 0.000
+ 3.55105e-06 1.800 3.55300e-06 1.800 3.55305e-06 0.000 3.55400e-06 0.000 3.55405e-06 1.800 3.55800e-06 1.800
+ 3.55805e-06 0.000 3.55900e-06 0.000 3.55905e-06 1.800 3.56200e-06 1.800 3.56205e-06 0.000 3.56300e-06 0.000
+ 3.56305e-06 1.800 3.56600e-06 1.800 3.56605e-06 0.000 3.56800e-06 0.000 3.56805e-06 1.800 3.56900e-06 1.800
+ 3.56905e-06 0.000 3.57000e-06 0.000 3.57005e-06 1.800 3.57300e-06 1.800 3.57305e-06 0.000 3.57400e-06 0.000
+ 3.57405e-06 1.800 3.57500e-06 1.800 3.57505e-06 0.000 3.57600e-06 0.000 3.57605e-06 1.800 3.57800e-06 1.800
+ 3.57805e-06 0.000 3.58000e-06 0.000 3.58005e-06 1.800 3.58100e-06 1.800 3.58105e-06 0.000 3.58200e-06 0.000
+ 3.58205e-06 1.800 3.58300e-06 1.800 3.58305e-06 0.000 3.58400e-06 0.000 3.58405e-06 1.800 3.58600e-06 1.800
+ 3.58605e-06 0.000 3.58900e-06 0.000 3.58905e-06 1.800 3.59100e-06 1.800 3.59105e-06 0.000 3.59200e-06 0.000
+ 3.59205e-06 1.800 3.59400e-06 1.800 3.59405e-06 0.000 3.59500e-06 0.000 3.59505e-06 1.800 3.59900e-06 1.800
+ 3.59905e-06 0.000 3.60000e-06 0.000 3.60005e-06 1.800 3.60100e-06 1.800 3.60105e-06 0.000 3.60300e-06 0.000
+ 3.60305e-06 1.800 3.60500e-06 1.800 3.60505e-06 0.000 3.60600e-06 0.000 3.60605e-06 1.800 3.60900e-06 1.800
+ 3.60905e-06 0.000 3.61300e-06 0.000 3.61305e-06 1.800 3.61500e-06 1.800 3.61505e-06 0.000 3.61600e-06 0.000
+ 3.61605e-06 1.800 3.61800e-06 1.800 3.61805e-06 0.000 3.61900e-06 0.000 3.61905e-06 1.800 3.62200e-06 1.800
+ 3.62205e-06 0.000 3.62300e-06 0.000 3.62305e-06 1.800 3.62500e-06 1.800 3.62505e-06 0.000 3.62900e-06 0.000
+ 3.62905e-06 1.800 3.63100e-06 1.800 3.63105e-06 0.000 3.63200e-06 0.000 3.63205e-06 1.800 3.63400e-06 1.800
+ 3.63405e-06 0.000 3.63600e-06 0.000 3.63605e-06 1.800 3.63800e-06 1.800 3.63805e-06 0.000 3.64200e-06 0.000
+ 3.64205e-06 1.800 3.64300e-06 1.800 3.64305e-06 0.000 3.64500e-06 0.000 3.64505e-06 1.800 3.64800e-06 1.800
+ 3.64805e-06 0.000 3.64900e-06 0.000 3.64905e-06 1.800 3.65700e-06 1.800 3.65705e-06 0.000 3.65800e-06 0.000
+ 3.65805e-06 1.800 3.66300e-06 1.800 3.66305e-06 0.000 3.66500e-06 0.000 3.66505e-06 1.800 3.66700e-06 1.800
+ 3.66705e-06 0.000 3.66900e-06 0.000 3.66905e-06 1.800 3.67000e-06 1.800 3.67005e-06 0.000 3.67100e-06 0.000
+ 3.67105e-06 1.800 3.67200e-06 1.800 3.67205e-06 0.000 3.67300e-06 0.000 3.67305e-06 1.800 3.67700e-06 1.800
+ 3.67705e-06 0.000 3.67800e-06 0.000 3.67805e-06 1.800 3.67900e-06 1.800 3.67905e-06 0.000 3.68200e-06 0.000
+ 3.68205e-06 1.800 3.68400e-06 1.800 3.68405e-06 0.000 3.68500e-06 0.000 3.68505e-06 1.800 3.69000e-06 1.800
+ 3.69005e-06 0.000 3.69100e-06 0.000 3.69105e-06 1.800 3.69700e-06 1.800 3.69705e-06 0.000 3.70100e-06 0.000
+ 3.70105e-06 1.800 3.70300e-06 1.800 3.70305e-06 0.000 3.70400e-06 0.000 3.70405e-06 1.800 3.70500e-06 1.800
+ 3.70505e-06 0.000 3.70600e-06 0.000 3.70605e-06 1.800 3.70800e-06 1.800 3.70805e-06 0.000 3.70900e-06 0.000
+ 3.70905e-06 1.800 3.71000e-06 1.800 3.71005e-06 0.000 3.71200e-06 0.000 3.71205e-06 1.800 3.71300e-06 1.800
+ 3.71305e-06 0.000 3.71400e-06 0.000 3.71405e-06 1.800 3.71500e-06 1.800 3.71505e-06 0.000 3.71900e-06 0.000
+ 3.71905e-06 1.800 3.72000e-06 1.800 3.72005e-06 0.000 3.72100e-06 0.000 3.72105e-06 1.800 3.72500e-06 1.800
+ 3.72505e-06 0.000 3.72700e-06 0.000 3.72705e-06 1.800 3.72900e-06 1.800 3.72905e-06 0.000 3.73000e-06 0.000
+ 3.73005e-06 1.800 3.73300e-06 1.800 3.73305e-06 0.000 3.73400e-06 0.000 3.73405e-06 1.800 3.73600e-06 1.800
+ 3.73605e-06 0.000 3.73800e-06 0.000 3.73805e-06 1.800 3.73900e-06 1.800 3.73905e-06 0.000 3.74100e-06 0.000
+ 3.74105e-06 1.800 3.74200e-06 1.800 3.74205e-06 0.000 3.74400e-06 0.000 3.74405e-06 1.800 3.74500e-06 1.800
+ 3.74505e-06 0.000 3.74600e-06 0.000 3.74605e-06 1.800 3.74800e-06 1.800 3.74805e-06 0.000 3.75000e-06 0.000
+ 3.75005e-06 1.800 3.75300e-06 1.800 3.75305e-06 0.000 3.75400e-06 0.000 3.75405e-06 1.800 3.75600e-06 1.800
+ 3.75605e-06 0.000 3.76000e-06 0.000 3.76005e-06 1.800 3.76500e-06 1.800 3.76505e-06 0.000 3.76600e-06 0.000
+ 3.76605e-06 1.800 3.76800e-06 1.800 3.76805e-06 0.000 3.77100e-06 0.000 3.77105e-06 1.800 3.77400e-06 1.800
+ 3.77405e-06 0.000 3.77500e-06 0.000 3.77505e-06 1.800 3.77700e-06 1.800 3.77705e-06 0.000 3.77900e-06 0.000
+ 3.77905e-06 1.800 3.78000e-06 1.800 3.78005e-06 0.000 3.78100e-06 0.000 3.78105e-06 1.800 3.78300e-06 1.800
+ 3.78305e-06 0.000 3.78500e-06 0.000 3.78505e-06 1.800 3.78800e-06 1.800 3.78805e-06 0.000 3.79200e-06 0.000
+ 3.79205e-06 1.800 3.79300e-06 1.800 3.79305e-06 0.000 3.79500e-06 0.000 3.79505e-06 1.800 3.79600e-06 1.800
+ 3.79605e-06 0.000 3.80000e-06 0.000 3.80005e-06 1.800 3.80200e-06 1.800 3.80205e-06 0.000 3.80400e-06 0.000
+ 3.80405e-06 1.800 3.80500e-06 1.800 3.80505e-06 0.000 3.80900e-06 0.000 3.80905e-06 1.800 3.81000e-06 1.800
+ 3.81005e-06 0.000 3.81200e-06 0.000 3.81205e-06 1.800 3.81300e-06 1.800 3.81305e-06 0.000 3.81400e-06 0.000
+ 3.81405e-06 1.800 3.81600e-06 1.800 3.81605e-06 0.000 3.81700e-06 0.000 3.81705e-06 1.800 3.81800e-06 1.800
+ 3.81805e-06 0.000 3.81900e-06 0.000 3.81905e-06 1.800 3.82000e-06 1.800 3.82005e-06 0.000 3.82100e-06 0.000
+ 3.82105e-06 1.800 3.82400e-06 1.800 3.82405e-06 0.000 3.82500e-06 0.000 3.82505e-06 1.800 3.82600e-06 1.800
+ 3.82605e-06 0.000 3.82700e-06 0.000 3.82705e-06 1.800 3.82800e-06 1.800 3.82805e-06 0.000 3.82900e-06 0.000
+ 3.82905e-06 1.800 3.83200e-06 1.800 3.83205e-06 0.000 3.83400e-06 0.000 3.83405e-06 1.800 3.83500e-06 1.800
+ 3.83505e-06 0.000 3.83700e-06 0.000 3.83705e-06 1.800 3.83800e-06 1.800 3.83805e-06 0.000 3.84000e-06 0.000
+ 3.84005e-06 1.800 3.84100e-06 1.800 3.84105e-06 0.000 3.84700e-06 0.000 3.84705e-06 1.800 3.85000e-06 1.800
+ 3.85005e-06 0.000 3.85100e-06 0.000 3.85105e-06 1.800 3.85200e-06 1.800 3.85205e-06 0.000 3.85300e-06 0.000
+ 3.85305e-06 1.800 3.85400e-06 1.800 3.85405e-06 0.000 3.85600e-06 0.000 3.85605e-06 1.800 3.86000e-06 1.800
+ 3.86005e-06 0.000 3.86100e-06 0.000 3.86105e-06 1.800 3.86500e-06 1.800 3.86505e-06 0.000 3.86600e-06 0.000
+ 3.86605e-06 1.800 3.86800e-06 1.800 3.86805e-06 0.000 3.86900e-06 0.000 3.86905e-06 1.800 3.87600e-06 1.800
+ 3.87605e-06 0.000 3.87700e-06 0.000 3.87705e-06 1.800 3.87900e-06 1.800 3.87905e-06 0.000 3.88200e-06 0.000
+ 3.88205e-06 1.800 3.88500e-06 1.800 3.88505e-06 0.000 3.88600e-06 0.000 3.88605e-06 1.800 3.89400e-06 1.800
+ 3.89405e-06 0.000 3.89500e-06 0.000 3.89505e-06 1.800 3.89700e-06 1.800 3.89705e-06 0.000 3.89900e-06 0.000
+ 3.89905e-06 1.800 3.90000e-06 1.800 3.90005e-06 0.000 3.90100e-06 0.000 3.90105e-06 1.800 3.90500e-06 1.800
+ 3.90505e-06 0.000 3.90600e-06 0.000 3.90605e-06 1.800 3.90700e-06 1.800 3.90705e-06 0.000 3.90900e-06 0.000
+ 3.90905e-06 1.800 3.91200e-06 1.800 3.91205e-06 0.000 3.91300e-06 0.000 3.91305e-06 1.800 3.91500e-06 1.800
+ 3.91505e-06 0.000 3.91700e-06 0.000 3.91705e-06 1.800 3.92000e-06 1.800 3.92005e-06 0.000 3.92100e-06 0.000
+ 3.92105e-06 1.800 3.92200e-06 1.800 3.92205e-06 0.000 3.92300e-06 0.000 3.92305e-06 1.800 3.92400e-06 1.800
+ 3.92405e-06 0.000 3.92600e-06 0.000 3.92605e-06 1.800 3.92700e-06 1.800 3.92705e-06 0.000 3.92900e-06 0.000
+ 3.92905e-06 1.800 3.93100e-06 1.800 3.93105e-06 0.000 3.93200e-06 0.000 3.93205e-06 1.800 3.93400e-06 1.800
+ 3.93405e-06 0.000 3.93600e-06 0.000 3.93605e-06 1.800 3.93700e-06 1.800 3.93705e-06 0.000 3.93900e-06 0.000
+ 3.93905e-06 1.800 3.94000e-06 1.800 3.94005e-06 0.000 3.94100e-06 0.000 3.94105e-06 1.800 3.94300e-06 1.800
+ 3.94305e-06 0.000 3.94400e-06 0.000 3.94405e-06 1.800 3.94500e-06 1.800 3.94505e-06 0.000 3.94900e-06 0.000
+ 3.94905e-06 1.800 3.95300e-06 1.800 3.95305e-06 0.000 3.95400e-06 0.000 3.95405e-06 1.800 3.95600e-06 1.800
+ 3.95605e-06 0.000 3.95700e-06 0.000 3.95705e-06 1.800 3.95800e-06 1.800 3.95805e-06 0.000 3.96000e-06 0.000
+ 3.96005e-06 1.800 3.96100e-06 1.800 3.96105e-06 0.000 3.96200e-06 0.000 3.96205e-06 1.800 3.96400e-06 1.800
+ 3.96405e-06 0.000 3.96500e-06 0.000 3.96505e-06 1.800 3.96800e-06 1.800 3.96805e-06 0.000 3.97000e-06 0.000
+ 3.97005e-06 1.800 3.97200e-06 1.800 3.97205e-06 0.000 3.97400e-06 0.000 3.97405e-06 1.800 3.97500e-06 1.800
+ 3.97505e-06 0.000 3.97700e-06 0.000 3.97705e-06 1.800 3.97900e-06 1.800 3.97905e-06 0.000 3.98300e-06 0.000
+ 3.98305e-06 1.800 3.98400e-06 1.800 3.98405e-06 0.000 3.98700e-06 0.000 3.98705e-06 1.800 3.99000e-06 1.800
+ 3.99005e-06 0.000 3.99100e-06 0.000 3.99105e-06 1.800 3.99200e-06 1.800 3.99205e-06 0.000 3.99300e-06 0.000
+ 3.99305e-06 1.800 3.99400e-06 1.800 3.99405e-06 0.000 3.99600e-06 0.000 3.99605e-06 1.800 3.99900e-06 1.800
+ 3.99905e-06 0.000 4.00200e-06 0.000 4.00205e-06 1.800 4.00400e-06 1.800 4.00405e-06 0.000 4.00600e-06 0.000
+ 4.00605e-06 1.800 4.00700e-06 1.800 4.00705e-06 0.000 4.01000e-06 0.000 4.01005e-06 1.800 4.01100e-06 1.800
+ 4.01105e-06 0.000 4.01200e-06 0.000 4.01205e-06 1.800 4.01500e-06 1.800 4.01505e-06 0.000 4.01800e-06 0.000
+ 4.01805e-06 1.800 4.01900e-06 1.800 4.01905e-06 0.000 4.02100e-06 0.000 4.02105e-06 1.800 4.02200e-06 1.800
+ 4.02205e-06 0.000 4.02300e-06 0.000 4.02305e-06 1.800 4.02400e-06 1.800 4.02405e-06 0.000 4.02500e-06 0.000
+ 4.02505e-06 1.800 4.02600e-06 1.800 4.02605e-06 0.000 4.02700e-06 0.000 4.02705e-06 1.800 4.02800e-06 1.800
+ 4.02805e-06 0.000 4.03400e-06 0.000 4.03405e-06 1.800 4.03500e-06 1.800 4.03505e-06 0.000 4.03600e-06 0.000
+ 4.03605e-06 1.800 4.03700e-06 1.800 4.03705e-06 0.000 4.04200e-06 0.000 4.04205e-06 1.800 4.04400e-06 1.800
+ 4.04405e-06 0.000 4.05200e-06 0.000 4.05205e-06 1.800 4.05400e-06 1.800 4.05405e-06 0.000 4.05500e-06 0.000
+ 4.05505e-06 1.800 4.05900e-06 1.800 4.05905e-06 0.000 4.06000e-06 0.000 4.06005e-06 1.800 4.06100e-06 1.800
+ 4.06105e-06 0.000 4.06200e-06 0.000 4.06205e-06 1.800 4.06300e-06 1.800 4.06305e-06 0.000 4.06400e-06 0.000
+ 4.06405e-06 1.800 4.06500e-06 1.800 4.06505e-06 0.000 4.06600e-06 0.000 4.06605e-06 1.800 4.06700e-06 1.800
+ 4.06705e-06 0.000 4.06900e-06 0.000 4.06905e-06 1.800 4.07300e-06 1.800 4.07305e-06 0.000 4.07500e-06 0.000
+ 4.07505e-06 1.800 4.07600e-06 1.800 4.07605e-06 0.000 4.07700e-06 0.000 4.07705e-06 1.800 4.07800e-06 1.800
+ 4.07805e-06 0.000 4.07900e-06 0.000 4.07905e-06 1.800 4.08000e-06 1.800 4.08005e-06 0.000 4.08100e-06 0.000
+ 4.08105e-06 1.800 4.08200e-06 1.800 4.08205e-06 0.000 4.08600e-06 0.000 4.08605e-06 1.800 4.08700e-06 1.800
+ 4.08705e-06 0.000 4.08800e-06 0.000 4.08805e-06 1.800 4.09600e-06 1.800
+ )
Xd_g1b src_g1b g1b vdd gnd tb_inv
Vt1b src_t1b gnd PWL(
+ 0.00000e+00 1.800 1.28000e-07 1.800 1.28050e-07 0.000 2.56000e-07 0.000 2.56050e-07 1.800 3.84000e-07 1.800
+ 3.84050e-07 0.000 5.12000e-07 0.000 5.12050e-07 1.800 6.40000e-07 1.800 6.40050e-07 0.000 7.68000e-07 0.000
+ 7.68050e-07 1.800 8.96000e-07 1.800 8.96050e-07 0.000 1.02400e-06 0.000 1.02405e-06 1.800 1.15200e-06 1.800
+ 1.15205e-06 0.000 1.28000e-06 0.000 1.28005e-06 1.800 1.40800e-06 1.800 1.40805e-06 0.000 1.53600e-06 0.000
+ 1.53605e-06 1.800 1.66400e-06 1.800 1.66405e-06 0.000 1.79200e-06 0.000 1.79205e-06 1.800 1.92000e-06 1.800
+ 1.92005e-06 0.000 2.05200e-06 0.000 2.05205e-06 1.800 2.05400e-06 1.800 2.05405e-06 0.000 2.05500e-06 0.000
+ 2.05505e-06 1.800 2.05600e-06 1.800 2.05605e-06 0.000 2.05700e-06 0.000 2.05705e-06 1.800 2.05800e-06 1.800
+ 2.05805e-06 0.000 2.05900e-06 0.000 2.05905e-06 1.800 2.06100e-06 1.800 2.06105e-06 0.000 2.06200e-06 0.000
+ 2.06205e-06 1.800 2.06400e-06 1.800 2.06405e-06 0.000 2.06600e-06 0.000 2.06605e-06 1.800 2.07100e-06 1.800
+ 2.07105e-06 0.000 2.07200e-06 0.000 2.07205e-06 1.800 2.07400e-06 1.800 2.07405e-06 0.000 2.07500e-06 0.000
+ 2.07505e-06 1.800 2.07700e-06 1.800 2.07705e-06 0.000 2.07800e-06 0.000 2.07805e-06 1.800 2.08100e-06 1.800
+ 2.08105e-06 0.000 2.08200e-06 0.000 2.08205e-06 1.800 2.08300e-06 1.800 2.08305e-06 0.000 2.08400e-06 0.000
+ 2.08405e-06 1.800 2.08600e-06 1.800 2.08605e-06 0.000 2.08700e-06 0.000 2.08705e-06 1.800 2.08900e-06 1.800
+ 2.08905e-06 0.000 2.09100e-06 0.000 2.09105e-06 1.800 2.09200e-06 1.800 2.09205e-06 0.000 2.09300e-06 0.000
+ 2.09305e-06 1.800 2.09400e-06 1.800 2.09405e-06 0.000 2.09500e-06 0.000 2.09505e-06 1.800 2.09600e-06 1.800
+ 2.09605e-06 0.000 2.09700e-06 0.000 2.09705e-06 1.800 2.09800e-06 1.800 2.09805e-06 0.000 2.10000e-06 0.000
+ 2.10005e-06 1.800 2.10100e-06 1.800 2.10105e-06 0.000 2.10300e-06 0.000 2.10305e-06 1.800 2.10500e-06 1.800
+ 2.10505e-06 0.000 2.10600e-06 0.000 2.10605e-06 1.800 2.11000e-06 1.800 2.11005e-06 0.000 2.11200e-06 0.000
+ 2.11205e-06 1.800 2.11500e-06 1.800 2.11505e-06 0.000 2.11600e-06 0.000 2.11605e-06 1.800 2.11700e-06 1.800
+ 2.11705e-06 0.000 2.11900e-06 0.000 2.11905e-06 1.800 2.12000e-06 1.800 2.12005e-06 0.000 2.12100e-06 0.000
+ 2.12105e-06 1.800 2.12400e-06 1.800 2.12405e-06 0.000 2.12500e-06 0.000 2.12505e-06 1.800 2.12600e-06 1.800
+ 2.12605e-06 0.000 2.12800e-06 0.000 2.12805e-06 1.800 2.13000e-06 1.800 2.13005e-06 0.000 2.13200e-06 0.000
+ 2.13205e-06 1.800 2.13400e-06 1.800 2.13405e-06 0.000 2.13600e-06 0.000 2.13605e-06 1.800 2.13700e-06 1.800
+ 2.13705e-06 0.000 2.13800e-06 0.000 2.13805e-06 1.800 2.14100e-06 1.800 2.14105e-06 0.000 2.14500e-06 0.000
+ 2.14505e-06 1.800 2.14600e-06 1.800 2.14605e-06 0.000 2.14800e-06 0.000 2.14805e-06 1.800 2.15000e-06 1.800
+ 2.15005e-06 0.000 2.15300e-06 0.000 2.15305e-06 1.800 2.15600e-06 1.800 2.15605e-06 0.000 2.15700e-06 0.000
+ 2.15705e-06 1.800 2.15800e-06 1.800 2.15805e-06 0.000 2.16000e-06 0.000 2.16005e-06 1.800 2.16100e-06 1.800
+ 2.16105e-06 0.000 2.16500e-06 0.000 2.16505e-06 1.800 2.16600e-06 1.800 2.16605e-06 0.000 2.16700e-06 0.000
+ 2.16705e-06 1.800 2.16900e-06 1.800 2.16905e-06 0.000 2.17000e-06 0.000 2.17005e-06 1.800 2.17100e-06 1.800
+ 2.17105e-06 0.000 2.17400e-06 0.000 2.17405e-06 1.800 2.17600e-06 1.800 2.17605e-06 0.000 2.18100e-06 0.000
+ 2.18105e-06 1.800 2.18300e-06 1.800 2.18305e-06 0.000 2.18400e-06 0.000 2.18405e-06 1.800 2.18600e-06 1.800
+ 2.18605e-06 0.000 2.18700e-06 0.000 2.18705e-06 1.800 2.18800e-06 1.800 2.18805e-06 0.000 2.18900e-06 0.000
+ 2.18905e-06 1.800 2.19000e-06 1.800 2.19005e-06 0.000 2.19100e-06 0.000 2.19105e-06 1.800 2.19400e-06 1.800
+ 2.19405e-06 0.000 2.19500e-06 0.000 2.19505e-06 1.800 2.19600e-06 1.800 2.19605e-06 0.000 2.20000e-06 0.000
+ 2.20005e-06 1.800 2.20200e-06 1.800 2.20205e-06 0.000 2.20400e-06 0.000 2.20405e-06 1.800 2.20500e-06 1.800
+ 2.20505e-06 0.000 2.20700e-06 0.000 2.20705e-06 1.800 2.20800e-06 1.800 2.20805e-06 0.000 2.21000e-06 0.000
+ 2.21005e-06 1.800 2.21100e-06 1.800 2.21105e-06 0.000 2.21500e-06 0.000 2.21505e-06 1.800 2.21900e-06 1.800
+ 2.21905e-06 0.000 2.22000e-06 0.000 2.22005e-06 1.800 2.22200e-06 1.800 2.22205e-06 0.000 2.22400e-06 0.000
+ 2.22405e-06 1.800 2.22800e-06 1.800 2.22805e-06 0.000 2.23000e-06 0.000 2.23005e-06 1.800 2.23100e-06 1.800
+ 2.23105e-06 0.000 2.23200e-06 0.000 2.23205e-06 1.800 2.23300e-06 1.800 2.23305e-06 0.000 2.23400e-06 0.000
+ 2.23405e-06 1.800 2.23600e-06 1.800 2.23605e-06 0.000 2.23700e-06 0.000 2.23705e-06 1.800 2.24000e-06 1.800
+ 2.24005e-06 0.000 2.24200e-06 0.000 2.24205e-06 1.800 2.24400e-06 1.800 2.24405e-06 0.000 2.24600e-06 0.000
+ 2.24605e-06 1.800 2.24800e-06 1.800 2.24805e-06 0.000 2.25200e-06 0.000 2.25205e-06 1.800 2.25300e-06 1.800
+ 2.25305e-06 0.000 2.25400e-06 0.000 2.25405e-06 1.800 2.25500e-06 1.800 2.25505e-06 0.000 2.25800e-06 0.000
+ 2.25805e-06 1.800 2.26100e-06 1.800 2.26105e-06 0.000 2.26300e-06 0.000 2.26305e-06 1.800 2.26500e-06 1.800
+ 2.26505e-06 0.000 2.26900e-06 0.000 2.26905e-06 1.800 2.27200e-06 1.800 2.27205e-06 0.000 2.27700e-06 0.000
+ 2.27705e-06 1.800 2.27900e-06 1.800 2.27905e-06 0.000 2.28000e-06 0.000 2.28005e-06 1.800 2.28500e-06 1.800
+ 2.28505e-06 0.000 2.28600e-06 0.000 2.28605e-06 1.800 2.28900e-06 1.800 2.28905e-06 0.000 2.29000e-06 0.000
+ 2.29005e-06 1.800 2.29100e-06 1.800 2.29105e-06 0.000 2.29300e-06 0.000 2.29305e-06 1.800 2.29400e-06 1.800
+ 2.29405e-06 0.000 2.29500e-06 0.000 2.29505e-06 1.800 2.29900e-06 1.800 2.29905e-06 0.000 2.30000e-06 0.000
+ 2.30005e-06 1.800 2.30200e-06 1.800 2.30205e-06 0.000 2.30300e-06 0.000 2.30305e-06 1.800 2.30500e-06 1.800
+ 2.30505e-06 0.000 2.30800e-06 0.000 2.30805e-06 1.800 2.31000e-06 1.800 2.31005e-06 0.000 2.31100e-06 0.000
+ 2.31105e-06 1.800 2.31500e-06 1.800 2.31505e-06 0.000 2.31600e-06 0.000 2.31605e-06 1.800 2.32100e-06 1.800
+ 2.32105e-06 0.000 2.32300e-06 0.000 2.32305e-06 1.800 2.32400e-06 1.800 2.32405e-06 0.000 2.32500e-06 0.000
+ 2.32505e-06 1.800 2.32900e-06 1.800 2.32905e-06 0.000 2.33100e-06 0.000 2.33105e-06 1.800 2.33300e-06 1.800
+ 2.33305e-06 0.000 2.33400e-06 0.000 2.33405e-06 1.800 2.33600e-06 1.800 2.33605e-06 0.000 2.34000e-06 0.000
+ 2.34005e-06 1.800 2.34100e-06 1.800 2.34105e-06 0.000 2.34300e-06 0.000 2.34305e-06 1.800 2.34600e-06 1.800
+ 2.34605e-06 0.000 2.34800e-06 0.000 2.34805e-06 1.800 2.35100e-06 1.800 2.35105e-06 0.000 2.35200e-06 0.000
+ 2.35205e-06 1.800 2.35500e-06 1.800 2.35505e-06 0.000 2.35600e-06 0.000 2.35605e-06 1.800 2.35800e-06 1.800
+ 2.35805e-06 0.000 2.36000e-06 0.000 2.36005e-06 1.800 2.36100e-06 1.800 2.36105e-06 0.000 2.36200e-06 0.000
+ 2.36205e-06 1.800 2.36400e-06 1.800 2.36405e-06 0.000 2.36500e-06 0.000 2.36505e-06 1.800 2.36700e-06 1.800
+ 2.36705e-06 0.000 2.36900e-06 0.000 2.36905e-06 1.800 2.37200e-06 1.800 2.37205e-06 0.000 2.37300e-06 0.000
+ 2.37305e-06 1.800 2.37400e-06 1.800 2.37405e-06 0.000 2.37800e-06 0.000 2.37805e-06 1.800 2.37900e-06 1.800
+ 2.37905e-06 0.000 2.38500e-06 0.000 2.38505e-06 1.800 2.38800e-06 1.800 2.38805e-06 0.000 2.38900e-06 0.000
+ 2.38905e-06 1.800 2.39100e-06 1.800 2.39105e-06 0.000 2.39300e-06 0.000 2.39305e-06 1.800 2.39500e-06 1.800
+ 2.39505e-06 0.000 2.39900e-06 0.000 2.39905e-06 1.800 2.40100e-06 1.800 2.40105e-06 0.000 2.40200e-06 0.000
+ 2.40205e-06 1.800 2.40300e-06 1.800 2.40305e-06 0.000 2.40500e-06 0.000 2.40505e-06 1.800 2.40700e-06 1.800
+ 2.40705e-06 0.000 2.41200e-06 0.000 2.41205e-06 1.800 2.41300e-06 1.800 2.41305e-06 0.000 2.41600e-06 0.000
+ 2.41605e-06 1.800 2.41700e-06 1.800 2.41705e-06 0.000 2.42000e-06 0.000 2.42005e-06 1.800 2.42100e-06 1.800
+ 2.42105e-06 0.000 2.42300e-06 0.000 2.42305e-06 1.800 2.42400e-06 1.800 2.42405e-06 0.000 2.42500e-06 0.000
+ 2.42505e-06 1.800 2.42900e-06 1.800 2.42905e-06 0.000 2.43100e-06 0.000 2.43105e-06 1.800 2.43300e-06 1.800
+ 2.43305e-06 0.000 2.43400e-06 0.000 2.43405e-06 1.800 2.43600e-06 1.800 2.43605e-06 0.000 2.44000e-06 0.000
+ 2.44005e-06 1.800 2.44100e-06 1.800 2.44105e-06 0.000 2.44200e-06 0.000 2.44205e-06 1.800 2.44800e-06 1.800
+ 2.44805e-06 0.000 2.44900e-06 0.000 2.44905e-06 1.800 2.45500e-06 1.800 2.45505e-06 0.000 2.45600e-06 0.000
+ 2.45605e-06 1.800 2.45700e-06 1.800 2.45705e-06 0.000 2.46100e-06 0.000 2.46105e-06 1.800 2.46200e-06 1.800
+ 2.46205e-06 0.000 2.46300e-06 0.000 2.46305e-06 1.800 2.46700e-06 1.800 2.46705e-06 0.000 2.46800e-06 0.000
+ 2.46805e-06 1.800 2.46900e-06 1.800 2.46905e-06 0.000 2.47000e-06 0.000 2.47005e-06 1.800 2.47200e-06 1.800
+ 2.47205e-06 0.000 2.47400e-06 0.000 2.47405e-06 1.800 2.47500e-06 1.800 2.47505e-06 0.000 2.47700e-06 0.000
+ 2.47705e-06 1.800 2.47800e-06 1.800 2.47805e-06 0.000 2.47900e-06 0.000 2.47905e-06 1.800 2.48100e-06 1.800
+ 2.48105e-06 0.000 2.48400e-06 0.000 2.48405e-06 1.800 2.48500e-06 1.800 2.48505e-06 0.000 2.48600e-06 0.000
+ 2.48605e-06 1.800 2.48700e-06 1.800 2.48705e-06 0.000 2.48800e-06 0.000 2.48805e-06 1.800 2.48900e-06 1.800
+ 2.48905e-06 0.000 2.49100e-06 0.000 2.49105e-06 1.800 2.49200e-06 1.800 2.49205e-06 0.000 2.49300e-06 0.000
+ 2.49305e-06 1.800 2.49400e-06 1.800 2.49405e-06 0.000 2.49500e-06 0.000 2.49505e-06 1.800 2.49600e-06 1.800
+ 2.49605e-06 0.000 2.49700e-06 0.000 2.49705e-06 1.800 2.49900e-06 1.800 2.49905e-06 0.000 2.50100e-06 0.000
+ 2.50105e-06 1.800 2.50200e-06 1.800 2.50205e-06 0.000 2.50300e-06 0.000 2.50305e-06 1.800 2.50700e-06 1.800
+ 2.50705e-06 0.000 2.50900e-06 0.000 2.50905e-06 1.800 2.51000e-06 1.800 2.51005e-06 0.000 2.51100e-06 0.000
+ 2.51105e-06 1.800 2.51200e-06 1.800 2.51205e-06 0.000 2.51300e-06 0.000 2.51305e-06 1.800 2.51700e-06 1.800
+ 2.51705e-06 0.000 2.52100e-06 0.000 2.52105e-06 1.800 2.52200e-06 1.800 2.52205e-06 0.000 2.52300e-06 0.000
+ 2.52305e-06 1.800 2.52400e-06 1.800 2.52405e-06 0.000 2.52500e-06 0.000 2.52505e-06 1.800 2.52600e-06 1.800
+ 2.52605e-06 0.000 2.52900e-06 0.000 2.52905e-06 1.800 2.53300e-06 1.800 2.53305e-06 0.000 2.53400e-06 0.000
+ 2.53405e-06 1.800 2.53500e-06 1.800 2.53505e-06 0.000 2.53700e-06 0.000 2.53705e-06 1.800 2.53900e-06 1.800
+ 2.53905e-06 0.000 2.54000e-06 0.000 2.54005e-06 1.800 2.54100e-06 1.800 2.54105e-06 0.000 2.54400e-06 0.000
+ 2.54405e-06 1.800 2.55100e-06 1.800 2.55105e-06 0.000 2.55200e-06 0.000 2.55205e-06 1.800 2.55700e-06 1.800
+ 2.55705e-06 0.000 2.56400e-06 0.000 2.56405e-06 1.800 2.56900e-06 1.800 2.56905e-06 0.000 2.57000e-06 0.000
+ 2.57005e-06 1.800 2.57100e-06 1.800 2.57105e-06 0.000 2.57700e-06 0.000 2.57705e-06 1.800 2.58200e-06 1.800
+ 2.58205e-06 0.000 2.58300e-06 0.000 2.58305e-06 1.800 2.58500e-06 1.800 2.58505e-06 0.000 2.58700e-06 0.000
+ 2.58705e-06 1.800 2.58800e-06 1.800 2.58805e-06 0.000 2.59000e-06 0.000 2.59005e-06 1.800 2.59200e-06 1.800
+ 2.59205e-06 0.000 2.59500e-06 0.000 2.59505e-06 1.800 2.59600e-06 1.800 2.59605e-06 0.000 2.59700e-06 0.000
+ 2.59705e-06 1.800 2.59900e-06 1.800 2.59905e-06 0.000 2.60100e-06 0.000 2.60105e-06 1.800 2.60200e-06 1.800
+ 2.60205e-06 0.000 2.60400e-06 0.000 2.60405e-06 1.800 2.60700e-06 1.800 2.60705e-06 0.000 2.60900e-06 0.000
+ 2.60905e-06 1.800 2.61000e-06 1.800 2.61005e-06 0.000 2.61200e-06 0.000 2.61205e-06 1.800 2.61300e-06 1.800
+ 2.61305e-06 0.000 2.61500e-06 0.000 2.61505e-06 1.800 2.61800e-06 1.800 2.61805e-06 0.000 2.61900e-06 0.000
+ 2.61905e-06 1.800 2.62000e-06 1.800 2.62005e-06 0.000 2.62500e-06 0.000 2.62505e-06 1.800 2.62600e-06 1.800
+ 2.62605e-06 0.000 2.62700e-06 0.000 2.62705e-06 1.800 2.62900e-06 1.800 2.62905e-06 0.000 2.63400e-06 0.000
+ 2.63405e-06 1.800 2.63500e-06 1.800 2.63505e-06 0.000 2.63800e-06 0.000 2.63805e-06 1.800 2.63900e-06 1.800
+ 2.63905e-06 0.000 2.64000e-06 0.000 2.64005e-06 1.800 2.64100e-06 1.800 2.64105e-06 0.000 2.64200e-06 0.000
+ 2.64205e-06 1.800 2.64300e-06 1.800 2.64305e-06 0.000 2.64500e-06 0.000 2.64505e-06 1.800 2.64900e-06 1.800
+ 2.64905e-06 0.000 2.65000e-06 0.000 2.65005e-06 1.800 2.65500e-06 1.800 2.65505e-06 0.000 2.65700e-06 0.000
+ 2.65705e-06 1.800 2.65900e-06 1.800 2.65905e-06 0.000 2.66400e-06 0.000 2.66405e-06 1.800 2.66500e-06 1.800
+ 2.66505e-06 0.000 2.66600e-06 0.000 2.66605e-06 1.800 2.66700e-06 1.800 2.66705e-06 0.000 2.66900e-06 0.000
+ 2.66905e-06 1.800 2.67000e-06 1.800 2.67005e-06 0.000 2.67200e-06 0.000 2.67205e-06 1.800 2.67500e-06 1.800
+ 2.67505e-06 0.000 2.67800e-06 0.000 2.67805e-06 1.800 2.67900e-06 1.800 2.67905e-06 0.000 2.68100e-06 0.000
+ 2.68105e-06 1.800 2.68200e-06 1.800 2.68205e-06 0.000 2.68300e-06 0.000 2.68305e-06 1.800 2.68500e-06 1.800
+ 2.68505e-06 0.000 2.68600e-06 0.000 2.68605e-06 1.800 2.68700e-06 1.800 2.68705e-06 0.000 2.68800e-06 0.000
+ 2.68805e-06 1.800 2.69000e-06 1.800 2.69005e-06 0.000 2.69400e-06 0.000 2.69405e-06 1.800 2.69500e-06 1.800
+ 2.69505e-06 0.000 2.69600e-06 0.000 2.69605e-06 1.800 2.69700e-06 1.800 2.69705e-06 0.000 2.69900e-06 0.000
+ 2.69905e-06 1.800 2.70300e-06 1.800 2.70305e-06 0.000 2.70400e-06 0.000 2.70405e-06 1.800 2.70500e-06 1.800
+ 2.70505e-06 0.000 2.70900e-06 0.000 2.70905e-06 1.800 2.71200e-06 1.800 2.71205e-06 0.000 2.71300e-06 0.000
+ 2.71305e-06 1.800 2.71400e-06 1.800 2.71405e-06 0.000 2.71700e-06 0.000 2.71705e-06 1.800 2.71800e-06 1.800
+ 2.71805e-06 0.000 2.71900e-06 0.000 2.71905e-06 1.800 2.72000e-06 1.800 2.72005e-06 0.000 2.72100e-06 0.000
+ 2.72105e-06 1.800 2.72200e-06 1.800 2.72205e-06 0.000 2.72300e-06 0.000 2.72305e-06 1.800 2.72500e-06 1.800
+ 2.72505e-06 0.000 2.72600e-06 0.000 2.72605e-06 1.800 2.72700e-06 1.800 2.72705e-06 0.000 2.73000e-06 0.000
+ 2.73005e-06 1.800 2.73200e-06 1.800 2.73205e-06 0.000 2.73300e-06 0.000 2.73305e-06 1.800 2.73700e-06 1.800
+ 2.73705e-06 0.000 2.74200e-06 0.000 2.74205e-06 1.800 2.74300e-06 1.800 2.74305e-06 0.000 2.74500e-06 0.000
+ 2.74505e-06 1.800 2.74600e-06 1.800 2.74605e-06 0.000 2.74700e-06 0.000 2.74705e-06 1.800 2.74800e-06 1.800
+ 2.74805e-06 0.000 2.74900e-06 0.000 2.74905e-06 1.800 2.75000e-06 1.800 2.75005e-06 0.000 2.75100e-06 0.000
+ 2.75105e-06 1.800 2.75600e-06 1.800 2.75605e-06 0.000 2.75800e-06 0.000 2.75805e-06 1.800 2.75900e-06 1.800
+ 2.75905e-06 0.000 2.76200e-06 0.000 2.76205e-06 1.800 2.76300e-06 1.800 2.76305e-06 0.000 2.77000e-06 0.000
+ 2.77005e-06 1.800 2.77100e-06 1.800 2.77105e-06 0.000 2.77200e-06 0.000 2.77205e-06 1.800 2.77500e-06 1.800
+ 2.77505e-06 0.000 2.77600e-06 0.000 2.77605e-06 1.800 2.77700e-06 1.800 2.77705e-06 0.000 2.78000e-06 0.000
+ 2.78005e-06 1.800 2.78100e-06 1.800 2.78105e-06 0.000 2.78400e-06 0.000 2.78405e-06 1.800 2.78500e-06 1.800
+ 2.78505e-06 0.000 2.78700e-06 0.000 2.78705e-06 1.800 2.78800e-06 1.800 2.78805e-06 0.000 2.78900e-06 0.000
+ 2.78905e-06 1.800 2.79000e-06 1.800 2.79005e-06 0.000 2.79100e-06 0.000 2.79105e-06 1.800 2.79300e-06 1.800
+ 2.79305e-06 0.000 2.79400e-06 0.000 2.79405e-06 1.800 2.79500e-06 1.800 2.79505e-06 0.000 2.79600e-06 0.000
+ 2.79605e-06 1.800 2.79700e-06 1.800 2.79705e-06 0.000 2.79800e-06 0.000 2.79805e-06 1.800 2.80100e-06 1.800
+ 2.80105e-06 0.000 2.80200e-06 0.000 2.80205e-06 1.800 2.80300e-06 1.800 2.80305e-06 0.000 2.80700e-06 0.000
+ 2.80705e-06 1.800 2.80800e-06 1.800 2.80805e-06 0.000 2.81000e-06 0.000 2.81005e-06 1.800 2.81100e-06 1.800
+ 2.81105e-06 0.000 2.81200e-06 0.000 2.81205e-06 1.800 2.81300e-06 1.800 2.81305e-06 0.000 2.81400e-06 0.000
+ 2.81405e-06 1.800 2.81600e-06 1.800 2.81605e-06 0.000 2.81700e-06 0.000 2.81705e-06 1.800 2.81800e-06 1.800
+ 2.81805e-06 0.000 2.81900e-06 0.000 2.81905e-06 1.800 2.82100e-06 1.800 2.82105e-06 0.000 2.82200e-06 0.000
+ 2.82205e-06 1.800 2.82300e-06 1.800 2.82305e-06 0.000 2.82400e-06 0.000 2.82405e-06 1.800 2.82600e-06 1.800
+ 2.82605e-06 0.000 2.82700e-06 0.000 2.82705e-06 1.800 2.82800e-06 1.800 2.82805e-06 0.000 2.83000e-06 0.000
+ 2.83005e-06 1.800 2.83100e-06 1.800 2.83105e-06 0.000 2.83200e-06 0.000 2.83205e-06 1.800 2.83300e-06 1.800
+ 2.83305e-06 0.000 2.83400e-06 0.000 2.83405e-06 1.800 2.83500e-06 1.800 2.83505e-06 0.000 2.83700e-06 0.000
+ 2.83705e-06 1.800 2.83900e-06 1.800 2.83905e-06 0.000 2.84000e-06 0.000 2.84005e-06 1.800 2.84100e-06 1.800
+ 2.84105e-06 0.000 2.84200e-06 0.000 2.84205e-06 1.800 2.84500e-06 1.800 2.84505e-06 0.000 2.84600e-06 0.000
+ 2.84605e-06 1.800 2.84700e-06 1.800 2.84705e-06 0.000 2.84800e-06 0.000 2.84805e-06 1.800 2.84900e-06 1.800
+ 2.84905e-06 0.000 2.85000e-06 0.000 2.85005e-06 1.800 2.85100e-06 1.800 2.85105e-06 0.000 2.85300e-06 0.000
+ 2.85305e-06 1.800 2.85400e-06 1.800 2.85405e-06 0.000 2.85500e-06 0.000 2.85505e-06 1.800 2.85600e-06 1.800
+ 2.85605e-06 0.000 2.86000e-06 0.000 2.86005e-06 1.800 2.86100e-06 1.800 2.86105e-06 0.000 2.86200e-06 0.000
+ 2.86205e-06 1.800 2.86400e-06 1.800 2.86405e-06 0.000 2.86800e-06 0.000 2.86805e-06 1.800 2.87000e-06 1.800
+ 2.87005e-06 0.000 2.87200e-06 0.000 2.87205e-06 1.800 2.87300e-06 1.800 2.87305e-06 0.000 2.87400e-06 0.000
+ 2.87405e-06 1.800 2.87500e-06 1.800 2.87505e-06 0.000 2.87700e-06 0.000 2.87705e-06 1.800 2.88200e-06 1.800
+ 2.88205e-06 0.000 2.88300e-06 0.000 2.88305e-06 1.800 2.88400e-06 1.800 2.88405e-06 0.000 2.88600e-06 0.000
+ 2.88605e-06 1.800 2.88900e-06 1.800 2.88905e-06 0.000 2.89000e-06 0.000 2.89005e-06 1.800 2.89100e-06 1.800
+ 2.89105e-06 0.000 2.89200e-06 0.000 2.89205e-06 1.800 2.89500e-06 1.800 2.89505e-06 0.000 2.89900e-06 0.000
+ 2.89905e-06 1.800 2.90000e-06 1.800 2.90005e-06 0.000 2.90100e-06 0.000 2.90105e-06 1.800 2.90200e-06 1.800
+ 2.90205e-06 0.000 2.90600e-06 0.000 2.90605e-06 1.800 2.90800e-06 1.800 2.90805e-06 0.000 2.91300e-06 0.000
+ 2.91305e-06 1.800 2.91400e-06 1.800 2.91405e-06 0.000 2.91500e-06 0.000 2.91505e-06 1.800 2.91600e-06 1.800
+ 2.91605e-06 0.000 2.91700e-06 0.000 2.91705e-06 1.800 2.92000e-06 1.800 2.92005e-06 0.000 2.92100e-06 0.000
+ 2.92105e-06 1.800 2.92200e-06 1.800 2.92205e-06 0.000 2.92600e-06 0.000 2.92605e-06 1.800 2.92800e-06 1.800
+ 2.92805e-06 0.000 2.93000e-06 0.000 2.93005e-06 1.800 2.93100e-06 1.800 2.93105e-06 0.000 2.93200e-06 0.000
+ 2.93205e-06 1.800 2.93800e-06 1.800 2.93805e-06 0.000 2.93900e-06 0.000 2.93905e-06 1.800 2.94000e-06 1.800
+ 2.94005e-06 0.000 2.94200e-06 0.000 2.94205e-06 1.800 2.94400e-06 1.800 2.94405e-06 0.000 2.94500e-06 0.000
+ 2.94505e-06 1.800 2.94700e-06 1.800 2.94705e-06 0.000 2.94800e-06 0.000 2.94805e-06 1.800 2.94900e-06 1.800
+ 2.94905e-06 0.000 2.95300e-06 0.000 2.95305e-06 1.800 2.95600e-06 1.800 2.95605e-06 0.000 2.95900e-06 0.000
+ 2.95905e-06 1.800 2.96100e-06 1.800 2.96105e-06 0.000 2.96300e-06 0.000 2.96305e-06 1.800 2.96500e-06 1.800
+ 2.96505e-06 0.000 2.96600e-06 0.000 2.96605e-06 1.800 2.97100e-06 1.800 2.97105e-06 0.000 2.97200e-06 0.000
+ 2.97205e-06 1.800 2.97300e-06 1.800 2.97305e-06 0.000 2.97600e-06 0.000 2.97605e-06 1.800 2.97700e-06 1.800
+ 2.97705e-06 0.000 2.97900e-06 0.000 2.97905e-06 1.800 2.98000e-06 1.800 2.98005e-06 0.000 2.98400e-06 0.000
+ 2.98405e-06 1.800 2.98700e-06 1.800 2.98705e-06 0.000 2.98800e-06 0.000 2.98805e-06 1.800 2.98900e-06 1.800
+ 2.98905e-06 0.000 2.99200e-06 0.000 2.99205e-06 1.800 2.99400e-06 1.800 2.99405e-06 0.000 2.99600e-06 0.000
+ 2.99605e-06 1.800 2.99700e-06 1.800 2.99705e-06 0.000 2.99900e-06 0.000 2.99905e-06 1.800 3.00000e-06 1.800
+ 3.00005e-06 0.000 3.00200e-06 0.000 3.00205e-06 1.800 3.00300e-06 1.800 3.00305e-06 0.000 3.00400e-06 0.000
+ 3.00405e-06 1.800 3.00500e-06 1.800 3.00505e-06 0.000 3.00700e-06 0.000 3.00705e-06 1.800 3.01000e-06 1.800
+ 3.01005e-06 0.000 3.01200e-06 0.000 3.01205e-06 1.800 3.01500e-06 1.800 3.01505e-06 0.000 3.01600e-06 0.000
+ 3.01605e-06 1.800 3.01700e-06 1.800 3.01705e-06 0.000 3.01800e-06 0.000 3.01805e-06 1.800 3.01900e-06 1.800
+ 3.01905e-06 0.000 3.02100e-06 0.000 3.02105e-06 1.800 3.02600e-06 1.800 3.02605e-06 0.000 3.02700e-06 0.000
+ 3.02705e-06 1.800 3.02800e-06 1.800 3.02805e-06 0.000 3.03300e-06 0.000 3.03305e-06 1.800 3.03400e-06 1.800
+ 3.03405e-06 0.000 3.03600e-06 0.000 3.03605e-06 1.800 3.04000e-06 1.800 3.04005e-06 0.000 3.04100e-06 0.000
+ 3.04105e-06 1.800 3.04400e-06 1.800 3.04405e-06 0.000 3.04500e-06 0.000 3.04505e-06 1.800 3.04600e-06 1.800
+ 3.04605e-06 0.000 3.04800e-06 0.000 3.04805e-06 1.800 3.04900e-06 1.800 3.04905e-06 0.000 3.05000e-06 0.000
+ 3.05005e-06 1.800 3.05100e-06 1.800 3.05105e-06 0.000 3.05200e-06 0.000 3.05205e-06 1.800 3.05300e-06 1.800
+ 3.05305e-06 0.000 3.05600e-06 0.000 3.05605e-06 1.800 3.05800e-06 1.800 3.05805e-06 0.000 3.05900e-06 0.000
+ 3.05905e-06 1.800 3.06100e-06 1.800 3.06105e-06 0.000 3.06300e-06 0.000 3.06305e-06 1.800 3.06800e-06 1.800
+ 3.06805e-06 0.000 3.07100e-06 0.000 3.07105e-06 1.800 3.07400e-06 1.800 3.07405e-06 0.000 3.07600e-06 0.000
+ 3.07605e-06 1.800 3.07700e-06 1.800 3.07705e-06 0.000 3.07800e-06 0.000 3.07805e-06 1.800 3.08200e-06 1.800
+ 3.08205e-06 0.000 3.08300e-06 0.000 3.08305e-06 1.800 3.08900e-06 1.800 3.08905e-06 0.000 3.09000e-06 0.000
+ 3.09005e-06 1.800 3.09200e-06 1.800 3.09205e-06 0.000 3.09400e-06 0.000 3.09405e-06 1.800 3.09500e-06 1.800
+ 3.09505e-06 0.000 3.10000e-06 0.000 3.10005e-06 1.800 3.10200e-06 1.800 3.10205e-06 0.000 3.10300e-06 0.000
+ 3.10305e-06 1.800 3.10400e-06 1.800 3.10405e-06 0.000 3.10600e-06 0.000 3.10605e-06 1.800 3.10700e-06 1.800
+ 3.10705e-06 0.000 3.10800e-06 0.000 3.10805e-06 1.800 3.11000e-06 1.800 3.11005e-06 0.000 3.11100e-06 0.000
+ 3.11105e-06 1.800 3.11400e-06 1.800 3.11405e-06 0.000 3.11500e-06 0.000 3.11505e-06 1.800 3.11600e-06 1.800
+ 3.11605e-06 0.000 3.11700e-06 0.000 3.11705e-06 1.800 3.11900e-06 1.800 3.11905e-06 0.000 3.12000e-06 0.000
+ 3.12005e-06 1.800 3.12400e-06 1.800 3.12405e-06 0.000 3.12600e-06 0.000 3.12605e-06 1.800 3.12800e-06 1.800
+ 3.12805e-06 0.000 3.12900e-06 0.000 3.12905e-06 1.800 3.13100e-06 1.800 3.13105e-06 0.000 3.13300e-06 0.000
+ 3.13305e-06 1.800 3.13600e-06 1.800 3.13605e-06 0.000 3.14600e-06 0.000 3.14605e-06 1.800 3.14700e-06 1.800
+ 3.14705e-06 0.000 3.14900e-06 0.000 3.14905e-06 1.800 3.15300e-06 1.800 3.15305e-06 0.000 3.15700e-06 0.000
+ 3.15705e-06 1.800 3.16000e-06 1.800 3.16005e-06 0.000 3.16200e-06 0.000 3.16205e-06 1.800 3.16300e-06 1.800
+ 3.16305e-06 0.000 3.16400e-06 0.000 3.16405e-06 1.800 3.16500e-06 1.800 3.16505e-06 0.000 3.16600e-06 0.000
+ 3.16605e-06 1.800 3.16800e-06 1.800 3.16805e-06 0.000 3.17300e-06 0.000 3.17305e-06 1.800 3.17400e-06 1.800
+ 3.17405e-06 0.000 3.18100e-06 0.000 3.18105e-06 1.800 3.18300e-06 1.800 3.18305e-06 0.000 3.18500e-06 0.000
+ 3.18505e-06 1.800 3.18600e-06 1.800 3.18605e-06 0.000 3.18700e-06 0.000 3.18705e-06 1.800 3.19200e-06 1.800
+ 3.19205e-06 0.000 3.19300e-06 0.000 3.19305e-06 1.800 3.19400e-06 1.800 3.19405e-06 0.000 3.19500e-06 0.000
+ 3.19505e-06 1.800 3.19600e-06 1.800 3.19605e-06 0.000 3.20000e-06 0.000 3.20005e-06 1.800 3.20100e-06 1.800
+ 3.20105e-06 0.000 3.20800e-06 0.000 3.20805e-06 1.800 3.21500e-06 1.800 3.21505e-06 0.000 3.21600e-06 0.000
+ 3.21605e-06 1.800 3.21700e-06 1.800 3.21705e-06 0.000 3.21800e-06 0.000 3.21805e-06 1.800 3.22100e-06 1.800
+ 3.22105e-06 0.000 3.22300e-06 0.000 3.22305e-06 1.800 3.22400e-06 1.800 3.22405e-06 0.000 3.22600e-06 0.000
+ 3.22605e-06 1.800 3.22700e-06 1.800 3.22705e-06 0.000 3.23000e-06 0.000 3.23005e-06 1.800 3.23400e-06 1.800
+ 3.23405e-06 0.000 3.23600e-06 0.000 3.23605e-06 1.800 3.24000e-06 1.800 3.24005e-06 0.000 3.24300e-06 0.000
+ 3.24305e-06 1.800 3.24500e-06 1.800 3.24505e-06 0.000 3.24600e-06 0.000 3.24605e-06 1.800 3.25000e-06 1.800
+ 3.25005e-06 0.000 3.25100e-06 0.000 3.25105e-06 1.800 3.25400e-06 1.800 3.25405e-06 0.000 3.25500e-06 0.000
+ 3.25505e-06 1.800 3.25600e-06 1.800 3.25605e-06 0.000 3.25700e-06 0.000 3.25705e-06 1.800 3.26000e-06 1.800
+ 3.26005e-06 0.000 3.26400e-06 0.000 3.26405e-06 1.800 3.26600e-06 1.800 3.26605e-06 0.000 3.26700e-06 0.000
+ 3.26705e-06 1.800 3.26800e-06 1.800 3.26805e-06 0.000 3.27500e-06 0.000 3.27505e-06 1.800 3.27700e-06 1.800
+ 3.27705e-06 0.000 3.27800e-06 0.000 3.27805e-06 1.800 3.28100e-06 1.800 3.28105e-06 0.000 3.28300e-06 0.000
+ 3.28305e-06 1.800 3.28400e-06 1.800 3.28405e-06 0.000 3.28500e-06 0.000 3.28505e-06 1.800 3.28600e-06 1.800
+ 3.28605e-06 0.000 3.28700e-06 0.000 3.28705e-06 1.800 3.29000e-06 1.800 3.29005e-06 0.000 3.29200e-06 0.000
+ 3.29205e-06 1.800 3.29300e-06 1.800 3.29305e-06 0.000 3.29400e-06 0.000 3.29405e-06 1.800 3.30000e-06 1.800
+ 3.30005e-06 0.000 3.30400e-06 0.000 3.30405e-06 1.800 3.30700e-06 1.800 3.30705e-06 0.000 3.31100e-06 0.000
+ 3.31105e-06 1.800 3.31200e-06 1.800 3.31205e-06 0.000 3.31300e-06 0.000 3.31305e-06 1.800 3.31800e-06 1.800
+ 3.31805e-06 0.000 3.32000e-06 0.000 3.32005e-06 1.800 3.32100e-06 1.800 3.32105e-06 0.000 3.32200e-06 0.000
+ 3.32205e-06 1.800 3.32300e-06 1.800 3.32305e-06 0.000 3.32500e-06 0.000 3.32505e-06 1.800 3.32600e-06 1.800
+ 3.32605e-06 0.000 3.32700e-06 0.000 3.32705e-06 1.800 3.32800e-06 1.800 3.32805e-06 0.000 3.32900e-06 0.000
+ 3.32905e-06 1.800 3.33000e-06 1.800 3.33005e-06 0.000 3.33200e-06 0.000 3.33205e-06 1.800 3.33300e-06 1.800
+ 3.33305e-06 0.000 3.33600e-06 0.000 3.33605e-06 1.800 3.33700e-06 1.800 3.33705e-06 0.000 3.33900e-06 0.000
+ 3.33905e-06 1.800 3.34100e-06 1.800 3.34105e-06 0.000 3.34400e-06 0.000 3.34405e-06 1.800 3.34600e-06 1.800
+ 3.34605e-06 0.000 3.34700e-06 0.000 3.34705e-06 1.800 3.35000e-06 1.800 3.35005e-06 0.000 3.35200e-06 0.000
+ 3.35205e-06 1.800 3.35300e-06 1.800 3.35305e-06 0.000 3.35500e-06 0.000 3.35505e-06 1.800 3.35800e-06 1.800
+ 3.35805e-06 0.000 3.36200e-06 0.000 3.36205e-06 1.800 3.36500e-06 1.800 3.36505e-06 0.000 3.36600e-06 0.000
+ 3.36605e-06 1.800 3.36700e-06 1.800 3.36705e-06 0.000 3.36900e-06 0.000 3.36905e-06 1.800 3.37100e-06 1.800
+ 3.37105e-06 0.000 3.37200e-06 0.000 3.37205e-06 1.800 3.37300e-06 1.800 3.37305e-06 0.000 3.37800e-06 0.000
+ 3.37805e-06 1.800 3.37900e-06 1.800 3.37905e-06 0.000 3.38000e-06 0.000 3.38005e-06 1.800 3.38200e-06 1.800
+ 3.38205e-06 0.000 3.38300e-06 0.000 3.38305e-06 1.800 3.38400e-06 1.800 3.38405e-06 0.000 3.38600e-06 0.000
+ 3.38605e-06 1.800 3.38700e-06 1.800 3.38705e-06 0.000 3.38800e-06 0.000 3.38805e-06 1.800 3.38900e-06 1.800
+ 3.38905e-06 0.000 3.39000e-06 0.000 3.39005e-06 1.800 3.39100e-06 1.800 3.39105e-06 0.000 3.39200e-06 0.000
+ 3.39205e-06 1.800 3.39300e-06 1.800 3.39305e-06 0.000 3.39500e-06 0.000 3.39505e-06 1.800 3.39700e-06 1.800
+ 3.39705e-06 0.000 3.39800e-06 0.000 3.39805e-06 1.800 3.40100e-06 1.800 3.40105e-06 0.000 3.40200e-06 0.000
+ 3.40205e-06 1.800 3.40400e-06 1.800 3.40405e-06 0.000 3.40500e-06 0.000 3.40505e-06 1.800 3.40600e-06 1.800
+ 3.40605e-06 0.000 3.40900e-06 0.000 3.40905e-06 1.800 3.41300e-06 1.800 3.41305e-06 0.000 3.41400e-06 0.000
+ 3.41405e-06 1.800 3.41500e-06 1.800 3.41505e-06 0.000 3.42000e-06 0.000 3.42005e-06 1.800 3.42100e-06 1.800
+ 3.42105e-06 0.000 3.42200e-06 0.000 3.42205e-06 1.800 3.42400e-06 1.800 3.42405e-06 0.000 3.42500e-06 0.000
+ 3.42505e-06 1.800 3.42600e-06 1.800 3.42605e-06 0.000 3.42700e-06 0.000 3.42705e-06 1.800 3.42900e-06 1.800
+ 3.42905e-06 0.000 3.43000e-06 0.000 3.43005e-06 1.800 3.43200e-06 1.800 3.43205e-06 0.000 3.43300e-06 0.000
+ 3.43305e-06 1.800 3.43400e-06 1.800 3.43405e-06 0.000 3.43600e-06 0.000 3.43605e-06 1.800 3.43800e-06 1.800
+ 3.43805e-06 0.000 3.43900e-06 0.000 3.43905e-06 1.800 3.44000e-06 1.800 3.44005e-06 0.000 3.44100e-06 0.000
+ 3.44105e-06 1.800 3.44200e-06 1.800 3.44205e-06 0.000 3.44800e-06 0.000 3.44805e-06 1.800 3.44900e-06 1.800
+ 3.44905e-06 0.000 3.45000e-06 0.000 3.45005e-06 1.800 3.45100e-06 1.800 3.45105e-06 0.000 3.45200e-06 0.000
+ 3.45205e-06 1.800 3.45600e-06 1.800 3.45605e-06 0.000 3.45900e-06 0.000 3.45905e-06 1.800 3.46600e-06 1.800
+ 3.46605e-06 0.000 3.46700e-06 0.000 3.46705e-06 1.800 3.46800e-06 1.800 3.46805e-06 0.000 3.46900e-06 0.000
+ 3.46905e-06 1.800 3.47100e-06 1.800 3.47105e-06 0.000 3.47300e-06 0.000 3.47305e-06 1.800 3.47900e-06 1.800
+ 3.47905e-06 0.000 3.48000e-06 0.000 3.48005e-06 1.800 3.48100e-06 1.800 3.48105e-06 0.000 3.48200e-06 0.000
+ 3.48205e-06 1.800 3.48500e-06 1.800 3.48505e-06 0.000 3.48600e-06 0.000 3.48605e-06 1.800 3.48700e-06 1.800
+ 3.48705e-06 0.000 3.48900e-06 0.000 3.48905e-06 1.800 3.49200e-06 1.800 3.49205e-06 0.000 3.49300e-06 0.000
+ 3.49305e-06 1.800 3.49600e-06 1.800 3.49605e-06 0.000 3.49700e-06 0.000 3.49705e-06 1.800 3.50100e-06 1.800
+ 3.50105e-06 0.000 3.50200e-06 0.000 3.50205e-06 1.800 3.50500e-06 1.800 3.50505e-06 0.000 3.50700e-06 0.000
+ 3.50705e-06 1.800 3.50900e-06 1.800 3.50905e-06 0.000 3.51000e-06 0.000 3.51005e-06 1.800 3.51300e-06 1.800
+ 3.51305e-06 0.000 3.51400e-06 0.000 3.51405e-06 1.800 3.51600e-06 1.800 3.51605e-06 0.000 3.51700e-06 0.000
+ 3.51705e-06 1.800 3.51800e-06 1.800 3.51805e-06 0.000 3.52000e-06 0.000 3.52005e-06 1.800 3.52100e-06 1.800
+ 3.52105e-06 0.000 3.52200e-06 0.000 3.52205e-06 1.800 3.52500e-06 1.800 3.52505e-06 0.000 3.52600e-06 0.000
+ 3.52605e-06 1.800 3.52700e-06 1.800 3.52705e-06 0.000 3.53000e-06 0.000 3.53005e-06 1.800 3.53100e-06 1.800
+ 3.53105e-06 0.000 3.53200e-06 0.000 3.53205e-06 1.800 3.53400e-06 1.800 3.53405e-06 0.000 3.53600e-06 0.000
+ 3.53605e-06 1.800 3.53900e-06 1.800 3.53905e-06 0.000 3.54100e-06 0.000 3.54105e-06 1.800 3.54200e-06 1.800
+ 3.54205e-06 0.000 3.54300e-06 0.000 3.54305e-06 1.800 3.54400e-06 1.800 3.54405e-06 0.000 3.54600e-06 0.000
+ 3.54605e-06 1.800 3.54700e-06 1.800 3.54705e-06 0.000 3.54800e-06 0.000 3.54805e-06 1.800 3.54900e-06 1.800
+ 3.54905e-06 0.000 3.55500e-06 0.000 3.55505e-06 1.800 3.55600e-06 1.800 3.55605e-06 0.000 3.55900e-06 0.000
+ 3.55905e-06 1.800 3.56000e-06 1.800 3.56005e-06 0.000 3.56200e-06 0.000 3.56205e-06 1.800 3.56300e-06 1.800
+ 3.56305e-06 0.000 3.56400e-06 0.000 3.56405e-06 1.800 3.56700e-06 1.800 3.56705e-06 0.000 3.56900e-06 0.000
+ 3.56905e-06 1.800 3.57000e-06 1.800 3.57005e-06 0.000 3.57100e-06 0.000 3.57105e-06 1.800 3.57200e-06 1.800
+ 3.57205e-06 0.000 3.57500e-06 0.000 3.57505e-06 1.800 3.57600e-06 1.800 3.57605e-06 0.000 3.58000e-06 0.000
+ 3.58005e-06 1.800 3.58100e-06 1.800 3.58105e-06 0.000 3.58200e-06 0.000 3.58205e-06 1.800 3.58500e-06 1.800
+ 3.58505e-06 0.000 3.58600e-06 0.000 3.58605e-06 1.800 3.58700e-06 1.800 3.58705e-06 0.000 3.58900e-06 0.000
+ 3.58905e-06 1.800 3.59000e-06 1.800 3.59005e-06 0.000 3.59200e-06 0.000 3.59205e-06 1.800 3.59300e-06 1.800
+ 3.59305e-06 0.000 3.59900e-06 0.000 3.59905e-06 1.800 3.60000e-06 1.800 3.60005e-06 0.000 3.60100e-06 0.000
+ 3.60105e-06 1.800 3.60200e-06 1.800 3.60205e-06 0.000 3.60600e-06 0.000 3.60605e-06 1.800 3.60900e-06 1.800
+ 3.60905e-06 0.000 3.61100e-06 0.000 3.61105e-06 1.800 3.61200e-06 1.800 3.61205e-06 0.000 3.61700e-06 0.000
+ 3.61705e-06 1.800 3.62300e-06 1.800 3.62305e-06 0.000 3.62500e-06 0.000 3.62505e-06 1.800 3.62600e-06 1.800
+ 3.62605e-06 0.000 3.62700e-06 0.000 3.62705e-06 1.800 3.62900e-06 1.800 3.62905e-06 0.000 3.63100e-06 0.000
+ 3.63105e-06 1.800 3.63200e-06 1.800 3.63205e-06 0.000 3.63600e-06 0.000 3.63605e-06 1.800 3.63700e-06 1.800
+ 3.63705e-06 0.000 3.63800e-06 0.000 3.63805e-06 1.800 3.64200e-06 1.800 3.64205e-06 0.000 3.64300e-06 0.000
+ 3.64305e-06 1.800 3.64600e-06 1.800 3.64605e-06 0.000 3.64700e-06 0.000 3.64705e-06 1.800 3.64800e-06 1.800
+ 3.64805e-06 0.000 3.64900e-06 0.000 3.64905e-06 1.800 3.65000e-06 1.800 3.65005e-06 0.000 3.65200e-06 0.000
+ 3.65205e-06 1.800 3.65300e-06 1.800 3.65305e-06 0.000 3.65400e-06 0.000 3.65405e-06 1.800 3.65500e-06 1.800
+ 3.65505e-06 0.000 3.65800e-06 0.000 3.65805e-06 1.800 3.65900e-06 1.800 3.65905e-06 0.000 3.66200e-06 0.000
+ 3.66205e-06 1.800 3.66300e-06 1.800 3.66305e-06 0.000 3.66400e-06 0.000 3.66405e-06 1.800 3.66500e-06 1.800
+ 3.66505e-06 0.000 3.66700e-06 0.000 3.66705e-06 1.800 3.67100e-06 1.800 3.67105e-06 0.000 3.67200e-06 0.000
+ 3.67205e-06 1.800 3.67400e-06 1.800 3.67405e-06 0.000 3.67600e-06 0.000 3.67605e-06 1.800 3.67800e-06 1.800
+ 3.67805e-06 0.000 3.67900e-06 0.000 3.67905e-06 1.800 3.68000e-06 1.800 3.68005e-06 0.000 3.68200e-06 0.000
+ 3.68205e-06 1.800 3.68300e-06 1.800 3.68305e-06 0.000 3.68500e-06 0.000 3.68505e-06 1.800 3.68600e-06 1.800
+ 3.68605e-06 0.000 3.69000e-06 0.000 3.69005e-06 1.800 3.69100e-06 1.800 3.69105e-06 0.000 3.69400e-06 0.000
+ 3.69405e-06 1.800 3.69600e-06 1.800 3.69605e-06 0.000 3.69700e-06 0.000 3.69705e-06 1.800 3.70100e-06 1.800
+ 3.70105e-06 0.000 3.70200e-06 0.000 3.70205e-06 1.800 3.70300e-06 1.800 3.70305e-06 0.000 3.70600e-06 0.000
+ 3.70605e-06 1.800 3.70800e-06 1.800 3.70805e-06 0.000 3.70900e-06 0.000 3.70905e-06 1.800 3.71400e-06 1.800
+ 3.71405e-06 0.000 3.71800e-06 0.000 3.71805e-06 1.800 3.71900e-06 1.800 3.71905e-06 0.000 3.72000e-06 0.000
+ 3.72005e-06 1.800 3.72200e-06 1.800 3.72205e-06 0.000 3.72300e-06 0.000 3.72305e-06 1.800 3.72400e-06 1.800
+ 3.72405e-06 0.000 3.72600e-06 0.000 3.72605e-06 1.800 3.73000e-06 1.800 3.73005e-06 0.000 3.73200e-06 0.000
+ 3.73205e-06 1.800 3.73300e-06 1.800 3.73305e-06 0.000 3.73400e-06 0.000 3.73405e-06 1.800 3.73600e-06 1.800
+ 3.73605e-06 0.000 3.73700e-06 0.000 3.73705e-06 1.800 3.73800e-06 1.800 3.73805e-06 0.000 3.74300e-06 0.000
+ 3.74305e-06 1.800 3.74400e-06 1.800 3.74405e-06 0.000 3.74900e-06 0.000 3.74905e-06 1.800 3.75200e-06 1.800
+ 3.75205e-06 0.000 3.75400e-06 0.000 3.75405e-06 1.800 3.75500e-06 1.800 3.75505e-06 0.000 3.75600e-06 0.000
+ 3.75605e-06 1.800 3.75700e-06 1.800 3.75705e-06 0.000 3.75800e-06 0.000 3.75805e-06 1.800 3.75900e-06 1.800
+ 3.75905e-06 0.000 3.76200e-06 0.000 3.76205e-06 1.800 3.76700e-06 1.800 3.76705e-06 0.000 3.76900e-06 0.000
+ 3.76905e-06 1.800 3.77000e-06 1.800 3.77005e-06 0.000 3.77100e-06 0.000 3.77105e-06 1.800 3.77300e-06 1.800
+ 3.77305e-06 0.000 3.77400e-06 0.000 3.77405e-06 1.800 3.77700e-06 1.800 3.77705e-06 0.000 3.77800e-06 0.000
+ 3.77805e-06 1.800 3.78000e-06 1.800 3.78005e-06 0.000 3.78100e-06 0.000 3.78105e-06 1.800 3.78200e-06 1.800
+ 3.78205e-06 0.000 3.78300e-06 0.000 3.78305e-06 1.800 3.78500e-06 1.800 3.78505e-06 0.000 3.78600e-06 0.000
+ 3.78605e-06 1.800 3.78700e-06 1.800 3.78705e-06 0.000 3.78800e-06 0.000 3.78805e-06 1.800 3.79000e-06 1.800
+ 3.79005e-06 0.000 3.79100e-06 0.000 3.79105e-06 1.800 3.79300e-06 1.800 3.79305e-06 0.000 3.79500e-06 0.000
+ 3.79505e-06 1.800 3.79600e-06 1.800 3.79605e-06 0.000 3.79800e-06 0.000 3.79805e-06 1.800 3.79900e-06 1.800
+ 3.79905e-06 0.000 3.80100e-06 0.000 3.80105e-06 1.800 3.80500e-06 1.800 3.80505e-06 0.000 3.80700e-06 0.000
+ 3.80705e-06 1.800 3.80800e-06 1.800 3.80805e-06 0.000 3.80900e-06 0.000 3.80905e-06 1.800 3.81300e-06 1.800
+ 3.81305e-06 0.000 3.81400e-06 0.000 3.81405e-06 1.800 3.81500e-06 1.800 3.81505e-06 0.000 3.81600e-06 0.000
+ 3.81605e-06 1.800 3.81700e-06 1.800 3.81705e-06 0.000 3.81900e-06 0.000 3.81905e-06 1.800 3.82000e-06 1.800
+ 3.82005e-06 0.000 3.82100e-06 0.000 3.82105e-06 1.800 3.82200e-06 1.800 3.82205e-06 0.000 3.82300e-06 0.000
+ 3.82305e-06 1.800 3.82400e-06 1.800 3.82405e-06 0.000 3.82500e-06 0.000 3.82505e-06 1.800 3.82700e-06 1.800
+ 3.82705e-06 0.000 3.82800e-06 0.000 3.82805e-06 1.800 3.83100e-06 1.800 3.83105e-06 0.000 3.83700e-06 0.000
+ 3.83705e-06 1.800 3.83800e-06 1.800 3.83805e-06 0.000 3.83900e-06 0.000 3.83905e-06 1.800 3.84300e-06 1.800
+ 3.84305e-06 0.000 3.84400e-06 0.000 3.84405e-06 1.800 3.84700e-06 1.800 3.84705e-06 0.000 3.84800e-06 0.000
+ 3.84805e-06 1.800 3.84900e-06 1.800 3.84905e-06 0.000 3.85000e-06 0.000 3.85005e-06 1.800 3.85100e-06 1.800
+ 3.85105e-06 0.000 3.85200e-06 0.000 3.85205e-06 1.800 3.85300e-06 1.800 3.85305e-06 0.000 3.85600e-06 0.000
+ 3.85605e-06 1.800 3.86000e-06 1.800 3.86005e-06 0.000 3.86100e-06 0.000 3.86105e-06 1.800 3.86200e-06 1.800
+ 3.86205e-06 0.000 3.86500e-06 0.000 3.86505e-06 1.800 3.86600e-06 1.800 3.86605e-06 0.000 3.86700e-06 0.000
+ 3.86705e-06 1.800 3.86800e-06 1.800 3.86805e-06 0.000 3.87100e-06 0.000 3.87105e-06 1.800 3.87400e-06 1.800
+ 3.87405e-06 0.000 3.87600e-06 0.000 3.87605e-06 1.800 3.87700e-06 1.800 3.87705e-06 0.000 3.87800e-06 0.000
+ 3.87805e-06 1.800 3.88100e-06 1.800 3.88105e-06 0.000 3.88200e-06 0.000 3.88205e-06 1.800 3.88400e-06 1.800
+ 3.88405e-06 0.000 3.88800e-06 0.000 3.88805e-06 1.800 3.88900e-06 1.800 3.88905e-06 0.000 3.89000e-06 0.000
+ 3.89005e-06 1.800 3.89300e-06 1.800 3.89305e-06 0.000 3.89800e-06 0.000 3.89805e-06 1.800 3.90000e-06 1.800
+ 3.90005e-06 0.000 3.90100e-06 0.000 3.90105e-06 1.800 3.90200e-06 1.800 3.90205e-06 0.000 3.90600e-06 0.000
+ 3.90605e-06 1.800 3.90800e-06 1.800 3.90805e-06 0.000 3.90900e-06 0.000 3.90905e-06 1.800 3.91500e-06 1.800
+ 3.91505e-06 0.000 3.91600e-06 0.000 3.91605e-06 1.800 3.91700e-06 1.800 3.91705e-06 0.000 3.91900e-06 0.000
+ 3.91905e-06 1.800 3.92200e-06 1.800 3.92205e-06 0.000 3.92500e-06 0.000 3.92505e-06 1.800 3.92800e-06 1.800
+ 3.92805e-06 0.000 3.93300e-06 0.000 3.93305e-06 1.800 3.93500e-06 1.800 3.93505e-06 0.000 3.93600e-06 0.000
+ 3.93605e-06 1.800 3.93700e-06 1.800 3.93705e-06 0.000 3.93800e-06 0.000 3.93805e-06 1.800 3.94000e-06 1.800
+ 3.94005e-06 0.000 3.94100e-06 0.000 3.94105e-06 1.800 3.94300e-06 1.800 3.94305e-06 0.000 3.94400e-06 0.000
+ 3.94405e-06 1.800 3.94900e-06 1.800 3.94905e-06 0.000 3.95400e-06 0.000 3.95405e-06 1.800 3.95600e-06 1.800
+ 3.95605e-06 0.000 3.95700e-06 0.000 3.95705e-06 1.800 3.95800e-06 1.800 3.95805e-06 0.000 3.96300e-06 0.000
+ 3.96305e-06 1.800 3.96600e-06 1.800 3.96605e-06 0.000 3.96700e-06 0.000 3.96705e-06 1.800 3.96900e-06 1.800
+ 3.96905e-06 0.000 3.97300e-06 0.000 3.97305e-06 1.800 3.97500e-06 1.800 3.97505e-06 0.000 3.97700e-06 0.000
+ 3.97705e-06 1.800 3.97800e-06 1.800 3.97805e-06 0.000 3.97900e-06 0.000 3.97905e-06 1.800 3.98400e-06 1.800
+ 3.98405e-06 0.000 3.98700e-06 0.000 3.98705e-06 1.800 3.98800e-06 1.800 3.98805e-06 0.000 3.99000e-06 0.000
+ 3.99005e-06 1.800 3.99200e-06 1.800 3.99205e-06 0.000 3.99500e-06 0.000 3.99505e-06 1.800 3.99600e-06 1.800
+ 3.99605e-06 0.000 3.99700e-06 0.000 3.99705e-06 1.800 3.99900e-06 1.800 3.99905e-06 0.000 4.00000e-06 0.000
+ 4.00005e-06 1.800 4.00200e-06 1.800 4.00205e-06 0.000 4.00300e-06 0.000 4.00305e-06 1.800 4.00400e-06 1.800
+ 4.00405e-06 0.000 4.00500e-06 0.000 4.00505e-06 1.800 4.00700e-06 1.800 4.00705e-06 0.000 4.00900e-06 0.000
+ 4.00905e-06 1.800 4.01000e-06 1.800 4.01005e-06 0.000 4.01300e-06 0.000 4.01305e-06 1.800 4.01400e-06 1.800
+ 4.01405e-06 0.000 4.01600e-06 0.000 4.01605e-06 1.800 4.01800e-06 1.800 4.01805e-06 0.000 4.01900e-06 0.000
+ 4.01905e-06 1.800 4.02300e-06 1.800 4.02305e-06 0.000 4.02400e-06 0.000 4.02405e-06 1.800 4.02800e-06 1.800
+ 4.02805e-06 0.000 4.03200e-06 0.000 4.03205e-06 1.800 4.03300e-06 1.800 4.03305e-06 0.000 4.03600e-06 0.000
+ 4.03605e-06 1.800 4.03700e-06 1.800 4.03705e-06 0.000 4.04200e-06 0.000 4.04205e-06 1.800 4.04400e-06 1.800
+ 4.04405e-06 0.000 4.04500e-06 0.000 4.04505e-06 1.800 4.04600e-06 1.800 4.04605e-06 0.000 4.04800e-06 0.000
+ 4.04805e-06 1.800 4.05100e-06 1.800 4.05105e-06 0.000 4.05200e-06 0.000 4.05205e-06 1.800 4.05800e-06 1.800
+ 4.05805e-06 0.000 4.05900e-06 0.000 4.05905e-06 1.800 4.06000e-06 1.800 4.06005e-06 0.000 4.06400e-06 0.000
+ 4.06405e-06 1.800 4.06500e-06 1.800 4.06505e-06 0.000 4.06600e-06 0.000 4.06605e-06 1.800 4.06700e-06 1.800
+ 4.06705e-06 0.000 4.06900e-06 0.000 4.06905e-06 1.800 4.07200e-06 1.800 4.07205e-06 0.000 4.07300e-06 0.000
+ 4.07305e-06 1.800 4.07500e-06 1.800 4.07505e-06 0.000 4.07600e-06 0.000 4.07605e-06 1.800 4.07800e-06 1.800
+ 4.07805e-06 0.000 4.08100e-06 0.000 4.08105e-06 1.800 4.08400e-06 1.800 4.08405e-06 0.000 4.08600e-06 0.000
+ 4.08605e-06 1.800 4.08700e-06 1.800 4.08705e-06 0.000 4.08900e-06 0.000 4.08905e-06 1.800 4.09000e-06 1.800
+ 4.09005e-06 0.000 4.09100e-06 0.000 4.09105e-06 1.800 4.09300e-06 1.800 4.09305e-06 0.000 4.09500e-06 0.000
+ 4.09505e-06 1.800 4.09600e-06 1.800
+ )
Xd_t1b src_t1b t1b vdd gnd tb_inv
Vg2b src_g2b gnd PWL(
+ 0.00000e+00 1.800 6.40000e-08 1.800 6.40500e-08 0.000 1.28000e-07 0.000 1.28050e-07 1.800 1.92000e-07 1.800
+ 1.92050e-07 0.000 2.56000e-07 0.000 2.56050e-07 1.800 3.20000e-07 1.800 3.20050e-07 0.000 3.84000e-07 0.000
+ 3.84050e-07 1.800 4.48000e-07 1.800 4.48050e-07 0.000 5.12000e-07 0.000 5.12050e-07 1.800 5.76000e-07 1.800
+ 5.76050e-07 0.000 6.40000e-07 0.000 6.40050e-07 1.800 7.04000e-07 1.800 7.04050e-07 0.000 7.68000e-07 0.000
+ 7.68050e-07 1.800 8.32000e-07 1.800 8.32050e-07 0.000 8.96000e-07 0.000 8.96050e-07 1.800 9.60000e-07 1.800
+ 9.60050e-07 0.000 1.02400e-06 0.000 1.02405e-06 1.800 1.08800e-06 1.800 1.08805e-06 0.000 1.15200e-06 0.000
+ 1.15205e-06 1.800 1.21600e-06 1.800 1.21605e-06 0.000 1.28000e-06 0.000 1.28005e-06 1.800 1.34400e-06 1.800
+ 1.34405e-06 0.000 1.40800e-06 0.000 1.40805e-06 1.800 1.47200e-06 1.800 1.47205e-06 0.000 1.53600e-06 0.000
+ 1.53605e-06 1.800 1.60000e-06 1.800 1.60005e-06 0.000 1.66400e-06 0.000 1.66405e-06 1.800 1.72800e-06 1.800
+ 1.72805e-06 0.000 1.79200e-06 0.000 1.79205e-06 1.800 1.85600e-06 1.800 1.85605e-06 0.000 1.92000e-06 0.000
+ 1.92005e-06 1.800 1.98400e-06 1.800 1.98405e-06 0.000 2.04800e-06 0.000 2.04805e-06 1.800 2.05100e-06 1.800
+ 2.05105e-06 0.000 2.05200e-06 0.000 2.05205e-06 1.800 2.05700e-06 1.800 2.05705e-06 0.000 2.05900e-06 0.000
+ 2.05905e-06 1.800 2.06000e-06 1.800 2.06005e-06 0.000 2.06200e-06 0.000 2.06205e-06 1.800 2.06300e-06 1.800
+ 2.06305e-06 0.000 2.06500e-06 0.000 2.06505e-06 1.800 2.06700e-06 1.800 2.06705e-06 0.000 2.06800e-06 0.000
+ 2.06805e-06 1.800 2.06900e-06 1.800 2.06905e-06 0.000 2.07100e-06 0.000 2.07105e-06 1.800 2.07300e-06 1.800
+ 2.07305e-06 0.000 2.07700e-06 0.000 2.07705e-06 1.800 2.07900e-06 1.800 2.07905e-06 0.000 2.08200e-06 0.000
+ 2.08205e-06 1.800 2.08500e-06 1.800 2.08505e-06 0.000 2.09100e-06 0.000 2.09105e-06 1.800 2.09600e-06 1.800
+ 2.09605e-06 0.000 2.09700e-06 0.000 2.09705e-06 1.800 2.09800e-06 1.800 2.09805e-06 0.000 2.09900e-06 0.000
+ 2.09905e-06 1.800 2.10100e-06 1.800 2.10105e-06 0.000 2.10300e-06 0.000 2.10305e-06 1.800 2.10600e-06 1.800
+ 2.10605e-06 0.000 2.10900e-06 0.000 2.10905e-06 1.800 2.11000e-06 1.800 2.11005e-06 0.000 2.11200e-06 0.000
+ 2.11205e-06 1.800 2.11300e-06 1.800 2.11305e-06 0.000 2.11500e-06 0.000 2.11505e-06 1.800 2.11600e-06 1.800
+ 2.11605e-06 0.000 2.11900e-06 0.000 2.11905e-06 1.800 2.12000e-06 1.800 2.12005e-06 0.000 2.12100e-06 0.000
+ 2.12105e-06 1.800 2.12300e-06 1.800 2.12305e-06 0.000 2.12700e-06 0.000 2.12705e-06 1.800 2.12900e-06 1.800
+ 2.12905e-06 0.000 2.13000e-06 0.000 2.13005e-06 1.800 2.13100e-06 1.800 2.13105e-06 0.000 2.13400e-06 0.000
+ 2.13405e-06 1.800 2.13500e-06 1.800 2.13505e-06 0.000 2.14000e-06 0.000 2.14005e-06 1.800 2.14200e-06 1.800
+ 2.14205e-06 0.000 2.14600e-06 0.000 2.14605e-06 1.800 2.14700e-06 1.800 2.14705e-06 0.000 2.14800e-06 0.000
+ 2.14805e-06 1.800 2.14900e-06 1.800 2.14905e-06 0.000 2.15000e-06 0.000 2.15005e-06 1.800 2.15300e-06 1.800
+ 2.15305e-06 0.000 2.15600e-06 0.000 2.15605e-06 1.800 2.15700e-06 1.800 2.15705e-06 0.000 2.15800e-06 0.000
+ 2.15805e-06 1.800 2.15900e-06 1.800 2.15905e-06 0.000 2.16200e-06 0.000 2.16205e-06 1.800 2.16400e-06 1.800
+ 2.16405e-06 0.000 2.16600e-06 0.000 2.16605e-06 1.800 2.16700e-06 1.800 2.16705e-06 0.000 2.16900e-06 0.000
+ 2.16905e-06 1.800 2.17000e-06 1.800 2.17005e-06 0.000 2.17100e-06 0.000 2.17105e-06 1.800 2.17200e-06 1.800
+ 2.17205e-06 0.000 2.17300e-06 0.000 2.17305e-06 1.800 2.17500e-06 1.800 2.17505e-06 0.000 2.17600e-06 0.000
+ 2.17605e-06 1.800 2.18100e-06 1.800 2.18105e-06 0.000 2.18300e-06 0.000 2.18305e-06 1.800 2.18400e-06 1.800
+ 2.18405e-06 0.000 2.18500e-06 0.000 2.18505e-06 1.800 2.18800e-06 1.800 2.18805e-06 0.000 2.18900e-06 0.000
+ 2.18905e-06 1.800 2.19000e-06 1.800 2.19005e-06 0.000 2.19300e-06 0.000 2.19305e-06 1.800 2.19400e-06 1.800
+ 2.19405e-06 0.000 2.19600e-06 0.000 2.19605e-06 1.800 2.19800e-06 1.800 2.19805e-06 0.000 2.19900e-06 0.000
+ 2.19905e-06 1.800 2.20100e-06 1.800 2.20105e-06 0.000 2.20300e-06 0.000 2.20305e-06 1.800 2.20400e-06 1.800
+ 2.20405e-06 0.000 2.20800e-06 0.000 2.20805e-06 1.800 2.20900e-06 1.800 2.20905e-06 0.000 2.21000e-06 0.000
+ 2.21005e-06 1.800 2.21100e-06 1.800 2.21105e-06 0.000 2.21200e-06 0.000 2.21205e-06 1.800 2.21400e-06 1.800
+ 2.21405e-06 0.000 2.21600e-06 0.000 2.21605e-06 1.800 2.22400e-06 1.800 2.22405e-06 0.000 2.22700e-06 0.000
+ 2.22705e-06 1.800 2.22800e-06 1.800 2.22805e-06 0.000 2.22900e-06 0.000 2.22905e-06 1.800 2.23000e-06 1.800
+ 2.23005e-06 0.000 2.23300e-06 0.000 2.23305e-06 1.800 2.23500e-06 1.800 2.23505e-06 0.000 2.23900e-06 0.000
+ 2.23905e-06 1.800 2.24000e-06 1.800 2.24005e-06 0.000 2.24200e-06 0.000 2.24205e-06 1.800 2.24500e-06 1.800
+ 2.24505e-06 0.000 2.24700e-06 0.000 2.24705e-06 1.800 2.24800e-06 1.800 2.24805e-06 0.000 2.24900e-06 0.000
+ 2.24905e-06 1.800 2.25000e-06 1.800 2.25005e-06 0.000 2.25200e-06 0.000 2.25205e-06 1.800 2.25300e-06 1.800
+ 2.25305e-06 0.000 2.25400e-06 0.000 2.25405e-06 1.800 2.25600e-06 1.800 2.25605e-06 0.000 2.25700e-06 0.000
+ 2.25705e-06 1.800 2.25800e-06 1.800 2.25805e-06 0.000 2.25900e-06 0.000 2.25905e-06 1.800 2.26100e-06 1.800
+ 2.26105e-06 0.000 2.26200e-06 0.000 2.26205e-06 1.800 2.26300e-06 1.800 2.26305e-06 0.000 2.26600e-06 0.000
+ 2.26605e-06 1.800 2.26900e-06 1.800 2.26905e-06 0.000 2.27000e-06 0.000 2.27005e-06 1.800 2.27100e-06 1.800
+ 2.27105e-06 0.000 2.27200e-06 0.000 2.27205e-06 1.800 2.27400e-06 1.800 2.27405e-06 0.000 2.27500e-06 0.000
+ 2.27505e-06 1.800 2.27800e-06 1.800 2.27805e-06 0.000 2.27900e-06 0.000 2.27905e-06 1.800 2.28300e-06 1.800
+ 2.28305e-06 0.000 2.28500e-06 0.000 2.28505e-06 1.800 2.28600e-06 1.800 2.28605e-06 0.000 2.28700e-06 0.000
+ 2.28705e-06 1.800 2.28900e-06 1.800 2.28905e-06 0.000 2.29200e-06 0.000 2.29205e-06 1.800 2.29300e-06 1.800
+ 2.29305e-06 0.000 2.29700e-06 0.000 2.29705e-06 1.800 2.30000e-06 1.800 2.30005e-06 0.000 2.30100e-06 0.000
+ 2.30105e-06 1.800 2.30200e-06 1.800 2.30205e-06 0.000 2.30800e-06 0.000 2.30805e-06 1.800 2.30900e-06 1.800
+ 2.30905e-06 0.000 2.31100e-06 0.000 2.31105e-06 1.800 2.31500e-06 1.800 2.31505e-06 0.000 2.31600e-06 0.000
+ 2.31605e-06 1.800 2.32000e-06 1.800 2.32005e-06 0.000 2.32300e-06 0.000 2.32305e-06 1.800 2.32500e-06 1.800
+ 2.32505e-06 0.000 2.32600e-06 0.000 2.32605e-06 1.800 2.33000e-06 1.800 2.33005e-06 0.000 2.33400e-06 0.000
+ 2.33405e-06 1.800 2.33600e-06 1.800 2.33605e-06 0.000 2.33700e-06 0.000 2.33705e-06 1.800 2.34000e-06 1.800
+ 2.34005e-06 0.000 2.34100e-06 0.000 2.34105e-06 1.800 2.34200e-06 1.800 2.34205e-06 0.000 2.34300e-06 0.000
+ 2.34305e-06 1.800 2.35000e-06 1.800 2.35005e-06 0.000 2.35200e-06 0.000 2.35205e-06 1.800 2.35600e-06 1.800
+ 2.35605e-06 0.000 2.35700e-06 0.000 2.35705e-06 1.800 2.35900e-06 1.800 2.35905e-06 0.000 2.36100e-06 0.000
+ 2.36105e-06 1.800 2.36400e-06 1.800 2.36405e-06 0.000 2.36500e-06 0.000 2.36505e-06 1.800 2.36600e-06 1.800
+ 2.36605e-06 0.000 2.36800e-06 0.000 2.36805e-06 1.800 2.36900e-06 1.800 2.36905e-06 0.000 2.37000e-06 0.000
+ 2.37005e-06 1.800 2.37200e-06 1.800 2.37205e-06 0.000 2.37400e-06 0.000 2.37405e-06 1.800 2.37600e-06 1.800
+ 2.37605e-06 0.000 2.37700e-06 0.000 2.37705e-06 1.800 2.37800e-06 1.800 2.37805e-06 0.000 2.38300e-06 0.000
+ 2.38305e-06 1.800 2.38400e-06 1.800 2.38405e-06 0.000 2.38700e-06 0.000 2.38705e-06 1.800 2.38800e-06 1.800
+ 2.38805e-06 0.000 2.38900e-06 0.000 2.38905e-06 1.800 2.39000e-06 1.800 2.39005e-06 0.000 2.39200e-06 0.000
+ 2.39205e-06 1.800 2.39300e-06 1.800 2.39305e-06 0.000 2.39400e-06 0.000 2.39405e-06 1.800 2.39500e-06 1.800
+ 2.39505e-06 0.000 2.39800e-06 0.000 2.39805e-06 1.800 2.39900e-06 1.800 2.39905e-06 0.000 2.40000e-06 0.000
+ 2.40005e-06 1.800 2.40100e-06 1.800 2.40105e-06 0.000 2.40300e-06 0.000 2.40305e-06 1.800 2.40500e-06 1.800
+ 2.40505e-06 0.000 2.41000e-06 0.000 2.41005e-06 1.800 2.41100e-06 1.800 2.41105e-06 0.000 2.41200e-06 0.000
+ 2.41205e-06 1.800 2.41300e-06 1.800 2.41305e-06 0.000 2.41400e-06 0.000 2.41405e-06 1.800 2.41900e-06 1.800
+ 2.41905e-06 0.000 2.42000e-06 0.000 2.42005e-06 1.800 2.42100e-06 1.800 2.42105e-06 0.000 2.42200e-06 0.000
+ 2.42205e-06 1.800 2.42400e-06 1.800 2.42405e-06 0.000 2.42500e-06 0.000 2.42505e-06 1.800 2.42800e-06 1.800
+ 2.42805e-06 0.000 2.42900e-06 0.000 2.42905e-06 1.800 2.43200e-06 1.800 2.43205e-06 0.000 2.43300e-06 0.000
+ 2.43305e-06 1.800 2.43400e-06 1.800 2.43405e-06 0.000 2.43600e-06 0.000 2.43605e-06 1.800 2.43700e-06 1.800
+ 2.43705e-06 0.000 2.43900e-06 0.000 2.43905e-06 1.800 2.44400e-06 1.800 2.44405e-06 0.000 2.44700e-06 0.000
+ 2.44705e-06 1.800 2.45000e-06 1.800 2.45005e-06 0.000 2.45100e-06 0.000 2.45105e-06 1.800 2.45400e-06 1.800
+ 2.45405e-06 0.000 2.45700e-06 0.000 2.45705e-06 1.800 2.45800e-06 1.800 2.45805e-06 0.000 2.46100e-06 0.000
+ 2.46105e-06 1.800 2.46800e-06 1.800 2.46805e-06 0.000 2.46900e-06 0.000 2.46905e-06 1.800 2.47000e-06 1.800
+ 2.47005e-06 0.000 2.47100e-06 0.000 2.47105e-06 1.800 2.47500e-06 1.800 2.47505e-06 0.000 2.47700e-06 0.000
+ 2.47705e-06 1.800 2.47900e-06 1.800 2.47905e-06 0.000 2.48200e-06 0.000 2.48205e-06 1.800 2.48300e-06 1.800
+ 2.48305e-06 0.000 2.49100e-06 0.000 2.49105e-06 1.800 2.49200e-06 1.800 2.49205e-06 0.000 2.49400e-06 0.000
+ 2.49405e-06 1.800 2.49500e-06 1.800 2.49505e-06 0.000 2.49700e-06 0.000 2.49705e-06 1.800 2.50000e-06 1.800
+ 2.50005e-06 0.000 2.50100e-06 0.000 2.50105e-06 1.800 2.50300e-06 1.800 2.50305e-06 0.000 2.50400e-06 0.000
+ 2.50405e-06 1.800 2.50800e-06 1.800 2.50805e-06 0.000 2.51100e-06 0.000 2.51105e-06 1.800 2.51200e-06 1.800
+ 2.51205e-06 0.000 2.51300e-06 0.000 2.51305e-06 1.800 2.51400e-06 1.800 2.51405e-06 0.000 2.51800e-06 0.000
+ 2.51805e-06 1.800 2.51900e-06 1.800 2.51905e-06 0.000 2.52000e-06 0.000 2.52005e-06 1.800 2.52200e-06 1.800
+ 2.52205e-06 0.000 2.52500e-06 0.000 2.52505e-06 1.800 2.52600e-06 1.800 2.52605e-06 0.000 2.52700e-06 0.000
+ 2.52705e-06 1.800 2.52800e-06 1.800 2.52805e-06 0.000 2.52900e-06 0.000 2.52905e-06 1.800 2.53200e-06 1.800
+ 2.53205e-06 0.000 2.53900e-06 0.000 2.53905e-06 1.800 2.54100e-06 1.800 2.54105e-06 0.000 2.54200e-06 0.000
+ 2.54205e-06 1.800 2.54500e-06 1.800 2.54505e-06 0.000 2.54600e-06 0.000 2.54605e-06 1.800 2.54700e-06 1.800
+ 2.54705e-06 0.000 2.54800e-06 0.000 2.54805e-06 1.800 2.55000e-06 1.800 2.55005e-06 0.000 2.55500e-06 0.000
+ 2.55505e-06 1.800 2.55600e-06 1.800 2.55605e-06 0.000 2.55700e-06 0.000 2.55705e-06 1.800 2.56000e-06 1.800
+ 2.56005e-06 0.000 2.56200e-06 0.000 2.56205e-06 1.800 2.56400e-06 1.800 2.56405e-06 0.000 2.56500e-06 0.000
+ 2.56505e-06 1.800 2.56600e-06 1.800 2.56605e-06 0.000 2.56900e-06 0.000 2.56905e-06 1.800 2.57000e-06 1.800
+ 2.57005e-06 0.000 2.57100e-06 0.000 2.57105e-06 1.800 2.57200e-06 1.800 2.57205e-06 0.000 2.57300e-06 0.000
+ 2.57305e-06 1.800 2.57600e-06 1.800 2.57605e-06 0.000 2.57700e-06 0.000 2.57705e-06 1.800 2.57900e-06 1.800
+ 2.57905e-06 0.000 2.58000e-06 0.000 2.58005e-06 1.800 2.58100e-06 1.800 2.58105e-06 0.000 2.58800e-06 0.000
+ 2.58805e-06 1.800 2.58900e-06 1.800 2.58905e-06 0.000 2.59300e-06 0.000 2.59305e-06 1.800 2.59500e-06 1.800
+ 2.59505e-06 0.000 2.59600e-06 0.000 2.59605e-06 1.800 2.59800e-06 1.800 2.59805e-06 0.000 2.59900e-06 0.000
+ 2.59905e-06 1.800 2.60000e-06 1.800 2.60005e-06 0.000 2.60600e-06 0.000 2.60605e-06 1.800 2.60800e-06 1.800
+ 2.60805e-06 0.000 2.60900e-06 0.000 2.60905e-06 1.800 2.61000e-06 1.800 2.61005e-06 0.000 2.61200e-06 0.000
+ 2.61205e-06 1.800 2.61300e-06 1.800 2.61305e-06 0.000 2.61600e-06 0.000 2.61605e-06 1.800 2.61900e-06 1.800
+ 2.61905e-06 0.000 2.62100e-06 0.000 2.62105e-06 1.800 2.62200e-06 1.800 2.62205e-06 0.000 2.62400e-06 0.000
+ 2.62405e-06 1.800 2.62700e-06 1.800 2.62705e-06 0.000 2.62900e-06 0.000 2.62905e-06 1.800 2.63000e-06 1.800
+ 2.63005e-06 0.000 2.63100e-06 0.000 2.63105e-06 1.800 2.63600e-06 1.800 2.63605e-06 0.000 2.63900e-06 0.000
+ 2.63905e-06 1.800 2.64000e-06 1.800 2.64005e-06 0.000 2.64100e-06 0.000 2.64105e-06 1.800 2.64200e-06 1.800
+ 2.64205e-06 0.000 2.64300e-06 0.000 2.64305e-06 1.800 2.64400e-06 1.800 2.64405e-06 0.000 2.64700e-06 0.000
+ 2.64705e-06 1.800 2.64900e-06 1.800 2.64905e-06 0.000 2.65200e-06 0.000 2.65205e-06 1.800 2.65400e-06 1.800
+ 2.65405e-06 0.000 2.65500e-06 0.000 2.65505e-06 1.800 2.65600e-06 1.800 2.65605e-06 0.000 2.65700e-06 0.000
+ 2.65705e-06 1.800 2.65900e-06 1.800 2.65905e-06 0.000 2.66500e-06 0.000 2.66505e-06 1.800 2.66700e-06 1.800
+ 2.66705e-06 0.000 2.67000e-06 0.000 2.67005e-06 1.800 2.67100e-06 1.800 2.67105e-06 0.000 2.67200e-06 0.000
+ 2.67205e-06 1.800 2.67300e-06 1.800 2.67305e-06 0.000 2.67400e-06 0.000 2.67405e-06 1.800 2.67600e-06 1.800
+ 2.67605e-06 0.000 2.67700e-06 0.000 2.67705e-06 1.800 2.67800e-06 1.800 2.67805e-06 0.000 2.68000e-06 0.000
+ 2.68005e-06 1.800 2.68200e-06 1.800 2.68205e-06 0.000 2.68300e-06 0.000 2.68305e-06 1.800 2.68700e-06 1.800
+ 2.68705e-06 0.000 2.68900e-06 0.000 2.68905e-06 1.800 2.69000e-06 1.800 2.69005e-06 0.000 2.69100e-06 0.000
+ 2.69105e-06 1.800 2.69200e-06 1.800 2.69205e-06 0.000 2.69400e-06 0.000 2.69405e-06 1.800 2.69600e-06 1.800
+ 2.69605e-06 0.000 2.69700e-06 0.000 2.69705e-06 1.800 2.69800e-06 1.800 2.69805e-06 0.000 2.69900e-06 0.000
+ 2.69905e-06 1.800 2.70000e-06 1.800 2.70005e-06 0.000 2.70300e-06 0.000 2.70305e-06 1.800 2.70400e-06 1.800
+ 2.70405e-06 0.000 2.70600e-06 0.000 2.70605e-06 1.800 2.70700e-06 1.800 2.70705e-06 0.000 2.70900e-06 0.000
+ 2.70905e-06 1.800 2.71100e-06 1.800 2.71105e-06 0.000 2.71300e-06 0.000 2.71305e-06 1.800 2.71600e-06 1.800
+ 2.71605e-06 0.000 2.71800e-06 0.000 2.71805e-06 1.800 2.72000e-06 1.800 2.72005e-06 0.000 2.72100e-06 0.000
+ 2.72105e-06 1.800 2.72200e-06 1.800 2.72205e-06 0.000 2.72600e-06 0.000 2.72605e-06 1.800 2.72900e-06 1.800
+ 2.72905e-06 0.000 2.73200e-06 0.000 2.73205e-06 1.800 2.73400e-06 1.800 2.73405e-06 0.000 2.73500e-06 0.000
+ 2.73505e-06 1.800 2.73600e-06 1.800 2.73605e-06 0.000 2.73900e-06 0.000 2.73905e-06 1.800 2.74100e-06 1.800
+ 2.74105e-06 0.000 2.74500e-06 0.000 2.74505e-06 1.800 2.74700e-06 1.800 2.74705e-06 0.000 2.74800e-06 0.000
+ 2.74805e-06 1.800 2.75000e-06 1.800 2.75005e-06 0.000 2.75200e-06 0.000 2.75205e-06 1.800 2.75300e-06 1.800
+ 2.75305e-06 0.000 2.75500e-06 0.000 2.75505e-06 1.800 2.75600e-06 1.800 2.75605e-06 0.000 2.75700e-06 0.000
+ 2.75705e-06 1.800 2.75900e-06 1.800 2.75905e-06 0.000 2.76000e-06 0.000 2.76005e-06 1.800 2.76100e-06 1.800
+ 2.76105e-06 0.000 2.76300e-06 0.000 2.76305e-06 1.800 2.76500e-06 1.800 2.76505e-06 0.000 2.76900e-06 0.000
+ 2.76905e-06 1.800 2.77000e-06 1.800 2.77005e-06 0.000 2.77100e-06 0.000 2.77105e-06 1.800 2.77200e-06 1.800
+ 2.77205e-06 0.000 2.77400e-06 0.000 2.77405e-06 1.800 2.77800e-06 1.800 2.77805e-06 0.000 2.78000e-06 0.000
+ 2.78005e-06 1.800 2.78100e-06 1.800 2.78105e-06 0.000 2.78200e-06 0.000 2.78205e-06 1.800 2.78700e-06 1.800
+ 2.78705e-06 0.000 2.78800e-06 0.000 2.78805e-06 1.800 2.78900e-06 1.800 2.78905e-06 0.000 2.79000e-06 0.000
+ 2.79005e-06 1.800 2.79500e-06 1.800 2.79505e-06 0.000 2.79700e-06 0.000 2.79705e-06 1.800 2.79800e-06 1.800
+ 2.79805e-06 0.000 2.80000e-06 0.000 2.80005e-06 1.800 2.80200e-06 1.800 2.80205e-06 0.000 2.80300e-06 0.000
+ 2.80305e-06 1.800 2.80400e-06 1.800 2.80405e-06 0.000 2.80500e-06 0.000 2.80505e-06 1.800 2.80700e-06 1.800
+ 2.80705e-06 0.000 2.80800e-06 0.000 2.80805e-06 1.800 2.81200e-06 1.800 2.81205e-06 0.000 2.81400e-06 0.000
+ 2.81405e-06 1.800 2.81500e-06 1.800 2.81505e-06 0.000 2.81600e-06 0.000 2.81605e-06 1.800 2.81900e-06 1.800
+ 2.81905e-06 0.000 2.82000e-06 0.000 2.82005e-06 1.800 2.82100e-06 1.800 2.82105e-06 0.000 2.82400e-06 0.000
+ 2.82405e-06 1.800 2.82500e-06 1.800 2.82505e-06 0.000 2.83000e-06 0.000 2.83005e-06 1.800 2.83100e-06 1.800
+ 2.83105e-06 0.000 2.83400e-06 0.000 2.83405e-06 1.800 2.83600e-06 1.800 2.83605e-06 0.000 2.83900e-06 0.000
+ 2.83905e-06 1.800 2.84000e-06 1.800 2.84005e-06 0.000 2.84200e-06 0.000 2.84205e-06 1.800 2.84300e-06 1.800
+ 2.84305e-06 0.000 2.84400e-06 0.000 2.84405e-06 1.800 2.84500e-06 1.800 2.84505e-06 0.000 2.84600e-06 0.000
+ 2.84605e-06 1.800 2.84900e-06 1.800 2.84905e-06 0.000 2.85000e-06 0.000 2.85005e-06 1.800 2.85100e-06 1.800
+ 2.85105e-06 0.000 2.85300e-06 0.000 2.85305e-06 1.800 2.85400e-06 1.800 2.85405e-06 0.000 2.85500e-06 0.000
+ 2.85505e-06 1.800 2.85600e-06 1.800 2.85605e-06 0.000 2.85700e-06 0.000 2.85705e-06 1.800 2.85800e-06 1.800
+ 2.85805e-06 0.000 2.86000e-06 0.000 2.86005e-06 1.800 2.86100e-06 1.800 2.86105e-06 0.000 2.86300e-06 0.000
+ 2.86305e-06 1.800 2.86400e-06 1.800 2.86405e-06 0.000 2.86600e-06 0.000 2.86605e-06 1.800 2.86700e-06 1.800
+ 2.86705e-06 0.000 2.87000e-06 0.000 2.87005e-06 1.800 2.87500e-06 1.800 2.87505e-06 0.000 2.88000e-06 0.000
+ 2.88005e-06 1.800 2.88100e-06 1.800 2.88105e-06 0.000 2.88200e-06 0.000 2.88205e-06 1.800 2.88300e-06 1.800
+ 2.88305e-06 0.000 2.88700e-06 0.000 2.88705e-06 1.800 2.88800e-06 1.800 2.88805e-06 0.000 2.88900e-06 0.000
+ 2.88905e-06 1.800 2.89100e-06 1.800 2.89105e-06 0.000 2.89200e-06 0.000 2.89205e-06 1.800 2.89400e-06 1.800
+ 2.89405e-06 0.000 2.89600e-06 0.000 2.89605e-06 1.800 2.89900e-06 1.800 2.89905e-06 0.000 2.90000e-06 0.000
+ 2.90005e-06 1.800 2.90100e-06 1.800 2.90105e-06 0.000 2.90400e-06 0.000 2.90405e-06 1.800 2.90800e-06 1.800
+ 2.90805e-06 0.000 2.91100e-06 0.000 2.91105e-06 1.800 2.91900e-06 1.800 2.91905e-06 0.000 2.92400e-06 0.000
+ 2.92405e-06 1.800 2.92500e-06 1.800 2.92505e-06 0.000 2.92900e-06 0.000 2.92905e-06 1.800 2.93300e-06 1.800
+ 2.93305e-06 0.000 2.93700e-06 0.000 2.93705e-06 1.800 2.93800e-06 1.800 2.93805e-06 0.000 2.94200e-06 0.000
+ 2.94205e-06 1.800 2.94300e-06 1.800 2.94305e-06 0.000 2.94400e-06 0.000 2.94405e-06 1.800 2.94500e-06 1.800
+ 2.94505e-06 0.000 2.94700e-06 0.000 2.94705e-06 1.800 2.94900e-06 1.800 2.94905e-06 0.000 2.95000e-06 0.000
+ 2.95005e-06 1.800 2.95500e-06 1.800 2.95505e-06 0.000 2.95600e-06 0.000 2.95605e-06 1.800 2.95800e-06 1.800
+ 2.95805e-06 0.000 2.96100e-06 0.000 2.96105e-06 1.800 2.96400e-06 1.800 2.96405e-06 0.000 2.96500e-06 0.000
+ 2.96505e-06 1.800 2.96600e-06 1.800 2.96605e-06 0.000 2.96700e-06 0.000 2.96705e-06 1.800 2.96900e-06 1.800
+ 2.96905e-06 0.000 2.97000e-06 0.000 2.97005e-06 1.800 2.97100e-06 1.800 2.97105e-06 0.000 2.97200e-06 0.000
+ 2.97205e-06 1.800 2.97400e-06 1.800 2.97405e-06 0.000 2.97600e-06 0.000 2.97605e-06 1.800 2.97900e-06 1.800
+ 2.97905e-06 0.000 2.98000e-06 0.000 2.98005e-06 1.800 2.98100e-06 1.800 2.98105e-06 0.000 2.98200e-06 0.000
+ 2.98205e-06 1.800 2.98600e-06 1.800 2.98605e-06 0.000 2.98700e-06 0.000 2.98705e-06 1.800 2.98900e-06 1.800
+ 2.98905e-06 0.000 2.99200e-06 0.000 2.99205e-06 1.800 2.99300e-06 1.800 2.99305e-06 0.000 2.99400e-06 0.000
+ 2.99405e-06 1.800 2.99500e-06 1.800 2.99505e-06 0.000 2.99600e-06 0.000 2.99605e-06 1.800 2.99800e-06 1.800
+ 2.99805e-06 0.000 3.00000e-06 0.000 3.00005e-06 1.800 3.00200e-06 1.800 3.00205e-06 0.000 3.00300e-06 0.000
+ 3.00305e-06 1.800 3.00400e-06 1.800 3.00405e-06 0.000 3.00600e-06 0.000 3.00605e-06 1.800 3.00900e-06 1.800
+ 3.00905e-06 0.000 3.01100e-06 0.000 3.01105e-06 1.800 3.01500e-06 1.800 3.01505e-06 0.000 3.01700e-06 0.000
+ 3.01705e-06 1.800 3.01800e-06 1.800 3.01805e-06 0.000 3.01900e-06 0.000 3.01905e-06 1.800 3.02000e-06 1.800
+ 3.02005e-06 0.000 3.02300e-06 0.000 3.02305e-06 1.800 3.02500e-06 1.800 3.02505e-06 0.000 3.02600e-06 0.000
+ 3.02605e-06 1.800 3.02700e-06 1.800 3.02705e-06 0.000 3.03000e-06 0.000 3.03005e-06 1.800 3.03100e-06 1.800
+ 3.03105e-06 0.000 3.03300e-06 0.000 3.03305e-06 1.800 3.03400e-06 1.800 3.03405e-06 0.000 3.03500e-06 0.000
+ 3.03505e-06 1.800 3.03600e-06 1.800 3.03605e-06 0.000 3.03700e-06 0.000 3.03705e-06 1.800 3.03800e-06 1.800
+ 3.03805e-06 0.000 3.03900e-06 0.000 3.03905e-06 1.800 3.04100e-06 1.800 3.04105e-06 0.000 3.04200e-06 0.000
+ 3.04205e-06 1.800 3.04600e-06 1.800 3.04605e-06 0.000 3.04700e-06 0.000 3.04705e-06 1.800 3.04900e-06 1.800
+ 3.04905e-06 0.000 3.05000e-06 0.000 3.05005e-06 1.800 3.05100e-06 1.800 3.05105e-06 0.000 3.05200e-06 0.000
+ 3.05205e-06 1.800 3.05400e-06 1.800 3.05405e-06 0.000 3.05600e-06 0.000 3.05605e-06 1.800 3.05800e-06 1.800
+ 3.05805e-06 0.000 3.06100e-06 0.000 3.06105e-06 1.800 3.06300e-06 1.800 3.06305e-06 0.000 3.06400e-06 0.000
+ 3.06405e-06 1.800 3.06500e-06 1.800 3.06505e-06 0.000 3.06600e-06 0.000 3.06605e-06 1.800 3.06700e-06 1.800
+ 3.06705e-06 0.000 3.06800e-06 0.000 3.06805e-06 1.800 3.07100e-06 1.800 3.07105e-06 0.000 3.07400e-06 0.000
+ 3.07405e-06 1.800 3.07800e-06 1.800 3.07805e-06 0.000 3.07900e-06 0.000 3.07905e-06 1.800 3.08000e-06 1.800
+ 3.08005e-06 0.000 3.08100e-06 0.000 3.08105e-06 1.800 3.08300e-06 1.800 3.08305e-06 0.000 3.08700e-06 0.000
+ 3.08705e-06 1.800 3.08800e-06 1.800 3.08805e-06 0.000 3.09300e-06 0.000 3.09305e-06 1.800 3.09500e-06 1.800
+ 3.09505e-06 0.000 3.09600e-06 0.000 3.09605e-06 1.800 3.10600e-06 1.800 3.10605e-06 0.000 3.10800e-06 0.000
+ 3.10805e-06 1.800 3.10900e-06 1.800 3.10905e-06 0.000 3.11000e-06 0.000 3.11005e-06 1.800 3.11100e-06 1.800
+ 3.11105e-06 0.000 3.11400e-06 0.000 3.11405e-06 1.800 3.11500e-06 1.800 3.11505e-06 0.000 3.11600e-06 0.000
+ 3.11605e-06 1.800 3.11900e-06 1.800 3.11905e-06 0.000 3.12100e-06 0.000 3.12105e-06 1.800 3.12600e-06 1.800
+ 3.12605e-06 0.000 3.12700e-06 0.000 3.12705e-06 1.800 3.12900e-06 1.800 3.12905e-06 0.000 3.13000e-06 0.000
+ 3.13005e-06 1.800 3.13100e-06 1.800 3.13105e-06 0.000 3.13200e-06 0.000 3.13205e-06 1.800 3.13500e-06 1.800
+ 3.13505e-06 0.000 3.13600e-06 0.000 3.13605e-06 1.800 3.13800e-06 1.800 3.13805e-06 0.000 3.14000e-06 0.000
+ 3.14005e-06 1.800 3.14600e-06 1.800 3.14605e-06 0.000 3.15400e-06 0.000 3.15405e-06 1.800 3.15500e-06 1.800
+ 3.15505e-06 0.000 3.15800e-06 0.000 3.15805e-06 1.800 3.16100e-06 1.800 3.16105e-06 0.000 3.16200e-06 0.000
+ 3.16205e-06 1.800 3.16300e-06 1.800 3.16305e-06 0.000 3.16600e-06 0.000 3.16605e-06 1.800 3.16700e-06 1.800
+ 3.16705e-06 0.000 3.16800e-06 0.000 3.16805e-06 1.800 3.16900e-06 1.800 3.16905e-06 0.000 3.17000e-06 0.000
+ 3.17005e-06 1.800 3.17300e-06 1.800 3.17305e-06 0.000 3.17600e-06 0.000 3.17605e-06 1.800 3.17700e-06 1.800
+ 3.17705e-06 0.000 3.17800e-06 0.000 3.17805e-06 1.800 3.17900e-06 1.800 3.17905e-06 0.000 3.18100e-06 0.000
+ 3.18105e-06 1.800 3.18200e-06 1.800 3.18205e-06 0.000 3.18400e-06 0.000 3.18405e-06 1.800 3.18700e-06 1.800
+ 3.18705e-06 0.000 3.18800e-06 0.000 3.18805e-06 1.800 3.18900e-06 1.800 3.18905e-06 0.000 3.19000e-06 0.000
+ 3.19005e-06 1.800 3.19300e-06 1.800 3.19305e-06 0.000 3.19500e-06 0.000 3.19505e-06 1.800 3.19800e-06 1.800
+ 3.19805e-06 0.000 3.20000e-06 0.000 3.20005e-06 1.800 3.20100e-06 1.800 3.20105e-06 0.000 3.20500e-06 0.000
+ 3.20505e-06 1.800 3.20700e-06 1.800 3.20705e-06 0.000 3.20800e-06 0.000 3.20805e-06 1.800 3.21000e-06 1.800
+ 3.21005e-06 0.000 3.21100e-06 0.000 3.21105e-06 1.800 3.21200e-06 1.800 3.21205e-06 0.000 3.21300e-06 0.000
+ 3.21305e-06 1.800 3.21600e-06 1.800 3.21605e-06 0.000 3.21700e-06 0.000 3.21705e-06 1.800 3.21800e-06 1.800
+ 3.21805e-06 0.000 3.22100e-06 0.000 3.22105e-06 1.800 3.22200e-06 1.800 3.22205e-06 0.000 3.22300e-06 0.000
+ 3.22305e-06 1.800 3.22400e-06 1.800 3.22405e-06 0.000 3.22500e-06 0.000 3.22505e-06 1.800 3.22600e-06 1.800
+ 3.22605e-06 0.000 3.22700e-06 0.000 3.22705e-06 1.800 3.22800e-06 1.800 3.22805e-06 0.000 3.23000e-06 0.000
+ 3.23005e-06 1.800 3.23200e-06 1.800 3.23205e-06 0.000 3.23300e-06 0.000 3.23305e-06 1.800 3.23800e-06 1.800
+ 3.23805e-06 0.000 3.23900e-06 0.000 3.23905e-06 1.800 3.24200e-06 1.800 3.24205e-06 0.000 3.24300e-06 0.000
+ 3.24305e-06 1.800 3.24400e-06 1.800 3.24405e-06 0.000 3.24600e-06 0.000 3.24605e-06 1.800 3.24800e-06 1.800
+ 3.24805e-06 0.000 3.24900e-06 0.000 3.24905e-06 1.800 3.25100e-06 1.800 3.25105e-06 0.000 3.25300e-06 0.000
+ 3.25305e-06 1.800 3.25700e-06 1.800 3.25705e-06 0.000 3.25900e-06 0.000 3.25905e-06 1.800 3.26000e-06 1.800
+ 3.26005e-06 0.000 3.26200e-06 0.000 3.26205e-06 1.800 3.26600e-06 1.800 3.26605e-06 0.000 3.27200e-06 0.000
+ 3.27205e-06 1.800 3.27300e-06 1.800 3.27305e-06 0.000 3.27400e-06 0.000 3.27405e-06 1.800 3.27600e-06 1.800
+ 3.27605e-06 0.000 3.27700e-06 0.000 3.27705e-06 1.800 3.27900e-06 1.800 3.27905e-06 0.000 3.28000e-06 0.000
+ 3.28005e-06 1.800 3.28100e-06 1.800 3.28105e-06 0.000 3.28200e-06 0.000 3.28205e-06 1.800 3.28400e-06 1.800
+ 3.28405e-06 0.000 3.28800e-06 0.000 3.28805e-06 1.800 3.28900e-06 1.800 3.28905e-06 0.000 3.29000e-06 0.000
+ 3.29005e-06 1.800 3.29100e-06 1.800 3.29105e-06 0.000 3.29200e-06 0.000 3.29205e-06 1.800 3.29300e-06 1.800
+ 3.29305e-06 0.000 3.29400e-06 0.000 3.29405e-06 1.800 3.29600e-06 1.800 3.29605e-06 0.000 3.29700e-06 0.000
+ 3.29705e-06 1.800 3.30000e-06 1.800 3.30005e-06 0.000 3.30100e-06 0.000 3.30105e-06 1.800 3.30500e-06 1.800
+ 3.30505e-06 0.000 3.30900e-06 0.000 3.30905e-06 1.800 3.31000e-06 1.800 3.31005e-06 0.000 3.31100e-06 0.000
+ 3.31105e-06 1.800 3.31600e-06 1.800 3.31605e-06 0.000 3.31700e-06 0.000 3.31705e-06 1.800 3.31900e-06 1.800
+ 3.31905e-06 0.000 3.32000e-06 0.000 3.32005e-06 1.800 3.32100e-06 1.800 3.32105e-06 0.000 3.32200e-06 0.000
+ 3.32205e-06 1.800 3.32400e-06 1.800 3.32405e-06 0.000 3.32500e-06 0.000 3.32505e-06 1.800 3.32600e-06 1.800
+ 3.32605e-06 0.000 3.32700e-06 0.000 3.32705e-06 1.800 3.32900e-06 1.800 3.32905e-06 0.000 3.33000e-06 0.000
+ 3.33005e-06 1.800 3.33500e-06 1.800 3.33505e-06 0.000 3.34000e-06 0.000 3.34005e-06 1.800 3.34400e-06 1.800
+ 3.34405e-06 0.000 3.34500e-06 0.000 3.34505e-06 1.800 3.34700e-06 1.800 3.34705e-06 0.000 3.34800e-06 0.000
+ 3.34805e-06 1.800 3.34900e-06 1.800 3.34905e-06 0.000 3.35000e-06 0.000 3.35005e-06 1.800 3.35300e-06 1.800
+ 3.35305e-06 0.000 3.35500e-06 0.000 3.35505e-06 1.800 3.35800e-06 1.800 3.35805e-06 0.000 3.35900e-06 0.000
+ 3.35905e-06 1.800 3.36000e-06 1.800 3.36005e-06 0.000 3.36100e-06 0.000 3.36105e-06 1.800 3.36300e-06 1.800
+ 3.36305e-06 0.000 3.36400e-06 0.000 3.36405e-06 1.800 3.36500e-06 1.800 3.36505e-06 0.000 3.36600e-06 0.000
+ 3.36605e-06 1.800 3.36800e-06 1.800 3.36805e-06 0.000 3.37700e-06 0.000 3.37705e-06 1.800 3.37800e-06 1.800
+ 3.37805e-06 0.000 3.37900e-06 0.000 3.37905e-06 1.800 3.38000e-06 1.800 3.38005e-06 0.000 3.38100e-06 0.000
+ 3.38105e-06 1.800 3.38400e-06 1.800 3.38405e-06 0.000 3.38500e-06 0.000 3.38505e-06 1.800 3.38600e-06 1.800
+ 3.38605e-06 0.000 3.38800e-06 0.000 3.38805e-06 1.800 3.39100e-06 1.800 3.39105e-06 0.000 3.39200e-06 0.000
+ 3.39205e-06 1.800 3.39300e-06 1.800 3.39305e-06 0.000 3.39500e-06 0.000 3.39505e-06 1.800 3.39600e-06 1.800
+ 3.39605e-06 0.000 3.39900e-06 0.000 3.39905e-06 1.800 3.40100e-06 1.800 3.40105e-06 0.000 3.40200e-06 0.000
+ 3.40205e-06 1.800 3.40300e-06 1.800 3.40305e-06 0.000 3.40400e-06 0.000 3.40405e-06 1.800 3.40500e-06 1.800
+ 3.40505e-06 0.000 3.40600e-06 0.000 3.40605e-06 1.800 3.40700e-06 1.800 3.40705e-06 0.000 3.40900e-06 0.000
+ 3.40905e-06 1.800 3.41100e-06 1.800 3.41105e-06 0.000 3.41200e-06 0.000 3.41205e-06 1.800 3.41400e-06 1.800
+ 3.41405e-06 0.000 3.41700e-06 0.000 3.41705e-06 1.800 3.41800e-06 1.800 3.41805e-06 0.000 3.41900e-06 0.000
+ 3.41905e-06 1.800 3.42000e-06 1.800 3.42005e-06 0.000 3.42600e-06 0.000 3.42605e-06 1.800 3.42700e-06 1.800
+ 3.42705e-06 0.000 3.42800e-06 0.000 3.42805e-06 1.800 3.42900e-06 1.800 3.42905e-06 0.000 3.43000e-06 0.000
+ 3.43005e-06 1.800 3.43300e-06 1.800 3.43305e-06 0.000 3.43500e-06 0.000 3.43505e-06 1.800 3.43800e-06 1.800
+ 3.43805e-06 0.000 3.44000e-06 0.000 3.44005e-06 1.800 3.44100e-06 1.800 3.44105e-06 0.000 3.44500e-06 0.000
+ 3.44505e-06 1.800 3.44600e-06 1.800 3.44605e-06 0.000 3.44800e-06 0.000 3.44805e-06 1.800 3.45400e-06 1.800
+ 3.45405e-06 0.000 3.45500e-06 0.000 3.45505e-06 1.800 3.45600e-06 1.800 3.45605e-06 0.000 3.45800e-06 0.000
+ 3.45805e-06 1.800 3.46000e-06 1.800 3.46005e-06 0.000 3.46100e-06 0.000 3.46105e-06 1.800 3.46200e-06 1.800
+ 3.46205e-06 0.000 3.46300e-06 0.000 3.46305e-06 1.800 3.46700e-06 1.800 3.46705e-06 0.000 3.46800e-06 0.000
+ 3.46805e-06 1.800 3.47000e-06 1.800 3.47005e-06 0.000 3.47200e-06 0.000 3.47205e-06 1.800 3.47300e-06 1.800
+ 3.47305e-06 0.000 3.47400e-06 0.000 3.47405e-06 1.800 3.47500e-06 1.800 3.47505e-06 0.000 3.47700e-06 0.000
+ 3.47705e-06 1.800 3.47900e-06 1.800 3.47905e-06 0.000 3.48000e-06 0.000 3.48005e-06 1.800 3.48200e-06 1.800
+ 3.48205e-06 0.000 3.48300e-06 0.000 3.48305e-06 1.800 3.48600e-06 1.800 3.48605e-06 0.000 3.48700e-06 0.000
+ 3.48705e-06 1.800 3.48800e-06 1.800 3.48805e-06 0.000 3.48900e-06 0.000 3.48905e-06 1.800 3.49000e-06 1.800
+ 3.49005e-06 0.000 3.49200e-06 0.000 3.49205e-06 1.800 3.49300e-06 1.800 3.49305e-06 0.000 3.49400e-06 0.000
+ 3.49405e-06 1.800 3.49600e-06 1.800 3.49605e-06 0.000 3.50100e-06 0.000 3.50105e-06 1.800 3.50200e-06 1.800
+ 3.50205e-06 0.000 3.50500e-06 0.000 3.50505e-06 1.800 3.50600e-06 1.800 3.50605e-06 0.000 3.50800e-06 0.000
+ 3.50805e-06 1.800 3.51000e-06 1.800 3.51005e-06 0.000 3.51200e-06 0.000 3.51205e-06 1.800 3.51500e-06 1.800
+ 3.51505e-06 0.000 3.51700e-06 0.000 3.51705e-06 1.800 3.51900e-06 1.800 3.51905e-06 0.000 3.52100e-06 0.000
+ 3.52105e-06 1.800 3.52400e-06 1.800 3.52405e-06 0.000 3.52500e-06 0.000 3.52505e-06 1.800 3.52600e-06 1.800
+ 3.52605e-06 0.000 3.52700e-06 0.000 3.52705e-06 1.800 3.53100e-06 1.800 3.53105e-06 0.000 3.53200e-06 0.000
+ 3.53205e-06 1.800 3.53400e-06 1.800 3.53405e-06 0.000 3.53700e-06 0.000 3.53705e-06 1.800 3.54100e-06 1.800
+ 3.54105e-06 0.000 3.54200e-06 0.000 3.54205e-06 1.800 3.54300e-06 1.800 3.54305e-06 0.000 3.54400e-06 0.000
+ 3.54405e-06 1.800 3.54700e-06 1.800 3.54705e-06 0.000 3.54800e-06 0.000 3.54805e-06 1.800 3.54900e-06 1.800
+ 3.54905e-06 0.000 3.55100e-06 0.000 3.55105e-06 1.800 3.55200e-06 1.800 3.55205e-06 0.000 3.55700e-06 0.000
+ 3.55705e-06 1.800 3.55800e-06 1.800 3.55805e-06 0.000 3.56000e-06 0.000 3.56005e-06 1.800 3.56200e-06 1.800
+ 3.56205e-06 0.000 3.56300e-06 0.000 3.56305e-06 1.800 3.56400e-06 1.800 3.56405e-06 0.000 3.56600e-06 0.000
+ 3.56605e-06 1.800 3.56700e-06 1.800 3.56705e-06 0.000 3.56800e-06 0.000 3.56805e-06 1.800 3.57700e-06 1.800
+ 3.57705e-06 0.000 3.57900e-06 0.000 3.57905e-06 1.800 3.58000e-06 1.800 3.58005e-06 0.000 3.58400e-06 0.000
+ 3.58405e-06 1.800 3.58500e-06 1.800 3.58505e-06 0.000 3.58800e-06 0.000 3.58805e-06 1.800 3.58900e-06 1.800
+ 3.58905e-06 0.000 3.59100e-06 0.000 3.59105e-06 1.800 3.59300e-06 1.800 3.59305e-06 0.000 3.59400e-06 0.000
+ 3.59405e-06 1.800 3.59500e-06 1.800 3.59505e-06 0.000 3.59600e-06 0.000 3.59605e-06 1.800 3.60400e-06 1.800
+ 3.60405e-06 0.000 3.60700e-06 0.000 3.60705e-06 1.800 3.61000e-06 1.800 3.61005e-06 0.000 3.61100e-06 0.000
+ 3.61105e-06 1.800 3.61300e-06 1.800 3.61305e-06 0.000 3.61400e-06 0.000 3.61405e-06 1.800 3.61500e-06 1.800
+ 3.61505e-06 0.000 3.61700e-06 0.000 3.61705e-06 1.800 3.61900e-06 1.800 3.61905e-06 0.000 3.62400e-06 0.000
+ 3.62405e-06 1.800 3.62500e-06 1.800 3.62505e-06 0.000 3.62800e-06 0.000 3.62805e-06 1.800 3.62900e-06 1.800
+ 3.62905e-06 0.000 3.63300e-06 0.000 3.63305e-06 1.800 3.63400e-06 1.800 3.63405e-06 0.000 3.63500e-06 0.000
+ 3.63505e-06 1.800 3.63600e-06 1.800 3.63605e-06 0.000 3.63800e-06 0.000 3.63805e-06 1.800 3.64100e-06 1.800
+ 3.64105e-06 0.000 3.64700e-06 0.000 3.64705e-06 1.800 3.64900e-06 1.800 3.64905e-06 0.000 3.65000e-06 0.000
+ 3.65005e-06 1.800 3.65200e-06 1.800 3.65205e-06 0.000 3.65400e-06 0.000 3.65405e-06 1.800 3.65700e-06 1.800
+ 3.65705e-06 0.000 3.65900e-06 0.000 3.65905e-06 1.800 3.66200e-06 1.800 3.66205e-06 0.000 3.66300e-06 0.000
+ 3.66305e-06 1.800 3.66400e-06 1.800 3.66405e-06 0.000 3.66600e-06 0.000 3.66605e-06 1.800 3.66900e-06 1.800
+ 3.66905e-06 0.000 3.67000e-06 0.000 3.67005e-06 1.800 3.67200e-06 1.800 3.67205e-06 0.000 3.67400e-06 0.000
+ 3.67405e-06 1.800 3.68000e-06 1.800 3.68005e-06 0.000 3.68100e-06 0.000 3.68105e-06 1.800 3.68300e-06 1.800
+ 3.68305e-06 0.000 3.68700e-06 0.000 3.68705e-06 1.800 3.68900e-06 1.800 3.68905e-06 0.000 3.69000e-06 0.000
+ 3.69005e-06 1.800 3.69100e-06 1.800 3.69105e-06 0.000 3.69300e-06 0.000 3.69305e-06 1.800 3.69800e-06 1.800
+ 3.69805e-06 0.000 3.70000e-06 0.000 3.70005e-06 1.800 3.70200e-06 1.800 3.70205e-06 0.000 3.70400e-06 0.000
+ 3.70405e-06 1.800 3.70500e-06 1.800 3.70505e-06 0.000 3.70700e-06 0.000 3.70705e-06 1.800 3.70800e-06 1.800
+ 3.70805e-06 0.000 3.71300e-06 0.000 3.71305e-06 1.800 3.71400e-06 1.800 3.71405e-06 0.000 3.71500e-06 0.000
+ 3.71505e-06 1.800 3.71600e-06 1.800 3.71605e-06 0.000 3.71700e-06 0.000 3.71705e-06 1.800 3.71800e-06 1.800
+ 3.71805e-06 0.000 3.71900e-06 0.000 3.71905e-06 1.800 3.72100e-06 1.800 3.72105e-06 0.000 3.72200e-06 0.000
+ 3.72205e-06 1.800 3.72300e-06 1.800 3.72305e-06 0.000 3.72400e-06 0.000 3.72405e-06 1.800 3.72600e-06 1.800
+ 3.72605e-06 0.000 3.72700e-06 0.000 3.72705e-06 1.800 3.72800e-06 1.800 3.72805e-06 0.000 3.72900e-06 0.000
+ 3.72905e-06 1.800 3.73000e-06 1.800 3.73005e-06 0.000 3.73100e-06 0.000 3.73105e-06 1.800 3.73300e-06 1.800
+ 3.73305e-06 0.000 3.73400e-06 0.000 3.73405e-06 1.800 3.73500e-06 1.800 3.73505e-06 0.000 3.74000e-06 0.000
+ 3.74005e-06 1.800 3.74200e-06 1.800 3.74205e-06 0.000 3.74400e-06 0.000 3.74405e-06 1.800 3.74600e-06 1.800
+ 3.74605e-06 0.000 3.74800e-06 0.000 3.74805e-06 1.800 3.75000e-06 1.800 3.75005e-06 0.000 3.75100e-06 0.000
+ 3.75105e-06 1.800 3.75200e-06 1.800 3.75205e-06 0.000 3.75300e-06 0.000 3.75305e-06 1.800 3.75600e-06 1.800
+ 3.75605e-06 0.000 3.75700e-06 0.000 3.75705e-06 1.800 3.76200e-06 1.800 3.76205e-06 0.000 3.76400e-06 0.000
+ 3.76405e-06 1.800 3.76900e-06 1.800 3.76905e-06 0.000 3.77000e-06 0.000 3.77005e-06 1.800 3.77100e-06 1.800
+ 3.77105e-06 0.000 3.77300e-06 0.000 3.77305e-06 1.800 3.77500e-06 1.800 3.77505e-06 0.000 3.77700e-06 0.000
+ 3.77705e-06 1.800 3.77900e-06 1.800 3.77905e-06 0.000 3.78300e-06 0.000 3.78305e-06 1.800 3.78400e-06 1.800
+ 3.78405e-06 0.000 3.78500e-06 0.000 3.78505e-06 1.800 3.78600e-06 1.800 3.78605e-06 0.000 3.78700e-06 0.000
+ 3.78705e-06 1.800 3.78800e-06 1.800 3.78805e-06 0.000 3.78900e-06 0.000 3.78905e-06 1.800 3.79000e-06 1.800
+ 3.79005e-06 0.000 3.79100e-06 0.000 3.79105e-06 1.800 3.79300e-06 1.800 3.79305e-06 0.000 3.79400e-06 0.000
+ 3.79405e-06 1.800 3.79700e-06 1.800 3.79705e-06 0.000 3.79800e-06 0.000 3.79805e-06 1.800 3.79900e-06 1.800
+ 3.79905e-06 0.000 3.80000e-06 0.000 3.80005e-06 1.800 3.80100e-06 1.800 3.80105e-06 0.000 3.80400e-06 0.000
+ 3.80405e-06 1.800 3.80600e-06 1.800 3.80605e-06 0.000 3.81000e-06 0.000 3.81005e-06 1.800 3.81300e-06 1.800
+ 3.81305e-06 0.000 3.81400e-06 0.000 3.81405e-06 1.800 3.81600e-06 1.800 3.81605e-06 0.000 3.81800e-06 0.000
+ 3.81805e-06 1.800 3.82000e-06 1.800 3.82005e-06 0.000 3.82100e-06 0.000 3.82105e-06 1.800 3.82200e-06 1.800
+ 3.82205e-06 0.000 3.82300e-06 0.000 3.82305e-06 1.800 3.82500e-06 1.800 3.82505e-06 0.000 3.82700e-06 0.000
+ 3.82705e-06 1.800 3.82900e-06 1.800 3.82905e-06 0.000 3.83000e-06 0.000 3.83005e-06 1.800 3.83100e-06 1.800
+ 3.83105e-06 0.000 3.83400e-06 0.000 3.83405e-06 1.800 3.83700e-06 1.800 3.83705e-06 0.000 3.83800e-06 0.000
+ 3.83805e-06 1.800 3.84100e-06 1.800 3.84105e-06 0.000 3.84400e-06 0.000 3.84405e-06 1.800 3.84500e-06 1.800
+ 3.84505e-06 0.000 3.84700e-06 0.000 3.84705e-06 1.800 3.84800e-06 1.800 3.84805e-06 0.000 3.85200e-06 0.000
+ 3.85205e-06 1.800 3.85300e-06 1.800 3.85305e-06 0.000 3.85600e-06 0.000 3.85605e-06 1.800 3.86200e-06 1.800
+ 3.86205e-06 0.000 3.86300e-06 0.000 3.86305e-06 1.800 3.86500e-06 1.800 3.86505e-06 0.000 3.86600e-06 0.000
+ 3.86605e-06 1.800 3.86700e-06 1.800 3.86705e-06 0.000 3.86900e-06 0.000 3.86905e-06 1.800 3.87000e-06 1.800
+ 3.87005e-06 0.000 3.87400e-06 0.000 3.87405e-06 1.800 3.87500e-06 1.800 3.87505e-06 0.000 3.87700e-06 0.000
+ 3.87705e-06 1.800 3.87800e-06 1.800 3.87805e-06 0.000 3.88000e-06 0.000 3.88005e-06 1.800 3.88100e-06 1.800
+ 3.88105e-06 0.000 3.88300e-06 0.000 3.88305e-06 1.800 3.88400e-06 1.800 3.88405e-06 0.000 3.88500e-06 0.000
+ 3.88505e-06 1.800 3.88700e-06 1.800 3.88705e-06 0.000 3.89200e-06 0.000 3.89205e-06 1.800 3.89300e-06 1.800
+ 3.89305e-06 0.000 3.89400e-06 0.000 3.89405e-06 1.800 3.89500e-06 1.800 3.89505e-06 0.000 3.89600e-06 0.000
+ 3.89605e-06 1.800 3.89700e-06 1.800 3.89705e-06 0.000 3.89900e-06 0.000 3.89905e-06 1.800 3.90100e-06 1.800
+ 3.90105e-06 0.000 3.90200e-06 0.000 3.90205e-06 1.800 3.90300e-06 1.800 3.90305e-06 0.000 3.90800e-06 0.000
+ 3.90805e-06 1.800 3.90900e-06 1.800 3.90905e-06 0.000 3.91000e-06 0.000 3.91005e-06 1.800 3.91300e-06 1.800
+ 3.91305e-06 0.000 3.91400e-06 0.000 3.91405e-06 1.800 3.91500e-06 1.800 3.91505e-06 0.000 3.91600e-06 0.000
+ 3.91605e-06 1.800 3.91800e-06 1.800 3.91805e-06 0.000 3.92000e-06 0.000 3.92005e-06 1.800 3.92200e-06 1.800
+ 3.92205e-06 0.000 3.92400e-06 0.000 3.92405e-06 1.800 3.92500e-06 1.800 3.92505e-06 0.000 3.92600e-06 0.000
+ 3.92605e-06 1.800 3.92700e-06 1.800 3.92705e-06 0.000 3.92800e-06 0.000 3.92805e-06 1.800 3.92900e-06 1.800
+ 3.92905e-06 0.000 3.93000e-06 0.000 3.93005e-06 1.800 3.93100e-06 1.800 3.93105e-06 0.000 3.93300e-06 0.000
+ 3.93305e-06 1.800 3.93500e-06 1.800 3.93505e-06 0.000 3.93700e-06 0.000 3.93705e-06 1.800 3.93800e-06 1.800
+ 3.93805e-06 0.000 3.94000e-06 0.000 3.94005e-06 1.800 3.94300e-06 1.800 3.94305e-06 0.000 3.94400e-06 0.000
+ 3.94405e-06 1.800 3.94500e-06 1.800 3.94505e-06 0.000 3.94700e-06 0.000 3.94705e-06 1.800 3.95100e-06 1.800
+ 3.95105e-06 0.000 3.95300e-06 0.000 3.95305e-06 1.800 3.95400e-06 1.800 3.95405e-06 0.000 3.95700e-06 0.000
+ 3.95705e-06 1.800 3.95800e-06 1.800 3.95805e-06 0.000 3.96100e-06 0.000 3.96105e-06 1.800 3.96400e-06 1.800
+ 3.96405e-06 0.000 3.96500e-06 0.000 3.96505e-06 1.800 3.96600e-06 1.800 3.96605e-06 0.000 3.96700e-06 0.000
+ 3.96705e-06 1.800 3.96800e-06 1.800 3.96805e-06 0.000 3.96900e-06 0.000 3.96905e-06 1.800 3.97100e-06 1.800
+ 3.97105e-06 0.000 3.97400e-06 0.000 3.97405e-06 1.800 3.97700e-06 1.800 3.97705e-06 0.000 3.98200e-06 0.000
+ 3.98205e-06 1.800 3.98300e-06 1.800 3.98305e-06 0.000 3.98900e-06 0.000 3.98905e-06 1.800 3.99300e-06 1.800
+ 3.99305e-06 0.000 3.99500e-06 0.000 3.99505e-06 1.800 3.99700e-06 1.800 3.99705e-06 0.000 3.99900e-06 0.000
+ 3.99905e-06 1.800 4.00000e-06 1.800 4.00005e-06 0.000 4.00200e-06 0.000 4.00205e-06 1.800 4.00400e-06 1.800
+ 4.00405e-06 0.000 4.00600e-06 0.000 4.00605e-06 1.800 4.00800e-06 1.800 4.00805e-06 0.000 4.00900e-06 0.000
+ 4.00905e-06 1.800 4.01100e-06 1.800 4.01105e-06 0.000 4.01600e-06 0.000 4.01605e-06 1.800 4.01700e-06 1.800
+ 4.01705e-06 0.000 4.01900e-06 0.000 4.01905e-06 1.800 4.02000e-06 1.800 4.02005e-06 0.000 4.02300e-06 0.000
+ 4.02305e-06 1.800 4.02400e-06 1.800 4.02405e-06 0.000 4.02500e-06 0.000 4.02505e-06 1.800 4.02600e-06 1.800
+ 4.02605e-06 0.000 4.02800e-06 0.000 4.02805e-06 1.800 4.03000e-06 1.800 4.03005e-06 0.000 4.03900e-06 0.000
+ 4.03905e-06 1.800 4.04000e-06 1.800 4.04005e-06 0.000 4.04200e-06 0.000 4.04205e-06 1.800 4.04400e-06 1.800
+ 4.04405e-06 0.000 4.04700e-06 0.000 4.04705e-06 1.800 4.04800e-06 1.800 4.04805e-06 0.000 4.04900e-06 0.000
+ 4.04905e-06 1.800 4.05300e-06 1.800 4.05305e-06 0.000 4.05400e-06 0.000 4.05405e-06 1.800 4.06000e-06 1.800
+ 4.06005e-06 0.000 4.06100e-06 0.000 4.06105e-06 1.800 4.06300e-06 1.800 4.06305e-06 0.000 4.06600e-06 0.000
+ 4.06605e-06 1.800 4.07200e-06 1.800 4.07205e-06 0.000 4.07400e-06 0.000 4.07405e-06 1.800 4.07800e-06 1.800
+ 4.07805e-06 0.000 4.08000e-06 0.000 4.08005e-06 1.800 4.08100e-06 1.800 4.08105e-06 0.000 4.08200e-06 0.000
+ 4.08205e-06 1.800 4.08400e-06 1.800 4.08405e-06 0.000 4.08500e-06 0.000 4.08505e-06 1.800 4.08700e-06 1.800
+ 4.08705e-06 0.000 4.08900e-06 0.000 4.08905e-06 1.800 4.09200e-06 1.800 4.09205e-06 0.000 4.09400e-06 0.000
+ 4.09405e-06 1.800 4.09600e-06 1.800
+ )
Xd_g2b src_g2b g2b vdd gnd tb_inv
Vt2b src_t2b gnd PWL(
+ 0.00000e+00 1.800 3.20000e-08 1.800 3.20500e-08 0.000 6.40000e-08 0.000 6.40500e-08 1.800 9.60000e-08 1.800
+ 9.60500e-08 0.000 1.28000e-07 0.000 1.28050e-07 1.800 1.60000e-07 1.800 1.60050e-07 0.000 1.92000e-07 0.000
+ 1.92050e-07 1.800 2.24000e-07 1.800 2.24050e-07 0.000 2.56000e-07 0.000 2.56050e-07 1.800 2.88000e-07 1.800
+ 2.88050e-07 0.000 3.20000e-07 0.000 3.20050e-07 1.800 3.52000e-07 1.800 3.52050e-07 0.000 3.84000e-07 0.000
+ 3.84050e-07 1.800 4.16000e-07 1.800 4.16050e-07 0.000 4.48000e-07 0.000 4.48050e-07 1.800 4.80000e-07 1.800
+ 4.80050e-07 0.000 5.12000e-07 0.000 5.12050e-07 1.800 5.44000e-07 1.800 5.44050e-07 0.000 5.76000e-07 0.000
+ 5.76050e-07 1.800 6.08000e-07 1.800 6.08050e-07 0.000 6.40000e-07 0.000 6.40050e-07 1.800 6.72000e-07 1.800
+ 6.72050e-07 0.000 7.04000e-07 0.000 7.04050e-07 1.800 7.36000e-07 1.800 7.36050e-07 0.000 7.68000e-07 0.000
+ 7.68050e-07 1.800 8.00000e-07 1.800 8.00050e-07 0.000 8.32000e-07 0.000 8.32050e-07 1.800 8.64000e-07 1.800
+ 8.64050e-07 0.000 8.96000e-07 0.000 8.96050e-07 1.800 9.28000e-07 1.800 9.28050e-07 0.000 9.60000e-07 0.000
+ 9.60050e-07 1.800 9.92000e-07 1.800 9.92050e-07 0.000 1.02400e-06 0.000 1.02405e-06 1.800 1.05600e-06 1.800
+ 1.05605e-06 0.000 1.08800e-06 0.000 1.08805e-06 1.800 1.12000e-06 1.800 1.12005e-06 0.000 1.15200e-06 0.000
+ 1.15205e-06 1.800 1.18400e-06 1.800 1.18405e-06 0.000 1.21600e-06 0.000 1.21605e-06 1.800 1.24800e-06 1.800
+ 1.24805e-06 0.000 1.28000e-06 0.000 1.28005e-06 1.800 1.31200e-06 1.800 1.31205e-06 0.000 1.34400e-06 0.000
+ 1.34405e-06 1.800 1.37600e-06 1.800 1.37605e-06 0.000 1.40800e-06 0.000 1.40805e-06 1.800 1.44000e-06 1.800
+ 1.44005e-06 0.000 1.47200e-06 0.000 1.47205e-06 1.800 1.50400e-06 1.800 1.50405e-06 0.000 1.53600e-06 0.000
+ 1.53605e-06 1.800 1.56800e-06 1.800 1.56805e-06 0.000 1.60000e-06 0.000 1.60005e-06 1.800 1.63200e-06 1.800
+ 1.63205e-06 0.000 1.66400e-06 0.000 1.66405e-06 1.800 1.69600e-06 1.800 1.69605e-06 0.000 1.72800e-06 0.000
+ 1.72805e-06 1.800 1.76000e-06 1.800 1.76005e-06 0.000 1.79200e-06 0.000 1.79205e-06 1.800 1.82400e-06 1.800
+ 1.82405e-06 0.000 1.85600e-06 0.000 1.85605e-06 1.800 1.88800e-06 1.800 1.88805e-06 0.000 1.92000e-06 0.000
+ 1.92005e-06 1.800 1.95200e-06 1.800 1.95205e-06 0.000 1.98400e-06 0.000 1.98405e-06 1.800 2.01600e-06 1.800
+ 2.01605e-06 0.000 2.05100e-06 0.000 2.05105e-06 1.800 2.05300e-06 1.800 2.05305e-06 0.000 2.05800e-06 0.000
+ 2.05805e-06 1.800 2.06000e-06 1.800 2.06005e-06 0.000 2.06200e-06 0.000 2.06205e-06 1.800 2.06400e-06 1.800
+ 2.06405e-06 0.000 2.06500e-06 0.000 2.06505e-06 1.800 2.06600e-06 1.800 2.06605e-06 0.000 2.06900e-06 0.000
+ 2.06905e-06 1.800 2.07000e-06 1.800 2.07005e-06 0.000 2.07100e-06 0.000 2.07105e-06 1.800 2.07300e-06 1.800
+ 2.07305e-06 0.000 2.07500e-06 0.000 2.07505e-06 1.800 2.07600e-06 1.800 2.07605e-06 0.000 2.07900e-06 0.000
+ 2.07905e-06 1.800 2.08000e-06 1.800 2.08005e-06 0.000 2.08400e-06 0.000 2.08405e-06 1.800 2.08900e-06 1.800
+ 2.08905e-06 0.000 2.09000e-06 0.000 2.09005e-06 1.800 2.09200e-06 1.800 2.09205e-06 0.000 2.09300e-06 0.000
+ 2.09305e-06 1.800 2.09600e-06 1.800 2.09605e-06 0.000 2.09700e-06 0.000 2.09705e-06 1.800 2.10100e-06 1.800
+ 2.10105e-06 0.000 2.10200e-06 0.000 2.10205e-06 1.800 2.10400e-06 1.800 2.10405e-06 0.000 2.10600e-06 0.000
+ 2.10605e-06 1.800 2.10800e-06 1.800 2.10805e-06 0.000 2.11200e-06 0.000 2.11205e-06 1.800 2.11400e-06 1.800
+ 2.11405e-06 0.000 2.11600e-06 0.000 2.11605e-06 1.800 2.11800e-06 1.800 2.11805e-06 0.000 2.12100e-06 0.000
+ 2.12105e-06 1.800 2.12300e-06 1.800 2.12305e-06 0.000 2.12400e-06 0.000 2.12405e-06 1.800 2.12500e-06 1.800
+ 2.12505e-06 0.000 2.12600e-06 0.000 2.12605e-06 1.800 2.12900e-06 1.800 2.12905e-06 0.000 2.13000e-06 0.000
+ 2.13005e-06 1.800 2.13400e-06 1.800 2.13405e-06 0.000 2.13600e-06 0.000 2.13605e-06 1.800 2.13900e-06 1.800
+ 2.13905e-06 0.000 2.14200e-06 0.000 2.14205e-06 1.800 2.14300e-06 1.800 2.14305e-06 0.000 2.14600e-06 0.000
+ 2.14605e-06 1.800 2.14700e-06 1.800 2.14705e-06 0.000 2.15300e-06 0.000 2.15305e-06 1.800 2.15400e-06 1.800
+ 2.15405e-06 0.000 2.15600e-06 0.000 2.15605e-06 1.800 2.15900e-06 1.800 2.15905e-06 0.000 2.16000e-06 0.000
+ 2.16005e-06 1.800 2.16600e-06 1.800 2.16605e-06 0.000 2.17000e-06 0.000 2.17005e-06 1.800 2.17600e-06 1.800
+ 2.17605e-06 0.000 2.17700e-06 0.000 2.17705e-06 1.800 2.17900e-06 1.800 2.17905e-06 0.000 2.18100e-06 0.000
+ 2.18105e-06 1.800 2.18300e-06 1.800 2.18305e-06 0.000 2.18400e-06 0.000 2.18405e-06 1.800 2.18500e-06 1.800
+ 2.18505e-06 0.000 2.18600e-06 0.000 2.18605e-06 1.800 2.19100e-06 1.800 2.19105e-06 0.000 2.19300e-06 0.000
+ 2.19305e-06 1.800 2.19500e-06 1.800 2.19505e-06 0.000 2.19600e-06 0.000 2.19605e-06 1.800 2.20300e-06 1.800
+ 2.20305e-06 0.000 2.20400e-06 0.000 2.20405e-06 1.800 2.20700e-06 1.800 2.20705e-06 0.000 2.21100e-06 0.000
+ 2.21105e-06 1.800 2.21200e-06 1.800 2.21205e-06 0.000 2.21300e-06 0.000 2.21305e-06 1.800 2.21500e-06 1.800
+ 2.21505e-06 0.000 2.21600e-06 0.000 2.21605e-06 1.800 2.22100e-06 1.800 2.22105e-06 0.000 2.22200e-06 0.000
+ 2.22205e-06 1.800 2.22400e-06 1.800 2.22405e-06 0.000 2.22700e-06 0.000 2.22705e-06 1.800 2.22800e-06 1.800
+ 2.22805e-06 0.000 2.23000e-06 0.000 2.23005e-06 1.800 2.23100e-06 1.800 2.23105e-06 0.000 2.23200e-06 0.000
+ 2.23205e-06 1.800 2.23400e-06 1.800 2.23405e-06 0.000 2.23600e-06 0.000 2.23605e-06 1.800 2.23700e-06 1.800
+ 2.23705e-06 0.000 2.24100e-06 0.000 2.24105e-06 1.800 2.24400e-06 1.800 2.24405e-06 0.000 2.24500e-06 0.000
+ 2.24505e-06 1.800 2.24600e-06 1.800 2.24605e-06 0.000 2.24800e-06 0.000 2.24805e-06 1.800 2.24900e-06 1.800
+ 2.24905e-06 0.000 2.25000e-06 0.000 2.25005e-06 1.800 2.25100e-06 1.800 2.25105e-06 0.000 2.25200e-06 0.000
+ 2.25205e-06 1.800 2.25400e-06 1.800 2.25405e-06 0.000 2.25500e-06 0.000 2.25505e-06 1.800 2.25600e-06 1.800
+ 2.25605e-06 0.000 2.26100e-06 0.000 2.26105e-06 1.800 2.26300e-06 1.800 2.26305e-06 0.000 2.26400e-06 0.000
+ 2.26405e-06 1.800 2.26500e-06 1.800 2.26505e-06 0.000 2.26700e-06 0.000 2.26705e-06 1.800 2.26800e-06 1.800
+ 2.26805e-06 0.000 2.27400e-06 0.000 2.27405e-06 1.800 2.27700e-06 1.800 2.27705e-06 0.000 2.27800e-06 0.000
+ 2.27805e-06 1.800 2.27900e-06 1.800 2.27905e-06 0.000 2.28100e-06 0.000 2.28105e-06 1.800 2.28300e-06 1.800
+ 2.28305e-06 0.000 2.28700e-06 0.000 2.28705e-06 1.800 2.28800e-06 1.800 2.28805e-06 0.000 2.28900e-06 0.000
+ 2.28905e-06 1.800 2.29100e-06 1.800 2.29105e-06 0.000 2.29200e-06 0.000 2.29205e-06 1.800 2.29300e-06 1.800
+ 2.29305e-06 0.000 2.29400e-06 0.000 2.29405e-06 1.800 2.29600e-06 1.800 2.29605e-06 0.000 2.30000e-06 0.000
+ 2.30005e-06 1.800 2.30100e-06 1.800 2.30105e-06 0.000 2.30500e-06 0.000 2.30505e-06 1.800 2.30900e-06 1.800
+ 2.30905e-06 0.000 2.31500e-06 0.000 2.31505e-06 1.800 2.31700e-06 1.800 2.31705e-06 0.000 2.31800e-06 0.000
+ 2.31805e-06 1.800 2.32000e-06 1.800 2.32005e-06 0.000 2.32600e-06 0.000 2.32605e-06 1.800 2.32700e-06 1.800
+ 2.32705e-06 0.000 2.32800e-06 0.000 2.32805e-06 1.800 2.32900e-06 1.800 2.32905e-06 0.000 2.33300e-06 0.000
+ 2.33305e-06 1.800 2.33400e-06 1.800 2.33405e-06 0.000 2.33500e-06 0.000 2.33505e-06 1.800 2.33700e-06 1.800
+ 2.33705e-06 0.000 2.33800e-06 0.000 2.33805e-06 1.800 2.33900e-06 1.800 2.33905e-06 0.000 2.34000e-06 0.000
+ 2.34005e-06 1.800 2.34200e-06 1.800 2.34205e-06 0.000 2.34400e-06 0.000 2.34405e-06 1.800 2.34600e-06 1.800
+ 2.34605e-06 0.000 2.34700e-06 0.000 2.34705e-06 1.800 2.35600e-06 1.800 2.35605e-06 0.000 2.35700e-06 0.000
+ 2.35705e-06 1.800 2.35800e-06 1.800 2.35805e-06 0.000 2.36400e-06 0.000 2.36405e-06 1.800 2.36500e-06 1.800
+ 2.36505e-06 0.000 2.37000e-06 0.000 2.37005e-06 1.800 2.37200e-06 1.800 2.37205e-06 0.000 2.37700e-06 0.000
+ 2.37705e-06 1.800 2.38300e-06 1.800 2.38305e-06 0.000 2.38500e-06 0.000 2.38505e-06 1.800 2.38700e-06 1.800
+ 2.38705e-06 0.000 2.38900e-06 0.000 2.38905e-06 1.800 2.39000e-06 1.800 2.39005e-06 0.000 2.39100e-06 0.000
+ 2.39105e-06 1.800 2.39200e-06 1.800 2.39205e-06 0.000 2.39300e-06 0.000 2.39305e-06 1.800 2.39400e-06 1.800
+ 2.39405e-06 0.000 2.39600e-06 0.000 2.39605e-06 1.800 2.39700e-06 1.800 2.39705e-06 0.000 2.39800e-06 0.000
+ 2.39805e-06 1.800 2.40400e-06 1.800 2.40405e-06 0.000 2.40500e-06 0.000 2.40505e-06 1.800 2.40600e-06 1.800
+ 2.40605e-06 0.000 2.40700e-06 0.000 2.40705e-06 1.800 2.40800e-06 1.800 2.40805e-06 0.000 2.40900e-06 0.000
+ 2.40905e-06 1.800 2.41000e-06 1.800 2.41005e-06 0.000 2.41200e-06 0.000 2.41205e-06 1.800 2.41600e-06 1.800
+ 2.41605e-06 0.000 2.41900e-06 0.000 2.41905e-06 1.800 2.42200e-06 1.800 2.42205e-06 0.000 2.42300e-06 0.000
+ 2.42305e-06 1.800 2.42400e-06 1.800 2.42405e-06 0.000 2.42900e-06 0.000 2.42905e-06 1.800 2.43200e-06 1.800
+ 2.43205e-06 0.000 2.43400e-06 0.000 2.43405e-06 1.800 2.43500e-06 1.800 2.43505e-06 0.000 2.43600e-06 0.000
+ 2.43605e-06 1.800 2.43800e-06 1.800 2.43805e-06 0.000 2.44100e-06 0.000 2.44105e-06 1.800 2.44400e-06 1.800
+ 2.44405e-06 0.000 2.44600e-06 0.000 2.44605e-06 1.800 2.45000e-06 1.800 2.45005e-06 0.000 2.45100e-06 0.000
+ 2.45105e-06 1.800 2.45200e-06 1.800 2.45205e-06 0.000 2.45400e-06 0.000 2.45405e-06 1.800 2.45900e-06 1.800
+ 2.45905e-06 0.000 2.46000e-06 0.000 2.46005e-06 1.800 2.46200e-06 1.800 2.46205e-06 0.000 2.46600e-06 0.000
+ 2.46605e-06 1.800 2.46800e-06 1.800 2.46805e-06 0.000 2.46900e-06 0.000 2.46905e-06 1.800 2.47000e-06 1.800
+ 2.47005e-06 0.000 2.47100e-06 0.000 2.47105e-06 1.800 2.47200e-06 1.800 2.47205e-06 0.000 2.47300e-06 0.000
+ 2.47305e-06 1.800 2.47400e-06 1.800 2.47405e-06 0.000 2.47800e-06 0.000 2.47805e-06 1.800 2.47900e-06 1.800
+ 2.47905e-06 0.000 2.48200e-06 0.000 2.48205e-06 1.800 2.48300e-06 1.800 2.48305e-06 0.000 2.48500e-06 0.000
+ 2.48505e-06 1.800 2.48600e-06 1.800 2.48605e-06 0.000 2.48900e-06 0.000 2.48905e-06 1.800 2.49100e-06 1.800
+ 2.49105e-06 0.000 2.49300e-06 0.000 2.49305e-06 1.800 2.49500e-06 1.800 2.49505e-06 0.000 2.49600e-06 0.000
+ 2.49605e-06 1.800 2.49700e-06 1.800 2.49705e-06 0.000 2.49800e-06 0.000 2.49805e-06 1.800 2.49900e-06 1.800
+ 2.49905e-06 0.000 2.50100e-06 0.000 2.50105e-06 1.800 2.50300e-06 1.800 2.50305e-06 0.000 2.50400e-06 0.000
+ 2.50405e-06 1.800 2.50500e-06 1.800 2.50505e-06 0.000 2.50700e-06 0.000 2.50705e-06 1.800 2.50800e-06 1.800
+ 2.50805e-06 0.000 2.50900e-06 0.000 2.50905e-06 1.800 2.51000e-06 1.800 2.51005e-06 0.000 2.51100e-06 0.000
+ 2.51105e-06 1.800 2.51300e-06 1.800 2.51305e-06 0.000 2.51500e-06 0.000 2.51505e-06 1.800 2.51900e-06 1.800
+ 2.51905e-06 0.000 2.52200e-06 0.000 2.52205e-06 1.800 2.52500e-06 1.800 2.52505e-06 0.000 2.52600e-06 0.000
+ 2.52605e-06 1.800 2.52700e-06 1.800 2.52705e-06 0.000 2.52800e-06 0.000 2.52805e-06 1.800 2.52900e-06 1.800
+ 2.52905e-06 0.000 2.53100e-06 0.000 2.53105e-06 1.800 2.53300e-06 1.800 2.53305e-06 0.000 2.53700e-06 0.000
+ 2.53705e-06 1.800 2.53800e-06 1.800 2.53805e-06 0.000 2.54100e-06 0.000 2.54105e-06 1.800 2.54500e-06 1.800
+ 2.54505e-06 0.000 2.54600e-06 0.000 2.54605e-06 1.800 2.54700e-06 1.800 2.54705e-06 0.000 2.54800e-06 0.000
+ 2.54805e-06 1.800 2.55000e-06 1.800 2.55005e-06 0.000 2.55500e-06 0.000 2.55505e-06 1.800 2.55600e-06 1.800
+ 2.55605e-06 0.000 2.55800e-06 0.000 2.55805e-06 1.800 2.56000e-06 1.800 2.56005e-06 0.000 2.56200e-06 0.000
+ 2.56205e-06 1.800 2.57100e-06 1.800 2.57105e-06 0.000 2.57600e-06 0.000 2.57605e-06 1.800 2.57700e-06 1.800
+ 2.57705e-06 0.000 2.58100e-06 0.000 2.58105e-06 1.800 2.58200e-06 1.800 2.58205e-06 0.000 2.58600e-06 0.000
+ 2.58605e-06 1.800 2.58800e-06 1.800 2.58805e-06 0.000 2.59100e-06 0.000 2.59105e-06 1.800 2.59300e-06 1.800
+ 2.59305e-06 0.000 2.59500e-06 0.000 2.59505e-06 1.800 2.59800e-06 1.800 2.59805e-06 0.000 2.60100e-06 0.000
+ 2.60105e-06 1.800 2.60200e-06 1.800 2.60205e-06 0.000 2.60400e-06 0.000 2.60405e-06 1.800 2.60500e-06 1.800
+ 2.60505e-06 0.000 2.60900e-06 0.000 2.60905e-06 1.800 2.61000e-06 1.800 2.61005e-06 0.000 2.61200e-06 0.000
+ 2.61205e-06 1.800 2.61300e-06 1.800 2.61305e-06 0.000 2.61600e-06 0.000 2.61605e-06 1.800 2.61800e-06 1.800
+ 2.61805e-06 0.000 2.61900e-06 0.000 2.61905e-06 1.800 2.62000e-06 1.800 2.62005e-06 0.000 2.62100e-06 0.000
+ 2.62105e-06 1.800 2.62200e-06 1.800 2.62205e-06 0.000 2.62300e-06 0.000 2.62305e-06 1.800 2.62500e-06 1.800
+ 2.62505e-06 0.000 2.62700e-06 0.000 2.62705e-06 1.800 2.62900e-06 1.800 2.62905e-06 0.000 2.63000e-06 0.000
+ 2.63005e-06 1.800 2.63300e-06 1.800 2.63305e-06 0.000 2.63400e-06 0.000 2.63405e-06 1.800 2.63500e-06 1.800
+ 2.63505e-06 0.000 2.63600e-06 0.000 2.63605e-06 1.800 2.63700e-06 1.800 2.63705e-06 0.000 2.63800e-06 0.000
+ 2.63805e-06 1.800 2.63900e-06 1.800 2.63905e-06 0.000 2.64700e-06 0.000 2.64705e-06 1.800 2.64800e-06 1.800
+ 2.64805e-06 0.000 2.65200e-06 0.000 2.65205e-06 1.800 2.65400e-06 1.800 2.65405e-06 0.000 2.65500e-06 0.000
+ 2.65505e-06 1.800 2.65700e-06 1.800 2.65705e-06 0.000 2.65800e-06 0.000 2.65805e-06 1.800 2.66300e-06 1.800
+ 2.66305e-06 0.000 2.66400e-06 0.000 2.66405e-06 1.800 2.66900e-06 1.800 2.66905e-06 0.000 2.67000e-06 0.000
+ 2.67005e-06 1.800 2.67200e-06 1.800 2.67205e-06 0.000 2.67400e-06 0.000 2.67405e-06 1.800 2.67600e-06 1.800
+ 2.67605e-06 0.000 2.67700e-06 0.000 2.67705e-06 1.800 2.67900e-06 1.800 2.67905e-06 0.000 2.68000e-06 0.000
+ 2.68005e-06 1.800 2.68100e-06 1.800 2.68105e-06 0.000 2.68600e-06 0.000 2.68605e-06 1.800 2.68700e-06 1.800
+ 2.68705e-06 0.000 2.68800e-06 0.000 2.68805e-06 1.800 2.68900e-06 1.800 2.68905e-06 0.000 2.69100e-06 0.000
+ 2.69105e-06 1.800 2.69200e-06 1.800 2.69205e-06 0.000 2.69300e-06 0.000 2.69305e-06 1.800 2.69400e-06 1.800
+ 2.69405e-06 0.000 2.69500e-06 0.000 2.69505e-06 1.800 2.69600e-06 1.800 2.69605e-06 0.000 2.69700e-06 0.000
+ 2.69705e-06 1.800 2.69800e-06 1.800 2.69805e-06 0.000 2.70000e-06 0.000 2.70005e-06 1.800 2.70200e-06 1.800
+ 2.70205e-06 0.000 2.70300e-06 0.000 2.70305e-06 1.800 2.70400e-06 1.800 2.70405e-06 0.000 2.70500e-06 0.000
+ 2.70505e-06 1.800 2.70600e-06 1.800 2.70605e-06 0.000 2.70700e-06 0.000 2.70705e-06 1.800 2.70800e-06 1.800
+ 2.70805e-06 0.000 2.70900e-06 0.000 2.70905e-06 1.800 2.71100e-06 1.800 2.71105e-06 0.000 2.71500e-06 0.000
+ 2.71505e-06 1.800 2.71600e-06 1.800 2.71605e-06 0.000 2.72000e-06 0.000 2.72005e-06 1.800 2.72300e-06 1.800
+ 2.72305e-06 0.000 2.72400e-06 0.000 2.72405e-06 1.800 2.72500e-06 1.800 2.72505e-06 0.000 2.72800e-06 0.000
+ 2.72805e-06 1.800 2.72900e-06 1.800 2.72905e-06 0.000 2.73000e-06 0.000 2.73005e-06 1.800 2.73100e-06 1.800
+ 2.73105e-06 0.000 2.73200e-06 0.000 2.73205e-06 1.800 2.73400e-06 1.800 2.73405e-06 0.000 2.73500e-06 0.000
+ 2.73505e-06 1.800 2.73700e-06 1.800 2.73705e-06 0.000 2.73800e-06 0.000 2.73805e-06 1.800 2.73900e-06 1.800
+ 2.73905e-06 0.000 2.74200e-06 0.000 2.74205e-06 1.800 2.74300e-06 1.800 2.74305e-06 0.000 2.74400e-06 0.000
+ 2.74405e-06 1.800 2.74500e-06 1.800 2.74505e-06 0.000 2.74700e-06 0.000 2.74705e-06 1.800 2.74800e-06 1.800
+ 2.74805e-06 0.000 2.74900e-06 0.000 2.74905e-06 1.800 2.75000e-06 1.800 2.75005e-06 0.000 2.75100e-06 0.000
+ 2.75105e-06 1.800 2.75400e-06 1.800 2.75405e-06 0.000 2.75700e-06 0.000 2.75705e-06 1.800 2.76000e-06 1.800
+ 2.76005e-06 0.000 2.76100e-06 0.000 2.76105e-06 1.800 2.76500e-06 1.800 2.76505e-06 0.000 2.76700e-06 0.000
+ 2.76705e-06 1.800 2.77100e-06 1.800 2.77105e-06 0.000 2.77200e-06 0.000 2.77205e-06 1.800 2.77300e-06 1.800
+ 2.77305e-06 0.000 2.77400e-06 0.000 2.77405e-06 1.800 2.77800e-06 1.800 2.77805e-06 0.000 2.77900e-06 0.000
+ 2.77905e-06 1.800 2.78000e-06 1.800 2.78005e-06 0.000 2.78100e-06 0.000 2.78105e-06 1.800 2.78200e-06 1.800
+ 2.78205e-06 0.000 2.78500e-06 0.000 2.78505e-06 1.800 2.78600e-06 1.800 2.78605e-06 0.000 2.78800e-06 0.000
+ 2.78805e-06 1.800 2.79000e-06 1.800 2.79005e-06 0.000 2.79200e-06 0.000 2.79205e-06 1.800 2.79400e-06 1.800
+ 2.79405e-06 0.000 2.79600e-06 0.000 2.79605e-06 1.800 2.80000e-06 1.800 2.80005e-06 0.000 2.80100e-06 0.000
+ 2.80105e-06 1.800 2.80200e-06 1.800 2.80205e-06 0.000 2.80300e-06 0.000 2.80305e-06 1.800 2.80500e-06 1.800
+ 2.80505e-06 0.000 2.80600e-06 0.000 2.80605e-06 1.800 2.80700e-06 1.800 2.80705e-06 0.000 2.80900e-06 0.000
+ 2.80905e-06 1.800 2.81000e-06 1.800 2.81005e-06 0.000 2.81200e-06 0.000 2.81205e-06 1.800 2.81700e-06 1.800
+ 2.81705e-06 0.000 2.81900e-06 0.000 2.81905e-06 1.800 2.82200e-06 1.800 2.82205e-06 0.000 2.82300e-06 0.000
+ 2.82305e-06 1.800 2.82500e-06 1.800 2.82505e-06 0.000 2.82600e-06 0.000 2.82605e-06 1.800 2.83200e-06 1.800
+ 2.83205e-06 0.000 2.83700e-06 0.000 2.83705e-06 1.800 2.83800e-06 1.800 2.83805e-06 0.000 2.83900e-06 0.000
+ 2.83905e-06 1.800 2.84300e-06 1.800 2.84305e-06 0.000 2.84400e-06 0.000 2.84405e-06 1.800 2.84600e-06 1.800
+ 2.84605e-06 0.000 2.85000e-06 0.000 2.85005e-06 1.800 2.85200e-06 1.800 2.85205e-06 0.000 2.85400e-06 0.000
+ 2.85405e-06 1.800 2.85500e-06 1.800 2.85505e-06 0.000 2.85800e-06 0.000 2.85805e-06 1.800 2.86000e-06 1.800
+ 2.86005e-06 0.000 2.86200e-06 0.000 2.86205e-06 1.800 2.86400e-06 1.800 2.86405e-06 0.000 2.86500e-06 0.000
+ 2.86505e-06 1.800 2.86600e-06 1.800 2.86605e-06 0.000 2.86900e-06 0.000 2.86905e-06 1.800 2.87100e-06 1.800
+ 2.87105e-06 0.000 2.87200e-06 0.000 2.87205e-06 1.800 2.87500e-06 1.800 2.87505e-06 0.000 2.87600e-06 0.000
+ 2.87605e-06 1.800 2.87800e-06 1.800 2.87805e-06 0.000 2.87900e-06 0.000 2.87905e-06 1.800 2.88200e-06 1.800
+ 2.88205e-06 0.000 2.88300e-06 0.000 2.88305e-06 1.800 2.88600e-06 1.800 2.88605e-06 0.000 2.88700e-06 0.000
+ 2.88705e-06 1.800 2.88800e-06 1.800 2.88805e-06 0.000 2.89000e-06 0.000 2.89005e-06 1.800 2.89100e-06 1.800
+ 2.89105e-06 0.000 2.90000e-06 0.000 2.90005e-06 1.800 2.90200e-06 1.800 2.90205e-06 0.000 2.90500e-06 0.000
+ 2.90505e-06 1.800 2.90600e-06 1.800 2.90605e-06 0.000 2.90900e-06 0.000 2.90905e-06 1.800 2.91100e-06 1.800
+ 2.91105e-06 0.000 2.91200e-06 0.000 2.91205e-06 1.800 2.91300e-06 1.800 2.91305e-06 0.000 2.91400e-06 0.000
+ 2.91405e-06 1.800 2.91600e-06 1.800 2.91605e-06 0.000 2.91700e-06 0.000 2.91705e-06 1.800 2.91800e-06 1.800
+ 2.91805e-06 0.000 2.92100e-06 0.000 2.92105e-06 1.800 2.92300e-06 1.800 2.92305e-06 0.000 2.92500e-06 0.000
+ 2.92505e-06 1.800 2.92900e-06 1.800 2.92905e-06 0.000 2.93000e-06 0.000 2.93005e-06 1.800 2.93100e-06 1.800
+ 2.93105e-06 0.000 2.93400e-06 0.000 2.93405e-06 1.800 2.93800e-06 1.800 2.93805e-06 0.000 2.94200e-06 0.000
+ 2.94205e-06 1.800 2.94300e-06 1.800 2.94305e-06 0.000 2.94400e-06 0.000 2.94405e-06 1.800 2.94600e-06 1.800
+ 2.94605e-06 0.000 2.94700e-06 0.000 2.94705e-06 1.800 2.94800e-06 1.800 2.94805e-06 0.000 2.95100e-06 0.000
+ 2.95105e-06 1.800 2.95200e-06 1.800 2.95205e-06 0.000 2.95300e-06 0.000 2.95305e-06 1.800 2.95400e-06 1.800
+ 2.95405e-06 0.000 2.95500e-06 0.000 2.95505e-06 1.800 2.95600e-06 1.800 2.95605e-06 0.000 2.95700e-06 0.000
+ 2.95705e-06 1.800 2.95800e-06 1.800 2.95805e-06 0.000 2.95900e-06 0.000 2.95905e-06 1.800 2.96000e-06 1.800
+ 2.96005e-06 0.000 2.96100e-06 0.000 2.96105e-06 1.800 2.96200e-06 1.800 2.96205e-06 0.000 2.96400e-06 0.000
+ 2.96405e-06 1.800 2.96500e-06 1.800 2.96505e-06 0.000 2.96600e-06 0.000 2.96605e-06 1.800 2.96700e-06 1.800
+ 2.96705e-06 0.000 2.96900e-06 0.000 2.96905e-06 1.800 2.97000e-06 1.800 2.97005e-06 0.000 2.97100e-06 0.000
+ 2.97105e-06 1.800 2.97500e-06 1.800 2.97505e-06 0.000 2.97600e-06 0.000 2.97605e-06 1.800 2.97700e-06 1.800
+ 2.97705e-06 0.000 2.97900e-06 0.000 2.97905e-06 1.800 2.98200e-06 1.800 2.98205e-06 0.000 2.98600e-06 0.000
+ 2.98605e-06 1.800 2.98900e-06 1.800 2.98905e-06 0.000 2.99100e-06 0.000 2.99105e-06 1.800 2.99400e-06 1.800
+ 2.99405e-06 0.000 2.99500e-06 0.000 2.99505e-06 1.800 2.99600e-06 1.800 2.99605e-06 0.000 2.99700e-06 0.000
+ 2.99705e-06 1.800 3.00200e-06 1.800 3.00205e-06 0.000 3.00400e-06 0.000 3.00405e-06 1.800 3.00500e-06 1.800
+ 3.00505e-06 0.000 3.00600e-06 0.000 3.00605e-06 1.800 3.00700e-06 1.800 3.00705e-06 0.000 3.00800e-06 0.000
+ 3.00805e-06 1.800 3.01100e-06 1.800 3.01105e-06 0.000 3.01400e-06 0.000 3.01405e-06 1.800 3.01500e-06 1.800
+ 3.01505e-06 0.000 3.01600e-06 0.000 3.01605e-06 1.800 3.01700e-06 1.800 3.01705e-06 0.000 3.02900e-06 0.000
+ 3.02905e-06 1.800 3.03000e-06 1.800 3.03005e-06 0.000 3.03200e-06 0.000 3.03205e-06 1.800 3.03600e-06 1.800
+ 3.03605e-06 0.000 3.03800e-06 0.000 3.03805e-06 1.800 3.03900e-06 1.800 3.03905e-06 0.000 3.04000e-06 0.000
+ 3.04005e-06 1.800 3.04100e-06 1.800 3.04105e-06 0.000 3.04200e-06 0.000 3.04205e-06 1.800 3.04400e-06 1.800
+ 3.04405e-06 0.000 3.04600e-06 0.000 3.04605e-06 1.800 3.04800e-06 1.800 3.04805e-06 0.000 3.04900e-06 0.000
+ 3.04905e-06 1.800 3.05300e-06 1.800 3.05305e-06 0.000 3.05400e-06 0.000 3.05405e-06 1.800 3.05600e-06 1.800
+ 3.05605e-06 0.000 3.06000e-06 0.000 3.06005e-06 1.800 3.06300e-06 1.800 3.06305e-06 0.000 3.06400e-06 0.000
+ 3.06405e-06 1.800 3.06800e-06 1.800 3.06805e-06 0.000 3.07000e-06 0.000 3.07005e-06 1.800 3.07100e-06 1.800
+ 3.07105e-06 0.000 3.07200e-06 0.000 3.07205e-06 1.800 3.07300e-06 1.800 3.07305e-06 0.000 3.07500e-06 0.000
+ 3.07505e-06 1.800 3.07600e-06 1.800 3.07605e-06 0.000 3.07700e-06 0.000 3.07705e-06 1.800 3.07800e-06 1.800
+ 3.07805e-06 0.000 3.07900e-06 0.000 3.07905e-06 1.800 3.08000e-06 1.800 3.08005e-06 0.000 3.08200e-06 0.000
+ 3.08205e-06 1.800 3.08300e-06 1.800 3.08305e-06 0.000 3.08500e-06 0.000 3.08505e-06 1.800 3.08700e-06 1.800
+ 3.08705e-06 0.000 3.08900e-06 0.000 3.08905e-06 1.800 3.09000e-06 1.800 3.09005e-06 0.000 3.09300e-06 0.000
+ 3.09305e-06 1.800 3.10000e-06 1.800 3.10005e-06 0.000 3.10200e-06 0.000 3.10205e-06 1.800 3.10300e-06 1.800
+ 3.10305e-06 0.000 3.10400e-06 0.000 3.10405e-06 1.800 3.10500e-06 1.800 3.10505e-06 0.000 3.10900e-06 0.000
+ 3.10905e-06 1.800 3.11000e-06 1.800 3.11005e-06 0.000 3.11300e-06 0.000 3.11305e-06 1.800 3.11400e-06 1.800
+ 3.11405e-06 0.000 3.11500e-06 0.000 3.11505e-06 1.800 3.11600e-06 1.800 3.11605e-06 0.000 3.11700e-06 0.000
+ 3.11705e-06 1.800 3.11900e-06 1.800 3.11905e-06 0.000 3.12200e-06 0.000 3.12205e-06 1.800 3.12300e-06 1.800
+ 3.12305e-06 0.000 3.12400e-06 0.000 3.12405e-06 1.800 3.12500e-06 1.800 3.12505e-06 0.000 3.12600e-06 0.000
+ 3.12605e-06 1.800 3.12700e-06 1.800 3.12705e-06 0.000 3.12800e-06 0.000 3.12805e-06 1.800 3.13600e-06 1.800
+ 3.13605e-06 0.000 3.14100e-06 0.000 3.14105e-06 1.800 3.14300e-06 1.800 3.14305e-06 0.000 3.14600e-06 0.000
+ 3.14605e-06 1.800 3.14700e-06 1.800 3.14705e-06 0.000 3.14800e-06 0.000 3.14805e-06 1.800 3.15000e-06 1.800
+ 3.15005e-06 0.000 3.15200e-06 0.000 3.15205e-06 1.800 3.15700e-06 1.800 3.15705e-06 0.000 3.15800e-06 0.000
+ 3.15805e-06 1.800 3.15900e-06 1.800 3.15905e-06 0.000 3.16200e-06 0.000 3.16205e-06 1.800 3.16300e-06 1.800
+ 3.16305e-06 0.000 3.16400e-06 0.000 3.16405e-06 1.800 3.16600e-06 1.800 3.16605e-06 0.000 3.17100e-06 0.000
+ 3.17105e-06 1.800 3.17800e-06 1.800 3.17805e-06 0.000 3.18400e-06 0.000 3.18405e-06 1.800 3.18800e-06 1.800
+ 3.18805e-06 0.000 3.18900e-06 0.000 3.18905e-06 1.800 3.19500e-06 1.800 3.19505e-06 0.000 3.19600e-06 0.000
+ 3.19605e-06 1.800 3.19700e-06 1.800 3.19705e-06 0.000 3.20100e-06 0.000 3.20105e-06 1.800 3.20200e-06 1.800
+ 3.20205e-06 0.000 3.20400e-06 0.000 3.20405e-06 1.800 3.20500e-06 1.800 3.20505e-06 0.000 3.20700e-06 0.000
+ 3.20705e-06 1.800 3.20800e-06 1.800 3.20805e-06 0.000 3.21000e-06 0.000 3.21005e-06 1.800 3.21100e-06 1.800
+ 3.21105e-06 0.000 3.21200e-06 0.000 3.21205e-06 1.800 3.21400e-06 1.800 3.21405e-06 0.000 3.22500e-06 0.000
+ 3.22505e-06 1.800 3.22700e-06 1.800 3.22705e-06 0.000 3.23100e-06 0.000 3.23105e-06 1.800 3.23200e-06 1.800
+ 3.23205e-06 0.000 3.23400e-06 0.000 3.23405e-06 1.800 3.23500e-06 1.800 3.23505e-06 0.000 3.23700e-06 0.000
+ 3.23705e-06 1.800 3.23900e-06 1.800 3.23905e-06 0.000 3.24000e-06 0.000 3.24005e-06 1.800 3.24400e-06 1.800
+ 3.24405e-06 0.000 3.24500e-06 0.000 3.24505e-06 1.800 3.24600e-06 1.800 3.24605e-06 0.000 3.24800e-06 0.000
+ 3.24805e-06 1.800 3.25000e-06 1.800 3.25005e-06 0.000 3.25300e-06 0.000 3.25305e-06 1.800 3.25400e-06 1.800
+ 3.25405e-06 0.000 3.25700e-06 0.000 3.25705e-06 1.800 3.26300e-06 1.800 3.26305e-06 0.000 3.26600e-06 0.000
+ 3.26605e-06 1.800 3.26800e-06 1.800 3.26805e-06 0.000 3.26900e-06 0.000 3.26905e-06 1.800 3.27000e-06 1.800
+ 3.27005e-06 0.000 3.27200e-06 0.000 3.27205e-06 1.800 3.27300e-06 1.800 3.27305e-06 0.000 3.27600e-06 0.000
+ 3.27605e-06 1.800 3.27700e-06 1.800 3.27705e-06 0.000 3.27800e-06 0.000 3.27805e-06 1.800 3.28000e-06 1.800
+ 3.28005e-06 0.000 3.28200e-06 0.000 3.28205e-06 1.800 3.28300e-06 1.800 3.28305e-06 0.000 3.28700e-06 0.000
+ 3.28705e-06 1.800 3.28800e-06 1.800 3.28805e-06 0.000 3.29200e-06 0.000 3.29205e-06 1.800 3.29400e-06 1.800
+ 3.29405e-06 0.000 3.29500e-06 0.000 3.29505e-06 1.800 3.29600e-06 1.800 3.29605e-06 0.000 3.29700e-06 0.000
+ 3.29705e-06 1.800 3.29800e-06 1.800 3.29805e-06 0.000 3.29900e-06 0.000 3.29905e-06 1.800 3.30000e-06 1.800
+ 3.30005e-06 0.000 3.30100e-06 0.000 3.30105e-06 1.800 3.30300e-06 1.800 3.30305e-06 0.000 3.30500e-06 0.000
+ 3.30505e-06 1.800 3.30600e-06 1.800 3.30605e-06 0.000 3.30700e-06 0.000 3.30705e-06 1.800 3.30800e-06 1.800
+ 3.30805e-06 0.000 3.30900e-06 0.000 3.30905e-06 1.800 3.31000e-06 1.800 3.31005e-06 0.000 3.31100e-06 0.000
+ 3.31105e-06 1.800 3.31300e-06 1.800 3.31305e-06 0.000 3.31500e-06 0.000 3.31505e-06 1.800 3.31600e-06 1.800
+ 3.31605e-06 0.000 3.31700e-06 0.000 3.31705e-06 1.800 3.31900e-06 1.800 3.31905e-06 0.000 3.32000e-06 0.000
+ 3.32005e-06 1.800 3.32300e-06 1.800 3.32305e-06 0.000 3.32400e-06 0.000 3.32405e-06 1.800 3.32600e-06 1.800
+ 3.32605e-06 0.000 3.32800e-06 0.000 3.32805e-06 1.800 3.32900e-06 1.800 3.32905e-06 0.000 3.33000e-06 0.000
+ 3.33005e-06 1.800 3.33100e-06 1.800 3.33105e-06 0.000 3.33200e-06 0.000 3.33205e-06 1.800 3.33400e-06 1.800
+ 3.33405e-06 0.000 3.33600e-06 0.000 3.33605e-06 1.800 3.33700e-06 1.800 3.33705e-06 0.000 3.33800e-06 0.000
+ 3.33805e-06 1.800 3.34100e-06 1.800 3.34105e-06 0.000 3.34200e-06 0.000 3.34205e-06 1.800 3.34300e-06 1.800
+ 3.34305e-06 0.000 3.34700e-06 0.000 3.34705e-06 1.800 3.34800e-06 1.800 3.34805e-06 0.000 3.34900e-06 0.000
+ 3.34905e-06 1.800 3.35000e-06 1.800 3.35005e-06 0.000 3.35200e-06 0.000 3.35205e-06 1.800 3.35300e-06 1.800
+ 3.35305e-06 0.000 3.35500e-06 0.000 3.35505e-06 1.800 3.35600e-06 1.800 3.35605e-06 0.000 3.35900e-06 0.000
+ 3.35905e-06 1.800 3.36300e-06 1.800 3.36305e-06 0.000 3.36400e-06 0.000 3.36405e-06 1.800 3.36500e-06 1.800
+ 3.36505e-06 0.000 3.36900e-06 0.000 3.36905e-06 1.800 3.37200e-06 1.800 3.37205e-06 0.000 3.37400e-06 0.000
+ 3.37405e-06 1.800 3.37500e-06 1.800 3.37505e-06 0.000 3.37900e-06 0.000 3.37905e-06 1.800 3.38100e-06 1.800
+ 3.38105e-06 0.000 3.38300e-06 0.000 3.38305e-06 1.800 3.38400e-06 1.800 3.38405e-06 0.000 3.38500e-06 0.000
+ 3.38505e-06 1.800 3.38700e-06 1.800 3.38705e-06 0.000 3.38800e-06 0.000 3.38805e-06 1.800 3.38900e-06 1.800
+ 3.38905e-06 0.000 3.39100e-06 0.000 3.39105e-06 1.800 3.39300e-06 1.800 3.39305e-06 0.000 3.39600e-06 0.000
+ 3.39605e-06 1.800 3.39700e-06 1.800 3.39705e-06 0.000 3.39800e-06 0.000 3.39805e-06 1.800 3.40300e-06 1.800
+ 3.40305e-06 0.000 3.40600e-06 0.000 3.40605e-06 1.800 3.40700e-06 1.800 3.40705e-06 0.000 3.40800e-06 0.000
+ 3.40805e-06 1.800 3.41000e-06 1.800 3.41005e-06 0.000 3.41200e-06 0.000 3.41205e-06 1.800 3.41600e-06 1.800
+ 3.41605e-06 0.000 3.41800e-06 0.000 3.41805e-06 1.800 3.41900e-06 1.800 3.41905e-06 0.000 3.42000e-06 0.000
+ 3.42005e-06 1.800 3.42100e-06 1.800 3.42105e-06 0.000 3.42400e-06 0.000 3.42405e-06 1.800 3.42600e-06 1.800
+ 3.42605e-06 0.000 3.42800e-06 0.000 3.42805e-06 1.800 3.42900e-06 1.800 3.42905e-06 0.000 3.43100e-06 0.000
+ 3.43105e-06 1.800 3.43300e-06 1.800 3.43305e-06 0.000 3.43400e-06 0.000 3.43405e-06 1.800 3.43600e-06 1.800
+ 3.43605e-06 0.000 3.44100e-06 0.000 3.44105e-06 1.800 3.44400e-06 1.800 3.44405e-06 0.000 3.44500e-06 0.000
+ 3.44505e-06 1.800 3.44600e-06 1.800 3.44605e-06 0.000 3.44700e-06 0.000 3.44705e-06 1.800 3.45100e-06 1.800
+ 3.45105e-06 0.000 3.45200e-06 0.000 3.45205e-06 1.800 3.45300e-06 1.800 3.45305e-06 0.000 3.45500e-06 0.000
+ 3.45505e-06 1.800 3.45600e-06 1.800 3.45605e-06 0.000 3.45700e-06 0.000 3.45705e-06 1.800 3.45800e-06 1.800
+ 3.45805e-06 0.000 3.46200e-06 0.000 3.46205e-06 1.800 3.46300e-06 1.800 3.46305e-06 0.000 3.46500e-06 0.000
+ 3.46505e-06 1.800 3.46800e-06 1.800 3.46805e-06 0.000 3.46900e-06 0.000 3.46905e-06 1.800 3.47300e-06 1.800
+ 3.47305e-06 0.000 3.47500e-06 0.000 3.47505e-06 1.800 3.47700e-06 1.800 3.47705e-06 0.000 3.48000e-06 0.000
+ 3.48005e-06 1.800 3.48100e-06 1.800 3.48105e-06 0.000 3.48400e-06 0.000 3.48405e-06 1.800 3.48500e-06 1.800
+ 3.48505e-06 0.000 3.48600e-06 0.000 3.48605e-06 1.800 3.49000e-06 1.800 3.49005e-06 0.000 3.49200e-06 0.000
+ 3.49205e-06 1.800 3.49300e-06 1.800 3.49305e-06 0.000 3.49400e-06 0.000 3.49405e-06 1.800 3.49600e-06 1.800
+ 3.49605e-06 0.000 3.49700e-06 0.000 3.49705e-06 1.800 3.49800e-06 1.800 3.49805e-06 0.000 3.49900e-06 0.000
+ 3.49905e-06 1.800 3.50200e-06 1.800 3.50205e-06 0.000 3.50400e-06 0.000 3.50405e-06 1.800 3.50700e-06 1.800
+ 3.50705e-06 0.000 3.50900e-06 0.000 3.50905e-06 1.800 3.51200e-06 1.800 3.51205e-06 0.000 3.51400e-06 0.000
+ 3.51405e-06 1.800 3.51800e-06 1.800 3.51805e-06 0.000 3.51900e-06 0.000 3.51905e-06 1.800 3.52000e-06 1.800
+ 3.52005e-06 0.000 3.52100e-06 0.000 3.52105e-06 1.800 3.52200e-06 1.800 3.52205e-06 0.000 3.52500e-06 0.000
+ 3.52505e-06 1.800 3.52700e-06 1.800 3.52705e-06 0.000 3.52800e-06 0.000 3.52805e-06 1.800 3.53100e-06 1.800
+ 3.53105e-06 0.000 3.53300e-06 0.000 3.53305e-06 1.800 3.53400e-06 1.800 3.53405e-06 0.000 3.53500e-06 0.000
+ 3.53505e-06 1.800 3.53800e-06 1.800 3.53805e-06 0.000 3.54000e-06 0.000 3.54005e-06 1.800 3.54400e-06 1.800
+ 3.54405e-06 0.000 3.54500e-06 0.000 3.54505e-06 1.800 3.54600e-06 1.800 3.54605e-06 0.000 3.54900e-06 0.000
+ 3.54905e-06 1.800 3.55000e-06 1.800 3.55005e-06 0.000 3.55200e-06 0.000 3.55205e-06 1.800 3.55300e-06 1.800
+ 3.55305e-06 0.000 3.55500e-06 0.000 3.55505e-06 1.800 3.55700e-06 1.800 3.55705e-06 0.000 3.56100e-06 0.000
+ 3.56105e-06 1.800 3.56200e-06 1.800 3.56205e-06 0.000 3.56300e-06 0.000 3.56305e-06 1.800 3.56500e-06 1.800
+ 3.56505e-06 0.000 3.56600e-06 0.000 3.56605e-06 1.800 3.56900e-06 1.800 3.56905e-06 0.000 3.57000e-06 0.000
+ 3.57005e-06 1.800 3.57200e-06 1.800 3.57205e-06 0.000 3.57300e-06 0.000 3.57305e-06 1.800 3.57400e-06 1.800
+ 3.57405e-06 0.000 3.57500e-06 0.000 3.57505e-06 1.800 3.57600e-06 1.800 3.57605e-06 0.000 3.57900e-06 0.000
+ 3.57905e-06 1.800 3.58000e-06 1.800 3.58005e-06 0.000 3.58100e-06 0.000 3.58105e-06 1.800 3.58300e-06 1.800
+ 3.58305e-06 0.000 3.58400e-06 0.000 3.58405e-06 1.800 3.58900e-06 1.800 3.58905e-06 0.000 3.59200e-06 0.000
+ 3.59205e-06 1.800 3.59300e-06 1.800 3.59305e-06 0.000 3.59500e-06 0.000 3.59505e-06 1.800 3.59900e-06 1.800
+ 3.59905e-06 0.000 3.60000e-06 0.000 3.60005e-06 1.800 3.60100e-06 1.800 3.60105e-06 0.000 3.60200e-06 0.000
+ 3.60205e-06 1.800 3.60600e-06 1.800 3.60605e-06 0.000 3.60700e-06 0.000 3.60705e-06 1.800 3.60800e-06 1.800
+ 3.60805e-06 0.000 3.60900e-06 0.000 3.60905e-06 1.800 3.61100e-06 1.800 3.61105e-06 0.000 3.61300e-06 0.000
+ 3.61305e-06 1.800 3.61600e-06 1.800 3.61605e-06 0.000 3.61700e-06 0.000 3.61705e-06 1.800 3.61800e-06 1.800
+ 3.61805e-06 0.000 3.61900e-06 0.000 3.61905e-06 1.800 3.62200e-06 1.800 3.62205e-06 0.000 3.62300e-06 0.000
+ 3.62305e-06 1.800 3.62400e-06 1.800 3.62405e-06 0.000 3.62500e-06 0.000 3.62505e-06 1.800 3.62600e-06 1.800
+ 3.62605e-06 0.000 3.62800e-06 0.000 3.62805e-06 1.800 3.63000e-06 1.800 3.63005e-06 0.000 3.63100e-06 0.000
+ 3.63105e-06 1.800 3.63200e-06 1.800 3.63205e-06 0.000 3.63500e-06 0.000 3.63505e-06 1.800 3.63700e-06 1.800
+ 3.63705e-06 0.000 3.64000e-06 0.000 3.64005e-06 1.800 3.64200e-06 1.800 3.64205e-06 0.000 3.64400e-06 0.000
+ 3.64405e-06 1.800 3.64700e-06 1.800 3.64705e-06 0.000 3.64900e-06 0.000 3.64905e-06 1.800 3.65300e-06 1.800
+ 3.65305e-06 0.000 3.65600e-06 0.000 3.65605e-06 1.800 3.65800e-06 1.800 3.65805e-06 0.000 3.65900e-06 0.000
+ 3.65905e-06 1.800 3.66000e-06 1.800 3.66005e-06 0.000 3.66200e-06 0.000 3.66205e-06 1.800 3.66400e-06 1.800
+ 3.66405e-06 0.000 3.66700e-06 0.000 3.66705e-06 1.800 3.66800e-06 1.800 3.66805e-06 0.000 3.66900e-06 0.000
+ 3.66905e-06 1.800 3.67600e-06 1.800 3.67605e-06 0.000 3.67900e-06 0.000 3.67905e-06 1.800 3.68000e-06 1.800
+ 3.68005e-06 0.000 3.68300e-06 0.000 3.68305e-06 1.800 3.68400e-06 1.800 3.68405e-06 0.000 3.68500e-06 0.000
+ 3.68505e-06 1.800 3.68600e-06 1.800 3.68605e-06 0.000 3.69000e-06 0.000 3.69005e-06 1.800 3.69300e-06 1.800
+ 3.69305e-06 0.000 3.69400e-06 0.000 3.69405e-06 1.800 3.69500e-06 1.800 3.69505e-06 0.000 3.69600e-06 0.000
+ 3.69605e-06 1.800 3.69700e-06 1.800 3.69705e-06 0.000 3.69800e-06 0.000 3.69805e-06 1.800 3.70100e-06 1.800
+ 3.70105e-06 0.000 3.70200e-06 0.000 3.70205e-06 1.800 3.70500e-06 1.800 3.70505e-06 0.000 3.70600e-06 0.000
+ 3.70605e-06 1.800 3.70700e-06 1.800 3.70705e-06 0.000 3.70900e-06 0.000 3.70905e-06 1.800 3.71000e-06 1.800
+ 3.71005e-06 0.000 3.71300e-06 0.000 3.71305e-06 1.800 3.71600e-06 1.800 3.71605e-06 0.000 3.72000e-06 0.000
+ 3.72005e-06 1.800 3.72300e-06 1.800 3.72305e-06 0.000 3.72400e-06 0.000 3.72405e-06 1.800 3.72700e-06 1.800
+ 3.72705e-06 0.000 3.72800e-06 0.000 3.72805e-06 1.800 3.72900e-06 1.800 3.72905e-06 0.000 3.73100e-06 0.000
+ 3.73105e-06 1.800 3.73200e-06 1.800 3.73205e-06 0.000 3.73400e-06 0.000 3.73405e-06 1.800 3.73600e-06 1.800
+ 3.73605e-06 0.000 3.73700e-06 0.000 3.73705e-06 1.800 3.73900e-06 1.800 3.73905e-06 0.000 3.74000e-06 0.000
+ 3.74005e-06 1.800 3.74100e-06 1.800 3.74105e-06 0.000 3.74400e-06 0.000 3.74405e-06 1.800 3.74500e-06 1.800
+ 3.74505e-06 0.000 3.74600e-06 0.000 3.74605e-06 1.800 3.75200e-06 1.800 3.75205e-06 0.000 3.75500e-06 0.000
+ 3.75505e-06 1.800 3.75700e-06 1.800 3.75705e-06 0.000 3.76000e-06 0.000 3.76005e-06 1.800 3.76100e-06 1.800
+ 3.76105e-06 0.000 3.76200e-06 0.000 3.76205e-06 1.800 3.76300e-06 1.800 3.76305e-06 0.000 3.76400e-06 0.000
+ 3.76405e-06 1.800 3.76800e-06 1.800 3.76805e-06 0.000 3.76900e-06 0.000 3.76905e-06 1.800 3.77100e-06 1.800
+ 3.77105e-06 0.000 3.77300e-06 0.000 3.77305e-06 1.800 3.77500e-06 1.800 3.77505e-06 0.000 3.77800e-06 0.000
+ 3.77805e-06 1.800 3.77900e-06 1.800 3.77905e-06 0.000 3.78200e-06 0.000 3.78205e-06 1.800 3.78600e-06 1.800
+ 3.78605e-06 0.000 3.78700e-06 0.000 3.78705e-06 1.800 3.78800e-06 1.800 3.78805e-06 0.000 3.79000e-06 0.000
+ 3.79005e-06 1.800 3.79100e-06 1.800 3.79105e-06 0.000 3.79300e-06 0.000 3.79305e-06 1.800 3.79500e-06 1.800
+ 3.79505e-06 0.000 3.79600e-06 0.000 3.79605e-06 1.800 3.80000e-06 1.800 3.80005e-06 0.000 3.80100e-06 0.000
+ 3.80105e-06 1.800 3.80200e-06 1.800 3.80205e-06 0.000 3.80400e-06 0.000 3.80405e-06 1.800 3.80500e-06 1.800
+ 3.80505e-06 0.000 3.80700e-06 0.000 3.80705e-06 1.800 3.81000e-06 1.800 3.81005e-06 0.000 3.81300e-06 0.000
+ 3.81305e-06 1.800 3.81400e-06 1.800 3.81405e-06 0.000 3.81500e-06 0.000 3.81505e-06 1.800 3.81600e-06 1.800
+ 3.81605e-06 0.000 3.81700e-06 0.000 3.81705e-06 1.800 3.81800e-06 1.800 3.81805e-06 0.000 3.81900e-06 0.000
+ 3.81905e-06 1.800 3.82700e-06 1.800 3.82705e-06 0.000 3.82800e-06 0.000 3.82805e-06 1.800 3.82900e-06 1.800
+ 3.82905e-06 0.000 3.83200e-06 0.000 3.83205e-06 1.800 3.83300e-06 1.800 3.83305e-06 0.000 3.83400e-06 0.000
+ 3.83405e-06 1.800 3.83600e-06 1.800 3.83605e-06 0.000 3.83700e-06 0.000 3.83705e-06 1.800 3.83800e-06 1.800
+ 3.83805e-06 0.000 3.84100e-06 0.000 3.84105e-06 1.800 3.85000e-06 1.800 3.85005e-06 0.000 3.85200e-06 0.000
+ 3.85205e-06 1.800 3.85300e-06 1.800 3.85305e-06 0.000 3.85700e-06 0.000 3.85705e-06 1.800 3.86100e-06 1.800
+ 3.86105e-06 0.000 3.86400e-06 0.000 3.86405e-06 1.800 3.86500e-06 1.800 3.86505e-06 0.000 3.86700e-06 0.000
+ 3.86705e-06 1.800 3.86800e-06 1.800 3.86805e-06 0.000 3.86900e-06 0.000 3.86905e-06 1.800 3.87100e-06 1.800
+ 3.87105e-06 0.000 3.88000e-06 0.000 3.88005e-06 1.800 3.88200e-06 1.800 3.88205e-06 0.000 3.88400e-06 0.000
+ 3.88405e-06 1.800 3.88500e-06 1.800 3.88505e-06 0.000 3.88800e-06 0.000 3.88805e-06 1.800 3.88900e-06 1.800
+ 3.88905e-06 0.000 3.89000e-06 0.000 3.89005e-06 1.800 3.89700e-06 1.800 3.89705e-06 0.000 3.89800e-06 0.000
+ 3.89805e-06 1.800 3.90100e-06 1.800 3.90105e-06 0.000 3.90200e-06 0.000 3.90205e-06 1.800 3.90300e-06 1.800
+ 3.90305e-06 0.000 3.90500e-06 0.000 3.90505e-06 1.800 3.90600e-06 1.800 3.90605e-06 0.000 3.91200e-06 0.000
+ 3.91205e-06 1.800 3.91300e-06 1.800 3.91305e-06 0.000 3.91400e-06 0.000 3.91405e-06 1.800 3.91500e-06 1.800
+ 3.91505e-06 0.000 3.91600e-06 0.000 3.91605e-06 1.800 3.92400e-06 1.800 3.92405e-06 0.000 3.92500e-06 0.000
+ 3.92505e-06 1.800 3.92600e-06 1.800 3.92605e-06 0.000 3.92700e-06 0.000 3.92705e-06 1.800 3.92800e-06 1.800
+ 3.92805e-06 0.000 3.92900e-06 0.000 3.92905e-06 1.800 3.93100e-06 1.800 3.93105e-06 0.000 3.93200e-06 0.000
+ 3.93205e-06 1.800 3.93400e-06 1.800 3.93405e-06 0.000 3.93500e-06 0.000 3.93505e-06 1.800 3.93600e-06 1.800
+ 3.93605e-06 0.000 3.93800e-06 0.000 3.93805e-06 1.800 3.94100e-06 1.800 3.94105e-06 0.000 3.94200e-06 0.000
+ 3.94205e-06 1.800 3.94700e-06 1.800 3.94705e-06 0.000 3.95200e-06 0.000 3.95205e-06 1.800 3.95300e-06 1.800
+ 3.95305e-06 0.000 3.95500e-06 0.000 3.95505e-06 1.800 3.95700e-06 1.800 3.95705e-06 0.000 3.95800e-06 0.000
+ 3.95805e-06 1.800 3.95900e-06 1.800 3.95905e-06 0.000 3.96100e-06 0.000 3.96105e-06 1.800 3.96200e-06 1.800
+ 3.96205e-06 0.000 3.96400e-06 0.000 3.96405e-06 1.800 3.96500e-06 1.800 3.96505e-06 0.000 3.96600e-06 0.000
+ 3.96605e-06 1.800 3.97000e-06 1.800 3.97005e-06 0.000 3.97500e-06 0.000 3.97505e-06 1.800 3.97700e-06 1.800
+ 3.97705e-06 0.000 3.98000e-06 0.000 3.98005e-06 1.800 3.98200e-06 1.800 3.98205e-06 0.000 3.98600e-06 0.000
+ 3.98605e-06 1.800 3.98900e-06 1.800 3.98905e-06 0.000 3.99100e-06 0.000 3.99105e-06 1.800 3.99400e-06 1.800
+ 3.99405e-06 0.000 3.99500e-06 0.000 3.99505e-06 1.800 3.99600e-06 1.800 3.99605e-06 0.000 3.99700e-06 0.000
+ 3.99705e-06 1.800 3.99800e-06 1.800 3.99805e-06 0.000 3.99900e-06 0.000 3.99905e-06 1.800 4.00200e-06 1.800
+ 4.00205e-06 0.000 4.00300e-06 0.000 4.00305e-06 1.800 4.00500e-06 1.800 4.00505e-06 0.000 4.00600e-06 0.000
+ 4.00605e-06 1.800 4.00700e-06 1.800 4.00705e-06 0.000 4.01300e-06 0.000 4.01305e-06 1.800 4.01400e-06 1.800
+ 4.01405e-06 0.000 4.01500e-06 0.000 4.01505e-06 1.800 4.01700e-06 1.800 4.01705e-06 0.000 4.01800e-06 0.000
+ 4.01805e-06 1.800 4.01900e-06 1.800 4.01905e-06 0.000 4.02200e-06 0.000 4.02205e-06 1.800 4.02300e-06 1.800
+ 4.02305e-06 0.000 4.02400e-06 0.000 4.02405e-06 1.800 4.02500e-06 1.800 4.02505e-06 0.000 4.02700e-06 0.000
+ 4.02705e-06 1.800 4.02900e-06 1.800 4.02905e-06 0.000 4.03100e-06 0.000 4.03105e-06 1.800 4.03200e-06 1.800
+ 4.03205e-06 0.000 4.03300e-06 0.000 4.03305e-06 1.800 4.03600e-06 1.800 4.03605e-06 0.000 4.03800e-06 0.000
+ 4.03805e-06 1.800 4.04000e-06 1.800 4.04005e-06 0.000 4.04100e-06 0.000 4.04105e-06 1.800 4.04200e-06 1.800
+ 4.04205e-06 0.000 4.04400e-06 0.000 4.04405e-06 1.800 4.04500e-06 1.800 4.04505e-06 0.000 4.04600e-06 0.000
+ 4.04605e-06 1.800 4.04700e-06 1.800 4.04705e-06 0.000 4.04900e-06 0.000 4.04905e-06 1.800 4.05400e-06 1.800
+ 4.05405e-06 0.000 4.05800e-06 0.000 4.05805e-06 1.800 4.05900e-06 1.800 4.05905e-06 0.000 4.06000e-06 0.000
+ 4.06005e-06 1.800 4.06200e-06 1.800 4.06205e-06 0.000 4.06300e-06 0.000 4.06305e-06 1.800 4.06400e-06 1.800
+ 4.06405e-06 0.000 4.06500e-06 0.000 4.06505e-06 1.800 4.06600e-06 1.800 4.06605e-06 0.000 4.06700e-06 0.000
+ 4.06705e-06 1.800 4.07000e-06 1.800 4.07005e-06 0.000 4.07100e-06 0.000 4.07105e-06 1.800 4.07300e-06 1.800
+ 4.07305e-06 0.000 4.07400e-06 0.000 4.07405e-06 1.800 4.07500e-06 1.800 4.07505e-06 0.000 4.07900e-06 0.000
+ 4.07905e-06 1.800 4.08000e-06 1.800 4.08005e-06 0.000 4.08100e-06 0.000 4.08105e-06 1.800 4.08300e-06 1.800
+ 4.08305e-06 0.000 4.08400e-06 0.000 4.08405e-06 1.800 4.08700e-06 1.800 4.08705e-06 0.000 4.08900e-06 0.000
+ 4.08905e-06 1.800 4.09200e-06 1.800 4.09205e-06 0.000 4.09300e-06 0.000 4.09305e-06 1.800 4.09500e-06 1.800
+ 4.09505e-06 0.000 4.09600e-06 0.000
+ )
Xd_t2b src_t2b t2b vdd gnd tb_inv
Vc0 src_c0 gnd PWL(
+ 0.00000e+00 1.800 1.60000e-08 1.800 1.60500e-08 0.000 3.20000e-08 0.000 3.20500e-08 1.800 4.80000e-08 1.800
+ 4.80500e-08 0.000 6.40000e-08 0.000 6.40500e-08 1.800 8.00000e-08 1.800 8.00500e-08 0.000 9.60000e-08 0.000
+ 9.60500e-08 1.800 1.12000e-07 1.800 1.12050e-07 0.000 1.28000e-07 0.000 1.28050e-07 1.800 1.44000e-07 1.800
+ 1.44050e-07 0.000 1.60000e-07 0.000 1.60050e-07 1.800 1.76000e-07 1.800 1.76050e-07 0.000 1.92000e-07 0.000
+ 1.92050e-07 1.800 2.08000e-07 1.800 2.08050e-07 0.000 2.24000e-07 0.000 2.24050e-07 1.800 2.40000e-07 1.800
+ 2.40050e-07 0.000 2.56000e-07 0.000 2.56050e-07 1.800 2.72000e-07 1.800 2.72050e-07 0.000 2.88000e-07 0.000
+ 2.88050e-07 1.800 3.04000e-07 1.800 3.04050e-07 0.000 3.20000e-07 0.000 3.20050e-07 1.800 3.36000e-07 1.800
+ 3.36050e-07 0.000 3.52000e-07 0.000 3.52050e-07 1.800 3.68000e-07 1.800 3.68050e-07 0.000 3.84000e-07 0.000
+ 3.84050e-07 1.800 4.00000e-07 1.800 4.00050e-07 0.000 4.16000e-07 0.000 4.16050e-07 1.800 4.32000e-07 1.800
+ 4.32050e-07 0.000 4.48000e-07 0.000 4.48050e-07 1.800 4.64000e-07 1.800 4.64050e-07 0.000 4.80000e-07 0.000
+ 4.80050e-07 1.800 4.96000e-07 1.800 4.96050e-07 0.000 5.12000e-07 0.000 5.12050e-07 1.800 5.28000e-07 1.800
+ 5.28050e-07 0.000 5.44000e-07 0.000 5.44050e-07 1.800 5.60000e-07 1.800 5.60050e-07 0.000 5.76000e-07 0.000
+ 5.76050e-07 1.800 5.92000e-07 1.800 5.92050e-07 0.000 6.08000e-07 0.000 6.08050e-07 1.800 6.24000e-07 1.800
+ 6.24050e-07 0.000 6.40000e-07 0.000 6.40050e-07 1.800 6.56000e-07 1.800 6.56050e-07 0.000 6.72000e-07 0.000
+ 6.72050e-07 1.800 6.88000e-07 1.800 6.88050e-07 0.000 7.04000e-07 0.000 7.04050e-07 1.800 7.20000e-07 1.800
+ 7.20050e-07 0.000 7.36000e-07 0.000 7.36050e-07 1.800 7.52000e-07 1.800 7.52050e-07 0.000 7.68000e-07 0.000
+ 7.68050e-07 1.800 7.84000e-07 1.800 7.84050e-07 0.000 8.00000e-07 0.000 8.00050e-07 1.800 8.16000e-07 1.800
+ 8.16050e-07 0.000 8.32000e-07 0.000 8.32050e-07 1.800 8.48000e-07 1.800 8.48050e-07 0.000 8.64000e-07 0.000
+ 8.64050e-07 1.800 8.80000e-07 1.800 8.80050e-07 0.000 8.96000e-07 0.000 8.96050e-07 1.800 9.12000e-07 1.800
+ 9.12050e-07 0.000 9.28000e-07 0.000 9.28050e-07 1.800 9.44000e-07 1.800 9.44050e-07 0.000 9.60000e-07 0.000
+ 9.60050e-07 1.800 9.76000e-07 1.800 9.76050e-07 0.000 9.92000e-07 0.000 9.92050e-07 1.800 1.00800e-06 1.800
+ 1.00805e-06 0.000 1.02400e-06 0.000 1.02405e-06 1.800 1.04000e-06 1.800 1.04005e-06 0.000 1.05600e-06 0.000
+ 1.05605e-06 1.800 1.07200e-06 1.800 1.07205e-06 0.000 1.08800e-06 0.000 1.08805e-06 1.800 1.10400e-06 1.800
+ 1.10405e-06 0.000 1.12000e-06 0.000 1.12005e-06 1.800 1.13600e-06 1.800 1.13605e-06 0.000 1.15200e-06 0.000
+ 1.15205e-06 1.800 1.16800e-06 1.800 1.16805e-06 0.000 1.18400e-06 0.000 1.18405e-06 1.800 1.20000e-06 1.800
+ 1.20005e-06 0.000 1.21600e-06 0.000 1.21605e-06 1.800 1.23200e-06 1.800 1.23205e-06 0.000 1.24800e-06 0.000
+ 1.24805e-06 1.800 1.26400e-06 1.800 1.26405e-06 0.000 1.28000e-06 0.000 1.28005e-06 1.800 1.29600e-06 1.800
+ 1.29605e-06 0.000 1.31200e-06 0.000 1.31205e-06 1.800 1.32800e-06 1.800 1.32805e-06 0.000 1.34400e-06 0.000
+ 1.34405e-06 1.800 1.36000e-06 1.800 1.36005e-06 0.000 1.37600e-06 0.000 1.37605e-06 1.800 1.39200e-06 1.800
+ 1.39205e-06 0.000 1.40800e-06 0.000 1.40805e-06 1.800 1.42400e-06 1.800 1.42405e-06 0.000 1.44000e-06 0.000
+ 1.44005e-06 1.800 1.45600e-06 1.800 1.45605e-06 0.000 1.47200e-06 0.000 1.47205e-06 1.800 1.48800e-06 1.800
+ 1.48805e-06 0.000 1.50400e-06 0.000 1.50405e-06 1.800 1.52000e-06 1.800 1.52005e-06 0.000 1.53600e-06 0.000
+ 1.53605e-06 1.800 1.55200e-06 1.800 1.55205e-06 0.000 1.56800e-06 0.000 1.56805e-06 1.800 1.58400e-06 1.800
+ 1.58405e-06 0.000 1.60000e-06 0.000 1.60005e-06 1.800 1.61600e-06 1.800 1.61605e-06 0.000 1.63200e-06 0.000
+ 1.63205e-06 1.800 1.64800e-06 1.800 1.64805e-06 0.000 1.66400e-06 0.000 1.66405e-06 1.800 1.68000e-06 1.800
+ 1.68005e-06 0.000 1.69600e-06 0.000 1.69605e-06 1.800 1.71200e-06 1.800 1.71205e-06 0.000 1.72800e-06 0.000
+ 1.72805e-06 1.800 1.74400e-06 1.800 1.74405e-06 0.000 1.76000e-06 0.000 1.76005e-06 1.800 1.77600e-06 1.800
+ 1.77605e-06 0.000 1.79200e-06 0.000 1.79205e-06 1.800 1.80800e-06 1.800 1.80805e-06 0.000 1.82400e-06 0.000
+ 1.82405e-06 1.800 1.84000e-06 1.800 1.84005e-06 0.000 1.85600e-06 0.000 1.85605e-06 1.800 1.87200e-06 1.800
+ 1.87205e-06 0.000 1.88800e-06 0.000 1.88805e-06 1.800 1.90400e-06 1.800 1.90405e-06 0.000 1.92000e-06 0.000
+ 1.92005e-06 1.800 1.93600e-06 1.800 1.93605e-06 0.000 1.95200e-06 0.000 1.95205e-06 1.800 1.96800e-06 1.800
+ 1.96805e-06 0.000 1.98400e-06 0.000 1.98405e-06 1.800 2.00000e-06 1.800 2.00005e-06 0.000 2.01600e-06 0.000
+ 2.01605e-06 1.800 2.03200e-06 1.800 2.03205e-06 0.000 2.04900e-06 0.000 2.04905e-06 1.800 2.05300e-06 1.800
+ 2.05305e-06 0.000 2.05400e-06 0.000 2.05405e-06 1.800 2.05500e-06 1.800 2.05505e-06 0.000 2.05700e-06 0.000
+ 2.05705e-06 1.800 2.06300e-06 1.800 2.06305e-06 0.000 2.06600e-06 0.000 2.06605e-06 1.800 2.06900e-06 1.800
+ 2.06905e-06 0.000 2.07100e-06 0.000 2.07105e-06 1.800 2.07200e-06 1.800 2.07205e-06 0.000 2.07400e-06 0.000
+ 2.07405e-06 1.800 2.07600e-06 1.800 2.07605e-06 0.000 2.07700e-06 0.000 2.07705e-06 1.800 2.08000e-06 1.800
+ 2.08005e-06 0.000 2.08200e-06 0.000 2.08205e-06 1.800 2.08300e-06 1.800 2.08305e-06 0.000 2.08400e-06 0.000
+ 2.08405e-06 1.800 2.08500e-06 1.800 2.08505e-06 0.000 2.08700e-06 0.000 2.08705e-06 1.800 2.09100e-06 1.800
+ 2.09105e-06 0.000 2.09200e-06 0.000 2.09205e-06 1.800 2.09400e-06 1.800 2.09405e-06 0.000 2.09600e-06 0.000
+ 2.09605e-06 1.800 2.09800e-06 1.800 2.09805e-06 0.000 2.10000e-06 0.000 2.10005e-06 1.800 2.10200e-06 1.800
+ 2.10205e-06 0.000 2.10600e-06 0.000 2.10605e-06 1.800 2.10700e-06 1.800 2.10705e-06 0.000 2.11000e-06 0.000
+ 2.11005e-06 1.800 2.11100e-06 1.800 2.11105e-06 0.000 2.11300e-06 0.000 2.11305e-06 1.800 2.11400e-06 1.800
+ 2.11405e-06 0.000 2.11600e-06 0.000 2.11605e-06 1.800 2.11700e-06 1.800 2.11705e-06 0.000 2.11900e-06 0.000
+ 2.11905e-06 1.800 2.12000e-06 1.800 2.12005e-06 0.000 2.12200e-06 0.000 2.12205e-06 1.800 2.12300e-06 1.800
+ 2.12305e-06 0.000 2.12500e-06 0.000 2.12505e-06 1.800 2.12600e-06 1.800 2.12605e-06 0.000 2.13000e-06 0.000
+ 2.13005e-06 1.800 2.13200e-06 1.800 2.13205e-06 0.000 2.13400e-06 0.000 2.13405e-06 1.800 2.13600e-06 1.800
+ 2.13605e-06 0.000 2.13800e-06 0.000 2.13805e-06 1.800 2.14000e-06 1.800 2.14005e-06 0.000 2.14300e-06 0.000
+ 2.14305e-06 1.800 2.14700e-06 1.800 2.14705e-06 0.000 2.14800e-06 0.000 2.14805e-06 1.800 2.15100e-06 1.800
+ 2.15105e-06 0.000 2.15200e-06 0.000 2.15205e-06 1.800 2.15400e-06 1.800 2.15405e-06 0.000 2.15500e-06 0.000
+ 2.15505e-06 1.800 2.15700e-06 1.800 2.15705e-06 0.000 2.15900e-06 0.000 2.15905e-06 1.800 2.16000e-06 1.800
+ 2.16005e-06 0.000 2.16200e-06 0.000 2.16205e-06 1.800 2.16800e-06 1.800 2.16805e-06 0.000 2.16900e-06 0.000
+ 2.16905e-06 1.800 2.17000e-06 1.800 2.17005e-06 0.000 2.17100e-06 0.000 2.17105e-06 1.800 2.17400e-06 1.800
+ 2.17405e-06 0.000 2.17500e-06 0.000 2.17505e-06 1.800 2.17800e-06 1.800 2.17805e-06 0.000 2.17900e-06 0.000
+ 2.17905e-06 1.800 2.18100e-06 1.800 2.18105e-06 0.000 2.18300e-06 0.000 2.18305e-06 1.800 2.18400e-06 1.800
+ 2.18405e-06 0.000 2.18700e-06 0.000 2.18705e-06 1.800 2.19000e-06 1.800 2.19005e-06 0.000 2.19100e-06 0.000
+ 2.19105e-06 1.800 2.19200e-06 1.800 2.19205e-06 0.000 2.19400e-06 0.000 2.19405e-06 1.800 2.19600e-06 1.800
+ 2.19605e-06 0.000 2.19700e-06 0.000 2.19705e-06 1.800 2.20200e-06 1.800 2.20205e-06 0.000 2.20300e-06 0.000
+ 2.20305e-06 1.800 2.20500e-06 1.800 2.20505e-06 0.000 2.20700e-06 0.000 2.20705e-06 1.800 2.20800e-06 1.800
+ 2.20805e-06 0.000 2.21000e-06 0.000 2.21005e-06 1.800 2.21200e-06 1.800 2.21205e-06 0.000 2.21300e-06 0.000
+ 2.21305e-06 1.800 2.21500e-06 1.800 2.21505e-06 0.000 2.21700e-06 0.000 2.21705e-06 1.800 2.21800e-06 1.800
+ 2.21805e-06 0.000 2.21900e-06 0.000 2.21905e-06 1.800 2.22000e-06 1.800 2.22005e-06 0.000 2.22100e-06 0.000
+ 2.22105e-06 1.800 2.22200e-06 1.800 2.22205e-06 0.000 2.22300e-06 0.000 2.22305e-06 1.800 2.22500e-06 1.800
+ 2.22505e-06 0.000 2.22700e-06 0.000 2.22705e-06 1.800 2.22900e-06 1.800 2.22905e-06 0.000 2.23000e-06 0.000
+ 2.23005e-06 1.800 2.23300e-06 1.800 2.23305e-06 0.000 2.23400e-06 0.000 2.23405e-06 1.800 2.23500e-06 1.800
+ 2.23505e-06 0.000 2.23600e-06 0.000 2.23605e-06 1.800 2.23700e-06 1.800 2.23705e-06 0.000 2.23800e-06 0.000
+ 2.23805e-06 1.800 2.24100e-06 1.800 2.24105e-06 0.000 2.24500e-06 0.000 2.24505e-06 1.800 2.24700e-06 1.800
+ 2.24705e-06 0.000 2.24800e-06 0.000 2.24805e-06 1.800 2.24900e-06 1.800 2.24905e-06 0.000 2.25100e-06 0.000
+ 2.25105e-06 1.800 2.25300e-06 1.800 2.25305e-06 0.000 2.25500e-06 0.000 2.25505e-06 1.800 2.25700e-06 1.800
+ 2.25705e-06 0.000 2.25800e-06 0.000 2.25805e-06 1.800 2.26100e-06 1.800 2.26105e-06 0.000 2.26400e-06 0.000
+ 2.26405e-06 1.800 2.26500e-06 1.800 2.26505e-06 0.000 2.26700e-06 0.000 2.26705e-06 1.800 2.26800e-06 1.800
+ 2.26805e-06 0.000 2.27000e-06 0.000 2.27005e-06 1.800 2.27300e-06 1.800 2.27305e-06 0.000 2.27400e-06 0.000
+ 2.27405e-06 1.800 2.27500e-06 1.800 2.27505e-06 0.000 2.27700e-06 0.000 2.27705e-06 1.800 2.27900e-06 1.800
+ 2.27905e-06 0.000 2.28000e-06 0.000 2.28005e-06 1.800 2.28100e-06 1.800 2.28105e-06 0.000 2.28200e-06 0.000
+ 2.28205e-06 1.800 2.28300e-06 1.800 2.28305e-06 0.000 2.28600e-06 0.000 2.28605e-06 1.800 2.28700e-06 1.800
+ 2.28705e-06 0.000 2.28800e-06 0.000 2.28805e-06 1.800 2.28900e-06 1.800 2.28905e-06 0.000 2.29000e-06 0.000
+ 2.29005e-06 1.800 2.29500e-06 1.800 2.29505e-06 0.000 2.29600e-06 0.000 2.29605e-06 1.800 2.29700e-06 1.800
+ 2.29705e-06 0.000 2.29800e-06 0.000 2.29805e-06 1.800 2.29900e-06 1.800 2.29905e-06 0.000 2.30100e-06 0.000
+ 2.30105e-06 1.800 2.30200e-06 1.800 2.30205e-06 0.000 2.30400e-06 0.000 2.30405e-06 1.800 2.30600e-06 1.800
+ 2.30605e-06 0.000 2.30700e-06 0.000 2.30705e-06 1.800 2.30800e-06 1.800 2.30805e-06 0.000 2.31000e-06 0.000
+ 2.31005e-06 1.800 2.31200e-06 1.800 2.31205e-06 0.000 2.31300e-06 0.000 2.31305e-06 1.800 2.31400e-06 1.800
+ 2.31405e-06 0.000 2.31500e-06 0.000 2.31505e-06 1.800 2.32300e-06 1.800 2.32305e-06 0.000 2.32400e-06 0.000
+ 2.32405e-06 1.800 2.32500e-06 1.800 2.32505e-06 0.000 2.32800e-06 0.000 2.32805e-06 1.800 2.33100e-06 1.800
+ 2.33105e-06 0.000 2.33500e-06 0.000 2.33505e-06 1.800 2.33700e-06 1.800 2.33705e-06 0.000 2.33900e-06 0.000
+ 2.33905e-06 1.800 2.34000e-06 1.800 2.34005e-06 0.000 2.34100e-06 0.000 2.34105e-06 1.800 2.34200e-06 1.800
+ 2.34205e-06 0.000 2.34400e-06 0.000 2.34405e-06 1.800 2.34500e-06 1.800 2.34505e-06 0.000 2.34900e-06 0.000
+ 2.34905e-06 1.800 2.35200e-06 1.800 2.35205e-06 0.000 2.35300e-06 0.000 2.35305e-06 1.800 2.35400e-06 1.800
+ 2.35405e-06 0.000 2.35700e-06 0.000 2.35705e-06 1.800 2.36000e-06 1.800 2.36005e-06 0.000 2.36100e-06 0.000
+ 2.36105e-06 1.800 2.36300e-06 1.800 2.36305e-06 0.000 2.36400e-06 0.000 2.36405e-06 1.800 2.36500e-06 1.800
+ 2.36505e-06 0.000 2.36600e-06 0.000 2.36605e-06 1.800 2.36700e-06 1.800 2.36705e-06 0.000 2.36800e-06 0.000
+ 2.36805e-06 1.800 2.37300e-06 1.800 2.37305e-06 0.000 2.37400e-06 0.000 2.37405e-06 1.800 2.37500e-06 1.800
+ 2.37505e-06 0.000 2.37600e-06 0.000 2.37605e-06 1.800 2.38000e-06 1.800 2.38005e-06 0.000 2.38100e-06 0.000
+ 2.38105e-06 1.800 2.38300e-06 1.800 2.38305e-06 0.000 2.38600e-06 0.000 2.38605e-06 1.800 2.38700e-06 1.800
+ 2.38705e-06 0.000 2.38900e-06 0.000 2.38905e-06 1.800 2.39200e-06 1.800 2.39205e-06 0.000 2.39500e-06 0.000
+ 2.39505e-06 1.800 2.39600e-06 1.800 2.39605e-06 0.000 2.39800e-06 0.000 2.39805e-06 1.800 2.40100e-06 1.800
+ 2.40105e-06 0.000 2.40600e-06 0.000 2.40605e-06 1.800 2.40900e-06 1.800 2.40905e-06 0.000 2.41000e-06 0.000
+ 2.41005e-06 1.800 2.41200e-06 1.800 2.41205e-06 0.000 2.41400e-06 0.000 2.41405e-06 1.800 2.41500e-06 1.800
+ 2.41505e-06 0.000 2.41800e-06 0.000 2.41805e-06 1.800 2.41900e-06 1.800 2.41905e-06 0.000 2.42300e-06 0.000
+ 2.42305e-06 1.800 2.42400e-06 1.800 2.42405e-06 0.000 2.42600e-06 0.000 2.42605e-06 1.800 2.42700e-06 1.800
+ 2.42705e-06 0.000 2.42900e-06 0.000 2.42905e-06 1.800 2.43000e-06 1.800 2.43005e-06 0.000 2.43100e-06 0.000
+ 2.43105e-06 1.800 2.43500e-06 1.800 2.43505e-06 0.000 2.43600e-06 0.000 2.43605e-06 1.800 2.43700e-06 1.800
+ 2.43705e-06 0.000 2.43800e-06 0.000 2.43805e-06 1.800 2.43900e-06 1.800 2.43905e-06 0.000 2.44000e-06 0.000
+ 2.44005e-06 1.800 2.44200e-06 1.800 2.44205e-06 0.000 2.44300e-06 0.000 2.44305e-06 1.800 2.44500e-06 1.800
+ 2.44505e-06 0.000 2.44600e-06 0.000 2.44605e-06 1.800 2.44700e-06 1.800 2.44705e-06 0.000 2.44800e-06 0.000
+ 2.44805e-06 1.800 2.44900e-06 1.800 2.44905e-06 0.000 2.45200e-06 0.000 2.45205e-06 1.800 2.45300e-06 1.800
+ 2.45305e-06 0.000 2.45400e-06 0.000 2.45405e-06 1.800 2.45500e-06 1.800 2.45505e-06 0.000 2.45700e-06 0.000
+ 2.45705e-06 1.800 2.45800e-06 1.800 2.45805e-06 0.000 2.46100e-06 0.000 2.46105e-06 1.800 2.46400e-06 1.800
+ 2.46405e-06 0.000 2.46700e-06 0.000 2.46705e-06 1.800 2.46800e-06 1.800 2.46805e-06 0.000 2.46900e-06 0.000
+ 2.46905e-06 1.800 2.47100e-06 1.800 2.47105e-06 0.000 2.47300e-06 0.000 2.47305e-06 1.800 2.47700e-06 1.800
+ 2.47705e-06 0.000 2.48000e-06 0.000 2.48005e-06 1.800 2.48400e-06 1.800 2.48405e-06 0.000 2.48500e-06 0.000
+ 2.48505e-06 1.800 2.48600e-06 1.800 2.48605e-06 0.000 2.49000e-06 0.000 2.49005e-06 1.800 2.49300e-06 1.800
+ 2.49305e-06 0.000 2.49700e-06 0.000 2.49705e-06 1.800 2.49800e-06 1.800 2.49805e-06 0.000 2.50200e-06 0.000
+ 2.50205e-06 1.800 2.50400e-06 1.800 2.50405e-06 0.000 2.50500e-06 0.000 2.50505e-06 1.800 2.50700e-06 1.800
+ 2.50705e-06 0.000 2.50900e-06 0.000 2.50905e-06 1.800 2.51300e-06 1.800 2.51305e-06 0.000 2.51500e-06 0.000
+ 2.51505e-06 1.800 2.51600e-06 1.800 2.51605e-06 0.000 2.51800e-06 0.000 2.51805e-06 1.800 2.52100e-06 1.800
+ 2.52105e-06 0.000 2.52300e-06 0.000 2.52305e-06 1.800 2.52400e-06 1.800 2.52405e-06 0.000 2.52700e-06 0.000
+ 2.52705e-06 1.800 2.52800e-06 1.800 2.52805e-06 0.000 2.53000e-06 0.000 2.53005e-06 1.800 2.53100e-06 1.800
+ 2.53105e-06 0.000 2.53200e-06 0.000 2.53205e-06 1.800 2.53300e-06 1.800 2.53305e-06 0.000 2.53400e-06 0.000
+ 2.53405e-06 1.800 2.53500e-06 1.800 2.53505e-06 0.000 2.53600e-06 0.000 2.53605e-06 1.800 2.53800e-06 1.800
+ 2.53805e-06 0.000 2.53900e-06 0.000 2.53905e-06 1.800 2.54000e-06 1.800 2.54005e-06 0.000 2.54300e-06 0.000
+ 2.54305e-06 1.800 2.54400e-06 1.800 2.54405e-06 0.000 2.54500e-06 0.000 2.54505e-06 1.800 2.54600e-06 1.800
+ 2.54605e-06 0.000 2.54900e-06 0.000 2.54905e-06 1.800 2.55000e-06 1.800 2.55005e-06 0.000 2.55300e-06 0.000
+ 2.55305e-06 1.800 2.55600e-06 1.800 2.55605e-06 0.000 2.56000e-06 0.000 2.56005e-06 1.800 2.56200e-06 1.800
+ 2.56205e-06 0.000 2.56500e-06 0.000 2.56505e-06 1.800 2.56600e-06 1.800 2.56605e-06 0.000 2.56700e-06 0.000
+ 2.56705e-06 1.800 2.57000e-06 1.800 2.57005e-06 0.000 2.57100e-06 0.000 2.57105e-06 1.800 2.57200e-06 1.800
+ 2.57205e-06 0.000 2.57500e-06 0.000 2.57505e-06 1.800 2.57600e-06 1.800 2.57605e-06 0.000 2.57900e-06 0.000
+ 2.57905e-06 1.800 2.58000e-06 1.800 2.58005e-06 0.000 2.58100e-06 0.000 2.58105e-06 1.800 2.58200e-06 1.800
+ 2.58205e-06 0.000 2.58400e-06 0.000 2.58405e-06 1.800 2.58500e-06 1.800 2.58505e-06 0.000 2.58700e-06 0.000
+ 2.58705e-06 1.800 2.59100e-06 1.800 2.59105e-06 0.000 2.59300e-06 0.000 2.59305e-06 1.800 2.59400e-06 1.800
+ 2.59405e-06 0.000 2.59500e-06 0.000 2.59505e-06 1.800 2.59700e-06 1.800 2.59705e-06 0.000 2.59800e-06 0.000
+ 2.59805e-06 1.800 2.60000e-06 1.800 2.60005e-06 0.000 2.60200e-06 0.000 2.60205e-06 1.800 2.60400e-06 1.800
+ 2.60405e-06 0.000 2.60500e-06 0.000 2.60505e-06 1.800 2.60600e-06 1.800 2.60605e-06 0.000 2.61000e-06 0.000
+ 2.61005e-06 1.800 2.61100e-06 1.800 2.61105e-06 0.000 2.61200e-06 0.000 2.61205e-06 1.800 2.61300e-06 1.800
+ 2.61305e-06 0.000 2.61400e-06 0.000 2.61405e-06 1.800 2.61500e-06 1.800 2.61505e-06 0.000 2.61600e-06 0.000
+ 2.61605e-06 1.800 2.61800e-06 1.800 2.61805e-06 0.000 2.62000e-06 0.000 2.62005e-06 1.800 2.62400e-06 1.800
+ 2.62405e-06 0.000 2.62800e-06 0.000 2.62805e-06 1.800 2.62900e-06 1.800 2.62905e-06 0.000 2.63000e-06 0.000
+ 2.63005e-06 1.800 2.63100e-06 1.800 2.63105e-06 0.000 2.63200e-06 0.000 2.63205e-06 1.800 2.63300e-06 1.800
+ 2.63305e-06 0.000 2.63600e-06 0.000 2.63605e-06 1.800 2.63900e-06 1.800 2.63905e-06 0.000 2.64000e-06 0.000
+ 2.64005e-06 1.800 2.64400e-06 1.800 2.64405e-06 0.000 2.64600e-06 0.000 2.64605e-06 1.800 2.64700e-06 1.800
+ 2.64705e-06 0.000 2.65500e-06 0.000 2.65505e-06 1.800 2.65600e-06 1.800 2.65605e-06 0.000 2.65900e-06 0.000
+ 2.65905e-06 1.800 2.66100e-06 1.800 2.66105e-06 0.000 2.66200e-06 0.000 2.66205e-06 1.800 2.66300e-06 1.800
+ 2.66305e-06 0.000 2.66800e-06 0.000 2.66805e-06 1.800 2.67000e-06 1.800 2.67005e-06 0.000 2.67200e-06 0.000
+ 2.67205e-06 1.800 2.67300e-06 1.800 2.67305e-06 0.000 2.67600e-06 0.000 2.67605e-06 1.800 2.67700e-06 1.800
+ 2.67705e-06 0.000 2.68100e-06 0.000 2.68105e-06 1.800 2.68200e-06 1.800 2.68205e-06 0.000 2.68300e-06 0.000
+ 2.68305e-06 1.800 2.68700e-06 1.800 2.68705e-06 0.000 2.68900e-06 0.000 2.68905e-06 1.800 2.69200e-06 1.800
+ 2.69205e-06 0.000 2.69300e-06 0.000 2.69305e-06 1.800 2.69400e-06 1.800 2.69405e-06 0.000 2.69500e-06 0.000
+ 2.69505e-06 1.800 2.69600e-06 1.800 2.69605e-06 0.000 2.69900e-06 0.000 2.69905e-06 1.800 2.70000e-06 1.800
+ 2.70005e-06 0.000 2.70100e-06 0.000 2.70105e-06 1.800 2.70200e-06 1.800 2.70205e-06 0.000 2.70300e-06 0.000
+ 2.70305e-06 1.800 2.70400e-06 1.800 2.70405e-06 0.000 2.70700e-06 0.000 2.70705e-06 1.800 2.70800e-06 1.800
+ 2.70805e-06 0.000 2.71000e-06 0.000 2.71005e-06 1.800 2.71100e-06 1.800 2.71105e-06 0.000 2.71400e-06 0.000
+ 2.71405e-06 1.800 2.71500e-06 1.800 2.71505e-06 0.000 2.71700e-06 0.000 2.71705e-06 1.800 2.71800e-06 1.800
+ 2.71805e-06 0.000 2.72100e-06 0.000 2.72105e-06 1.800 2.72200e-06 1.800 2.72205e-06 0.000 2.72400e-06 0.000
+ 2.72405e-06 1.800 2.72500e-06 1.800 2.72505e-06 0.000 2.73000e-06 0.000 2.73005e-06 1.800 2.73100e-06 1.800
+ 2.73105e-06 0.000 2.73300e-06 0.000 2.73305e-06 1.800 2.73500e-06 1.800 2.73505e-06 0.000 2.74200e-06 0.000
+ 2.74205e-06 1.800 2.74400e-06 1.800 2.74405e-06 0.000 2.74600e-06 0.000 2.74605e-06 1.800 2.74700e-06 1.800
+ 2.74705e-06 0.000 2.75400e-06 0.000 2.75405e-06 1.800 2.75600e-06 1.800 2.75605e-06 0.000 2.75700e-06 0.000
+ 2.75705e-06 1.800 2.75800e-06 1.800 2.75805e-06 0.000 2.76600e-06 0.000 2.76605e-06 1.800 2.76800e-06 1.800
+ 2.76805e-06 0.000 2.77200e-06 0.000 2.77205e-06 1.800 2.77300e-06 1.800 2.77305e-06 0.000 2.77700e-06 0.000
+ 2.77705e-06 1.800 2.77900e-06 1.800 2.77905e-06 0.000 2.78200e-06 0.000 2.78205e-06 1.800 2.78700e-06 1.800
+ 2.78705e-06 0.000 2.78800e-06 0.000 2.78805e-06 1.800 2.79400e-06 1.800 2.79405e-06 0.000 2.79600e-06 0.000
+ 2.79605e-06 1.800 2.79700e-06 1.800 2.79705e-06 0.000 2.80000e-06 0.000 2.80005e-06 1.800 2.80200e-06 1.800
+ 2.80205e-06 0.000 2.80400e-06 0.000 2.80405e-06 1.800 2.80500e-06 1.800 2.80505e-06 0.000 2.80600e-06 0.000
+ 2.80605e-06 1.800 2.81200e-06 1.800 2.81205e-06 0.000 2.81300e-06 0.000 2.81305e-06 1.800 2.81400e-06 1.800
+ 2.81405e-06 0.000 2.81500e-06 0.000 2.81505e-06 1.800 2.81600e-06 1.800 2.81605e-06 0.000 2.81700e-06 0.000
+ 2.81705e-06 1.800 2.82100e-06 1.800 2.82105e-06 0.000 2.82300e-06 0.000 2.82305e-06 1.800 2.82500e-06 1.800
+ 2.82505e-06 0.000 2.82600e-06 0.000 2.82605e-06 1.800 2.83100e-06 1.800 2.83105e-06 0.000 2.83200e-06 0.000
+ 2.83205e-06 1.800 2.83300e-06 1.800 2.83305e-06 0.000 2.83400e-06 0.000 2.83405e-06 1.800 2.83500e-06 1.800
+ 2.83505e-06 0.000 2.83700e-06 0.000 2.83705e-06 1.800 2.83800e-06 1.800 2.83805e-06 0.000 2.84000e-06 0.000
+ 2.84005e-06 1.800 2.84100e-06 1.800 2.84105e-06 0.000 2.84200e-06 0.000 2.84205e-06 1.800 2.84300e-06 1.800
+ 2.84305e-06 0.000 2.84500e-06 0.000 2.84505e-06 1.800 2.84800e-06 1.800 2.84805e-06 0.000 2.84900e-06 0.000
+ 2.84905e-06 1.800 2.85300e-06 1.800 2.85305e-06 0.000 2.85400e-06 0.000 2.85405e-06 1.800 2.85600e-06 1.800
+ 2.85605e-06 0.000 2.85800e-06 0.000 2.85805e-06 1.800 2.86100e-06 1.800 2.86105e-06 0.000 2.86400e-06 0.000
+ 2.86405e-06 1.800 2.86500e-06 1.800 2.86505e-06 0.000 2.86600e-06 0.000 2.86605e-06 1.800 2.86700e-06 1.800
+ 2.86705e-06 0.000 2.87200e-06 0.000 2.87205e-06 1.800 2.87600e-06 1.800 2.87605e-06 0.000 2.87700e-06 0.000
+ 2.87705e-06 1.800 2.87800e-06 1.800 2.87805e-06 0.000 2.88100e-06 0.000 2.88105e-06 1.800 2.88200e-06 1.800
+ 2.88205e-06 0.000 2.88300e-06 0.000 2.88305e-06 1.800 2.88400e-06 1.800 2.88405e-06 0.000 2.88600e-06 0.000
+ 2.88605e-06 1.800 2.88800e-06 1.800 2.88805e-06 0.000 2.89000e-06 0.000 2.89005e-06 1.800 2.89100e-06 1.800
+ 2.89105e-06 0.000 2.89400e-06 0.000 2.89405e-06 1.800 2.89700e-06 1.800 2.89705e-06 0.000 2.90000e-06 0.000
+ 2.90005e-06 1.800 2.90300e-06 1.800 2.90305e-06 0.000 2.90600e-06 0.000 2.90605e-06 1.800 2.90700e-06 1.800
+ 2.90705e-06 0.000 2.90800e-06 0.000 2.90805e-06 1.800 2.91000e-06 1.800 2.91005e-06 0.000 2.91100e-06 0.000
+ 2.91105e-06 1.800 2.91300e-06 1.800 2.91305e-06 0.000 2.91500e-06 0.000 2.91505e-06 1.800 2.91900e-06 1.800
+ 2.91905e-06 0.000 2.92100e-06 0.000 2.92105e-06 1.800 2.92300e-06 1.800 2.92305e-06 0.000 2.92500e-06 0.000
+ 2.92505e-06 1.800 2.92600e-06 1.800 2.92605e-06 0.000 2.92700e-06 0.000 2.92705e-06 1.800 2.92900e-06 1.800
+ 2.92905e-06 0.000 2.93000e-06 0.000 2.93005e-06 1.800 2.93400e-06 1.800 2.93405e-06 0.000 2.93600e-06 0.000
+ 2.93605e-06 1.800 2.93700e-06 1.800 2.93705e-06 0.000 2.94000e-06 0.000 2.94005e-06 1.800 2.94200e-06 1.800
+ 2.94205e-06 0.000 2.94500e-06 0.000 2.94505e-06 1.800 2.94600e-06 1.800 2.94605e-06 0.000 2.94700e-06 0.000
+ 2.94705e-06 1.800 2.94800e-06 1.800 2.94805e-06 0.000 2.94900e-06 0.000 2.94905e-06 1.800 2.95000e-06 1.800
+ 2.95005e-06 0.000 2.95200e-06 0.000 2.95205e-06 1.800 2.95300e-06 1.800 2.95305e-06 0.000 2.95400e-06 0.000
+ 2.95405e-06 1.800 2.95800e-06 1.800 2.95805e-06 0.000 2.95900e-06 0.000 2.95905e-06 1.800 2.96000e-06 1.800
+ 2.96005e-06 0.000 2.96200e-06 0.000 2.96205e-06 1.800 2.96300e-06 1.800 2.96305e-06 0.000 2.96600e-06 0.000
+ 2.96605e-06 1.800 2.96700e-06 1.800 2.96705e-06 0.000 2.97400e-06 0.000 2.97405e-06 1.800 2.97500e-06 1.800
+ 2.97505e-06 0.000 2.97600e-06 0.000 2.97605e-06 1.800 2.98200e-06 1.800 2.98205e-06 0.000 2.98300e-06 0.000
+ 2.98305e-06 1.800 2.98400e-06 1.800 2.98405e-06 0.000 2.98500e-06 0.000 2.98505e-06 1.800 2.98600e-06 1.800
+ 2.98605e-06 0.000 2.99000e-06 0.000 2.99005e-06 1.800 2.99200e-06 1.800 2.99205e-06 0.000 2.99400e-06 0.000
+ 2.99405e-06 1.800 2.99500e-06 1.800 2.99505e-06 0.000 2.99800e-06 0.000 2.99805e-06 1.800 3.00000e-06 1.800
+ 3.00005e-06 0.000 3.00100e-06 0.000 3.00105e-06 1.800 3.00300e-06 1.800 3.00305e-06 0.000 3.00700e-06 0.000
+ 3.00705e-06 1.800 3.00900e-06 1.800 3.00905e-06 0.000 3.01100e-06 0.000 3.01105e-06 1.800 3.01300e-06 1.800
+ 3.01305e-06 0.000 3.01400e-06 0.000 3.01405e-06 1.800 3.01500e-06 1.800 3.01505e-06 0.000 3.01800e-06 0.000
+ 3.01805e-06 1.800 3.01900e-06 1.800 3.01905e-06 0.000 3.02400e-06 0.000 3.02405e-06 1.800 3.02600e-06 1.800
+ 3.02605e-06 0.000 3.03100e-06 0.000 3.03105e-06 1.800 3.03300e-06 1.800 3.03305e-06 0.000 3.03600e-06 0.000
+ 3.03605e-06 1.800 3.03900e-06 1.800 3.03905e-06 0.000 3.04000e-06 0.000 3.04005e-06 1.800 3.04200e-06 1.800
+ 3.04205e-06 0.000 3.04400e-06 0.000 3.04405e-06 1.800 3.04500e-06 1.800 3.04505e-06 0.000 3.04600e-06 0.000
+ 3.04605e-06 1.800 3.04900e-06 1.800 3.04905e-06 0.000 3.05000e-06 0.000 3.05005e-06 1.800 3.05100e-06 1.800
+ 3.05105e-06 0.000 3.05300e-06 0.000 3.05305e-06 1.800 3.05800e-06 1.800 3.05805e-06 0.000 3.06000e-06 0.000
+ 3.06005e-06 1.800 3.06300e-06 1.800 3.06305e-06 0.000 3.06400e-06 0.000 3.06405e-06 1.800 3.06700e-06 1.800
+ 3.06705e-06 0.000 3.06800e-06 0.000 3.06805e-06 1.800 3.07200e-06 1.800 3.07205e-06 0.000 3.07300e-06 0.000
+ 3.07305e-06 1.800 3.07500e-06 1.800 3.07505e-06 0.000 3.07700e-06 0.000 3.07705e-06 1.800 3.07800e-06 1.800
+ 3.07805e-06 0.000 3.07900e-06 0.000 3.07905e-06 1.800 3.08000e-06 1.800 3.08005e-06 0.000 3.08200e-06 0.000
+ 3.08205e-06 1.800 3.08600e-06 1.800 3.08605e-06 0.000 3.08700e-06 0.000 3.08705e-06 1.800 3.09100e-06 1.800
+ 3.09105e-06 0.000 3.09600e-06 0.000 3.09605e-06 1.800 3.09700e-06 1.800 3.09705e-06 0.000 3.09900e-06 0.000
+ 3.09905e-06 1.800 3.10000e-06 1.800 3.10005e-06 0.000 3.10100e-06 0.000 3.10105e-06 1.800 3.10200e-06 1.800
+ 3.10205e-06 0.000 3.10400e-06 0.000 3.10405e-06 1.800 3.10500e-06 1.800 3.10505e-06 0.000 3.11000e-06 0.000
+ 3.11005e-06 1.800 3.11100e-06 1.800 3.11105e-06 0.000 3.11200e-06 0.000 3.11205e-06 1.800 3.11400e-06 1.800
+ 3.11405e-06 0.000 3.11500e-06 0.000 3.11505e-06 1.800 3.11900e-06 1.800 3.11905e-06 0.000 3.12100e-06 0.000
+ 3.12105e-06 1.800 3.12200e-06 1.800 3.12205e-06 0.000 3.12400e-06 0.000 3.12405e-06 1.800 3.12500e-06 1.800
+ 3.12505e-06 0.000 3.12600e-06 0.000 3.12605e-06 1.800 3.12700e-06 1.800 3.12705e-06 0.000 3.12900e-06 0.000
+ 3.12905e-06 1.800 3.13200e-06 1.800 3.13205e-06 0.000 3.13300e-06 0.000 3.13305e-06 1.800 3.13400e-06 1.800
+ 3.13405e-06 0.000 3.13600e-06 0.000 3.13605e-06 1.800 3.13700e-06 1.800 3.13705e-06 0.000 3.13800e-06 0.000
+ 3.13805e-06 1.800 3.13900e-06 1.800 3.13905e-06 0.000 3.14000e-06 0.000 3.14005e-06 1.800 3.14100e-06 1.800
+ 3.14105e-06 0.000 3.14400e-06 0.000 3.14405e-06 1.800 3.14500e-06 1.800 3.14505e-06 0.000 3.14600e-06 0.000
+ 3.14605e-06 1.800 3.14800e-06 1.800 3.14805e-06 0.000 3.15000e-06 0.000 3.15005e-06 1.800 3.15900e-06 1.800
+ 3.15905e-06 0.000 3.16100e-06 0.000 3.16105e-06 1.800 3.16300e-06 1.800 3.16305e-06 0.000 3.16400e-06 0.000
+ 3.16405e-06 1.800 3.16700e-06 1.800 3.16705e-06 0.000 3.16900e-06 0.000 3.16905e-06 1.800 3.17000e-06 1.800
+ 3.17005e-06 0.000 3.17600e-06 0.000 3.17605e-06 1.800 3.17700e-06 1.800 3.17705e-06 0.000 3.17800e-06 0.000
+ 3.17805e-06 1.800 3.18100e-06 1.800 3.18105e-06 0.000 3.18300e-06 0.000 3.18305e-06 1.800 3.18500e-06 1.800
+ 3.18505e-06 0.000 3.18600e-06 0.000 3.18605e-06 1.800 3.18800e-06 1.800 3.18805e-06 0.000 3.19200e-06 0.000
+ 3.19205e-06 1.800 3.19300e-06 1.800 3.19305e-06 0.000 3.19500e-06 0.000 3.19505e-06 1.800 3.19600e-06 1.800
+ 3.19605e-06 0.000 3.19700e-06 0.000 3.19705e-06 1.800 3.20000e-06 1.800 3.20005e-06 0.000 3.20100e-06 0.000
+ 3.20105e-06 1.800 3.20200e-06 1.800 3.20205e-06 0.000 3.20300e-06 0.000 3.20305e-06 1.800 3.20600e-06 1.800
+ 3.20605e-06 0.000 3.20800e-06 0.000 3.20805e-06 1.800 3.20900e-06 1.800 3.20905e-06 0.000 3.21000e-06 0.000
+ 3.21005e-06 1.800 3.21200e-06 1.800 3.21205e-06 0.000 3.21300e-06 0.000 3.21305e-06 1.800 3.21500e-06 1.800
+ 3.21505e-06 0.000 3.21600e-06 0.000 3.21605e-06 1.800 3.21700e-06 1.800 3.21705e-06 0.000 3.21800e-06 0.000
+ 3.21805e-06 1.800 3.21900e-06 1.800 3.21905e-06 0.000 3.22000e-06 0.000 3.22005e-06 1.800 3.22100e-06 1.800
+ 3.22105e-06 0.000 3.22300e-06 0.000 3.22305e-06 1.800 3.22400e-06 1.800 3.22405e-06 0.000 3.22500e-06 0.000
+ 3.22505e-06 1.800 3.22600e-06 1.800 3.22605e-06 0.000 3.22700e-06 0.000 3.22705e-06 1.800 3.22900e-06 1.800
+ 3.22905e-06 0.000 3.23100e-06 0.000 3.23105e-06 1.800 3.23300e-06 1.800 3.23305e-06 0.000 3.23600e-06 0.000
+ 3.23605e-06 1.800 3.23800e-06 1.800 3.23805e-06 0.000 3.23900e-06 0.000 3.23905e-06 1.800 3.24200e-06 1.800
+ 3.24205e-06 0.000 3.24300e-06 0.000 3.24305e-06 1.800 3.24600e-06 1.800 3.24605e-06 0.000 3.24700e-06 0.000
+ 3.24705e-06 1.800 3.24800e-06 1.800 3.24805e-06 0.000 3.25700e-06 0.000 3.25705e-06 1.800 3.25900e-06 1.800
+ 3.25905e-06 0.000 3.26000e-06 0.000 3.26005e-06 1.800 3.26100e-06 1.800 3.26105e-06 0.000 3.26300e-06 0.000
+ 3.26305e-06 1.800 3.26500e-06 1.800 3.26505e-06 0.000 3.26600e-06 0.000 3.26605e-06 1.800 3.26900e-06 1.800
+ 3.26905e-06 0.000 3.27200e-06 0.000 3.27205e-06 1.800 3.27400e-06 1.800 3.27405e-06 0.000 3.27600e-06 0.000
+ 3.27605e-06 1.800 3.27800e-06 1.800 3.27805e-06 0.000 3.28100e-06 0.000 3.28105e-06 1.800 3.28200e-06 1.800
+ 3.28205e-06 0.000 3.28400e-06 0.000 3.28405e-06 1.800 3.29000e-06 1.800 3.29005e-06 0.000 3.29300e-06 0.000
+ 3.29305e-06 1.800 3.29600e-06 1.800 3.29605e-06 0.000 3.29800e-06 0.000 3.29805e-06 1.800 3.30100e-06 1.800
+ 3.30105e-06 0.000 3.30700e-06 0.000 3.30705e-06 1.800 3.30800e-06 1.800 3.30805e-06 0.000 3.30900e-06 0.000
+ 3.30905e-06 1.800 3.31000e-06 1.800 3.31005e-06 0.000 3.31100e-06 0.000 3.31105e-06 1.800 3.31200e-06 1.800
+ 3.31205e-06 0.000 3.31300e-06 0.000 3.31305e-06 1.800 3.31400e-06 1.800 3.31405e-06 0.000 3.31500e-06 0.000
+ 3.31505e-06 1.800 3.31600e-06 1.800 3.31605e-06 0.000 3.32000e-06 0.000 3.32005e-06 1.800 3.32100e-06 1.800
+ 3.32105e-06 0.000 3.32300e-06 0.000 3.32305e-06 1.800 3.32400e-06 1.800 3.32405e-06 0.000 3.32700e-06 0.000
+ 3.32705e-06 1.800 3.32800e-06 1.800 3.32805e-06 0.000 3.33100e-06 0.000 3.33105e-06 1.800 3.33200e-06 1.800
+ 3.33205e-06 0.000 3.33400e-06 0.000 3.33405e-06 1.800 3.33500e-06 1.800 3.33505e-06 0.000 3.33700e-06 0.000
+ 3.33705e-06 1.800 3.33800e-06 1.800 3.33805e-06 0.000 3.34000e-06 0.000 3.34005e-06 1.800 3.34400e-06 1.800
+ 3.34405e-06 0.000 3.34500e-06 0.000 3.34505e-06 1.800 3.34700e-06 1.800 3.34705e-06 0.000 3.34800e-06 0.000
+ 3.34805e-06 1.800 3.35100e-06 1.800 3.35105e-06 0.000 3.35400e-06 0.000 3.35405e-06 1.800 3.35600e-06 1.800
+ 3.35605e-06 0.000 3.35700e-06 0.000 3.35705e-06 1.800 3.36000e-06 1.800 3.36005e-06 0.000 3.36200e-06 0.000
+ 3.36205e-06 1.800 3.36300e-06 1.800 3.36305e-06 0.000 3.36400e-06 0.000 3.36405e-06 1.800 3.36500e-06 1.800
+ 3.36505e-06 0.000 3.36900e-06 0.000 3.36905e-06 1.800 3.37200e-06 1.800 3.37205e-06 0.000 3.37400e-06 0.000
+ 3.37405e-06 1.800 3.37600e-06 1.800 3.37605e-06 0.000 3.38100e-06 0.000 3.38105e-06 1.800 3.38800e-06 1.800
+ 3.38805e-06 0.000 3.38900e-06 0.000 3.38905e-06 1.800 3.39400e-06 1.800 3.39405e-06 0.000 3.39700e-06 0.000
+ 3.39705e-06 1.800 3.39800e-06 1.800 3.39805e-06 0.000 3.40100e-06 0.000 3.40105e-06 1.800 3.40200e-06 1.800
+ 3.40205e-06 0.000 3.40300e-06 0.000 3.40305e-06 1.800 3.41000e-06 1.800 3.41005e-06 0.000 3.41100e-06 0.000
+ 3.41105e-06 1.800 3.41300e-06 1.800 3.41305e-06 0.000 3.41700e-06 0.000 3.41705e-06 1.800 3.41900e-06 1.800
+ 3.41905e-06 0.000 3.42200e-06 0.000 3.42205e-06 1.800 3.42900e-06 1.800 3.42905e-06 0.000 3.43000e-06 0.000
+ 3.43005e-06 1.800 3.43100e-06 1.800 3.43105e-06 0.000 3.43300e-06 0.000 3.43305e-06 1.800 3.43500e-06 1.800
+ 3.43505e-06 0.000 3.43800e-06 0.000 3.43805e-06 1.800 3.43900e-06 1.800 3.43905e-06 0.000 3.44100e-06 0.000
+ 3.44105e-06 1.800 3.44300e-06 1.800 3.44305e-06 0.000 3.44500e-06 0.000 3.44505e-06 1.800 3.44800e-06 1.800
+ 3.44805e-06 0.000 3.44900e-06 0.000 3.44905e-06 1.800 3.45000e-06 1.800 3.45005e-06 0.000 3.45100e-06 0.000
+ 3.45105e-06 1.800 3.45300e-06 1.800 3.45305e-06 0.000 3.45400e-06 0.000 3.45405e-06 1.800 3.45700e-06 1.800
+ 3.45705e-06 0.000 3.45900e-06 0.000 3.45905e-06 1.800 3.46100e-06 1.800 3.46105e-06 0.000 3.46200e-06 0.000
+ 3.46205e-06 1.800 3.46400e-06 1.800 3.46405e-06 0.000 3.46500e-06 0.000 3.46505e-06 1.800 3.46700e-06 1.800
+ 3.46705e-06 0.000 3.47000e-06 0.000 3.47005e-06 1.800 3.47100e-06 1.800 3.47105e-06 0.000 3.47200e-06 0.000
+ 3.47205e-06 1.800 3.47300e-06 1.800 3.47305e-06 0.000 3.47400e-06 0.000 3.47405e-06 1.800 3.47600e-06 1.800
+ 3.47605e-06 0.000 3.47700e-06 0.000 3.47705e-06 1.800 3.47800e-06 1.800 3.47805e-06 0.000 3.47900e-06 0.000
+ 3.47905e-06 1.800 3.48000e-06 1.800 3.48005e-06 0.000 3.48100e-06 0.000 3.48105e-06 1.800 3.48400e-06 1.800
+ 3.48405e-06 0.000 3.48500e-06 0.000 3.48505e-06 1.800 3.48800e-06 1.800 3.48805e-06 0.000 3.49000e-06 0.000
+ 3.49005e-06 1.800 3.49100e-06 1.800 3.49105e-06 0.000 3.49400e-06 0.000 3.49405e-06 1.800 3.49600e-06 1.800
+ 3.49605e-06 0.000 3.49800e-06 0.000 3.49805e-06 1.800 3.50100e-06 1.800 3.50105e-06 0.000 3.50200e-06 0.000
+ 3.50205e-06 1.800 3.50800e-06 1.800 3.50805e-06 0.000 3.50900e-06 0.000 3.50905e-06 1.800 3.51100e-06 1.800
+ 3.51105e-06 0.000 3.51200e-06 0.000 3.51205e-06 1.800 3.51500e-06 1.800 3.51505e-06 0.000 3.51800e-06 0.000
+ 3.51805e-06 1.800 3.51900e-06 1.800 3.51905e-06 0.000 3.52100e-06 0.000 3.52105e-06 1.800 3.52300e-06 1.800
+ 3.52305e-06 0.000 3.52400e-06 0.000 3.52405e-06 1.800 3.52600e-06 1.800 3.52605e-06 0.000 3.52700e-06 0.000
+ 3.52705e-06 1.800 3.52800e-06 1.800 3.52805e-06 0.000 3.52900e-06 0.000 3.52905e-06 1.800 3.53200e-06 1.800
+ 3.53205e-06 0.000 3.53300e-06 0.000 3.53305e-06 1.800 3.53400e-06 1.800 3.53405e-06 0.000 3.53800e-06 0.000
+ 3.53805e-06 1.800 3.53900e-06 1.800 3.53905e-06 0.000 3.54400e-06 0.000 3.54405e-06 1.800 3.54500e-06 1.800
+ 3.54505e-06 0.000 3.54800e-06 0.000 3.54805e-06 1.800 3.55000e-06 1.800 3.55005e-06 0.000 3.55200e-06 0.000
+ 3.55205e-06 1.800 3.55500e-06 1.800 3.55505e-06 0.000 3.55600e-06 0.000 3.55605e-06 1.800 3.55800e-06 1.800
+ 3.55805e-06 0.000 3.55900e-06 0.000 3.55905e-06 1.800 3.56200e-06 1.800 3.56205e-06 0.000 3.56800e-06 0.000
+ 3.56805e-06 1.800 3.57000e-06 1.800 3.57005e-06 0.000 3.57600e-06 0.000 3.57605e-06 1.800 3.57800e-06 1.800
+ 3.57805e-06 0.000 3.58100e-06 0.000 3.58105e-06 1.800 3.58200e-06 1.800 3.58205e-06 0.000 3.58600e-06 0.000
+ 3.58605e-06 1.800 3.58900e-06 1.800 3.58905e-06 0.000 3.59200e-06 0.000 3.59205e-06 1.800 3.59900e-06 1.800
+ 3.59905e-06 0.000 3.60000e-06 0.000 3.60005e-06 1.800 3.60200e-06 1.800 3.60205e-06 0.000 3.60300e-06 0.000
+ 3.60305e-06 1.800 3.60700e-06 1.800 3.60705e-06 0.000 3.61200e-06 0.000 3.61205e-06 1.800 3.61500e-06 1.800
+ 3.61505e-06 0.000 3.61700e-06 0.000 3.61705e-06 1.800 3.61800e-06 1.800 3.61805e-06 0.000 3.62100e-06 0.000
+ 3.62105e-06 1.800 3.62200e-06 1.800 3.62205e-06 0.000 3.62500e-06 0.000 3.62505e-06 1.800 3.62700e-06 1.800
+ 3.62705e-06 0.000 3.62800e-06 0.000 3.62805e-06 1.800 3.62900e-06 1.800 3.62905e-06 0.000 3.63000e-06 0.000
+ 3.63005e-06 1.800 3.63200e-06 1.800 3.63205e-06 0.000 3.63400e-06 0.000 3.63405e-06 1.800 3.63600e-06 1.800
+ 3.63605e-06 0.000 3.63700e-06 0.000 3.63705e-06 1.800 3.63800e-06 1.800 3.63805e-06 0.000 3.63900e-06 0.000
+ 3.63905e-06 1.800 3.64000e-06 1.800 3.64005e-06 0.000 3.64200e-06 0.000 3.64205e-06 1.800 3.64500e-06 1.800
+ 3.64505e-06 0.000 3.64800e-06 0.000 3.64805e-06 1.800 3.64900e-06 1.800 3.64905e-06 0.000 3.65000e-06 0.000
+ 3.65005e-06 1.800 3.65200e-06 1.800 3.65205e-06 0.000 3.65300e-06 0.000 3.65305e-06 1.800 3.65900e-06 1.800
+ 3.65905e-06 0.000 3.66100e-06 0.000 3.66105e-06 1.800 3.66300e-06 1.800 3.66305e-06 0.000 3.66400e-06 0.000
+ 3.66405e-06 1.800 3.66600e-06 1.800 3.66605e-06 0.000 3.66700e-06 0.000 3.66705e-06 1.800 3.67100e-06 1.800
+ 3.67105e-06 0.000 3.67200e-06 0.000 3.67205e-06 1.800 3.67300e-06 1.800 3.67305e-06 0.000 3.67600e-06 0.000
+ 3.67605e-06 1.800 3.67900e-06 1.800 3.67905e-06 0.000 3.68000e-06 0.000 3.68005e-06 1.800 3.68100e-06 1.800
+ 3.68105e-06 0.000 3.68400e-06 0.000 3.68405e-06 1.800 3.68500e-06 1.800 3.68505e-06 0.000 3.69000e-06 0.000
+ 3.69005e-06 1.800 3.69100e-06 1.800 3.69105e-06 0.000 3.69200e-06 0.000 3.69205e-06 1.800 3.69400e-06 1.800
+ 3.69405e-06 0.000 3.69500e-06 0.000 3.69505e-06 1.800 3.69700e-06 1.800 3.69705e-06 0.000 3.70100e-06 0.000
+ 3.70105e-06 1.800 3.70200e-06 1.800 3.70205e-06 0.000 3.70300e-06 0.000 3.70305e-06 1.800 3.71000e-06 1.800
+ 3.71005e-06 0.000 3.71100e-06 0.000 3.71105e-06 1.800 3.71700e-06 1.800 3.71705e-06 0.000 3.71800e-06 0.000
+ 3.71805e-06 1.800 3.71900e-06 1.800 3.71905e-06 0.000 3.72100e-06 0.000 3.72105e-06 1.800 3.72300e-06 1.800
+ 3.72305e-06 0.000 3.72600e-06 0.000 3.72605e-06 1.800 3.72900e-06 1.800 3.72905e-06 0.000 3.73000e-06 0.000
+ 3.73005e-06 1.800 3.73100e-06 1.800 3.73105e-06 0.000 3.73200e-06 0.000 3.73205e-06 1.800 3.73300e-06 1.800
+ 3.73305e-06 0.000 3.73400e-06 0.000 3.73405e-06 1.800 3.73500e-06 1.800 3.73505e-06 0.000 3.73600e-06 0.000
+ 3.73605e-06 1.800 3.73700e-06 1.800 3.73705e-06 0.000 3.74000e-06 0.000 3.74005e-06 1.800 3.74100e-06 1.800
+ 3.74105e-06 0.000 3.74200e-06 0.000 3.74205e-06 1.800 3.74400e-06 1.800 3.74405e-06 0.000 3.74500e-06 0.000
+ 3.74505e-06 1.800 3.74800e-06 1.800 3.74805e-06 0.000 3.74900e-06 0.000 3.74905e-06 1.800 3.75100e-06 1.800
+ 3.75105e-06 0.000 3.75300e-06 0.000 3.75305e-06 1.800 3.75400e-06 1.800 3.75405e-06 0.000 3.75700e-06 0.000
+ 3.75705e-06 1.800 3.75800e-06 1.800 3.75805e-06 0.000 3.76000e-06 0.000 3.76005e-06 1.800 3.76100e-06 1.800
+ 3.76105e-06 0.000 3.76200e-06 0.000 3.76205e-06 1.800 3.76300e-06 1.800 3.76305e-06 0.000 3.76500e-06 0.000
+ 3.76505e-06 1.800 3.76800e-06 1.800 3.76805e-06 0.000 3.76900e-06 0.000 3.76905e-06 1.800 3.77000e-06 1.800
+ 3.77005e-06 0.000 3.77100e-06 0.000 3.77105e-06 1.800 3.77200e-06 1.800 3.77205e-06 0.000 3.77600e-06 0.000
+ 3.77605e-06 1.800 3.77700e-06 1.800 3.77705e-06 0.000 3.77800e-06 0.000 3.77805e-06 1.800 3.78100e-06 1.800
+ 3.78105e-06 0.000 3.78300e-06 0.000 3.78305e-06 1.800 3.78500e-06 1.800 3.78505e-06 0.000 3.78600e-06 0.000
+ 3.78605e-06 1.800 3.78700e-06 1.800 3.78705e-06 0.000 3.78800e-06 0.000 3.78805e-06 1.800 3.79000e-06 1.800
+ 3.79005e-06 0.000 3.79300e-06 0.000 3.79305e-06 1.800 3.79400e-06 1.800 3.79405e-06 0.000 3.79500e-06 0.000
+ 3.79505e-06 1.800 3.79700e-06 1.800 3.79705e-06 0.000 3.79800e-06 0.000 3.79805e-06 1.800 3.80100e-06 1.800
+ 3.80105e-06 0.000 3.80200e-06 0.000 3.80205e-06 1.800 3.81600e-06 1.800 3.81605e-06 0.000 3.81800e-06 0.000
+ 3.81805e-06 1.800 3.81900e-06 1.800 3.81905e-06 0.000 3.82100e-06 0.000 3.82105e-06 1.800 3.82200e-06 1.800
+ 3.82205e-06 0.000 3.82400e-06 0.000 3.82405e-06 1.800 3.82500e-06 1.800 3.82505e-06 0.000 3.83100e-06 0.000
+ 3.83105e-06 1.800 3.83300e-06 1.800 3.83305e-06 0.000 3.83600e-06 0.000 3.83605e-06 1.800 3.83700e-06 1.800
+ 3.83705e-06 0.000 3.83900e-06 0.000 3.83905e-06 1.800 3.84200e-06 1.800 3.84205e-06 0.000 3.84300e-06 0.000
+ 3.84305e-06 1.800 3.84400e-06 1.800 3.84405e-06 0.000 3.84500e-06 0.000 3.84505e-06 1.800 3.84600e-06 1.800
+ 3.84605e-06 0.000 3.84700e-06 0.000 3.84705e-06 1.800 3.84800e-06 1.800 3.84805e-06 0.000 3.84900e-06 0.000
+ 3.84905e-06 1.800 3.85000e-06 1.800 3.85005e-06 0.000 3.85300e-06 0.000 3.85305e-06 1.800 3.85400e-06 1.800
+ 3.85405e-06 0.000 3.85700e-06 0.000 3.85705e-06 1.800 3.85900e-06 1.800 3.85905e-06 0.000 3.86100e-06 0.000
+ 3.86105e-06 1.800 3.86200e-06 1.800 3.86205e-06 0.000 3.86300e-06 0.000 3.86305e-06 1.800 3.86400e-06 1.800
+ 3.86405e-06 0.000 3.86500e-06 0.000 3.86505e-06 1.800 3.86600e-06 1.800 3.86605e-06 0.000 3.86700e-06 0.000
+ 3.86705e-06 1.800 3.86800e-06 1.800 3.86805e-06 0.000 3.86900e-06 0.000 3.86905e-06 1.800 3.87400e-06 1.800
+ 3.87405e-06 0.000 3.87500e-06 0.000 3.87505e-06 1.800 3.87600e-06 1.800 3.87605e-06 0.000 3.87700e-06 0.000
+ 3.87705e-06 1.800 3.88000e-06 1.800 3.88005e-06 0.000 3.88200e-06 0.000 3.88205e-06 1.800 3.88300e-06 1.800
+ 3.88305e-06 0.000 3.88400e-06 0.000 3.88405e-06 1.800 3.88900e-06 1.800 3.88905e-06 0.000 3.89100e-06 0.000
+ 3.89105e-06 1.800 3.89500e-06 1.800 3.89505e-06 0.000 3.89600e-06 0.000 3.89605e-06 1.800 3.90000e-06 1.800
+ 3.90005e-06 0.000 3.90100e-06 0.000 3.90105e-06 1.800 3.90400e-06 1.800 3.90405e-06 0.000 3.90700e-06 0.000
+ 3.90705e-06 1.800 3.90900e-06 1.800 3.90905e-06 0.000 3.91100e-06 0.000 3.91105e-06 1.800 3.91300e-06 1.800
+ 3.91305e-06 0.000 3.91500e-06 0.000 3.91505e-06 1.800 3.91600e-06 1.800 3.91605e-06 0.000 3.91900e-06 0.000
+ 3.91905e-06 1.800 3.92000e-06 1.800 3.92005e-06 0.000 3.92100e-06 0.000 3.92105e-06 1.800 3.92200e-06 1.800
+ 3.92205e-06 0.000 3.92500e-06 0.000 3.92505e-06 1.800 3.92900e-06 1.800 3.92905e-06 0.000 3.93200e-06 0.000
+ 3.93205e-06 1.800 3.93300e-06 1.800 3.93305e-06 0.000 3.93600e-06 0.000 3.93605e-06 1.800 3.93800e-06 1.800
+ 3.93805e-06 0.000 3.94100e-06 0.000 3.94105e-06 1.800 3.94200e-06 1.800 3.94205e-06 0.000 3.94400e-06 0.000
+ 3.94405e-06 1.800 3.94500e-06 1.800 3.94505e-06 0.000 3.94700e-06 0.000 3.94705e-06 1.800 3.95000e-06 1.800
+ 3.95005e-06 0.000 3.95100e-06 0.000 3.95105e-06 1.800 3.95400e-06 1.800 3.95405e-06 0.000 3.95600e-06 0.000
+ 3.95605e-06 1.800 3.95700e-06 1.800 3.95705e-06 0.000 3.95900e-06 0.000 3.95905e-06 1.800 3.96000e-06 1.800
+ 3.96005e-06 0.000 3.96300e-06 0.000 3.96305e-06 1.800 3.96500e-06 1.800 3.96505e-06 0.000 3.96800e-06 0.000
+ 3.96805e-06 1.800 3.97000e-06 1.800 3.97005e-06 0.000 3.97200e-06 0.000 3.97205e-06 1.800 3.97400e-06 1.800
+ 3.97405e-06 0.000 3.97700e-06 0.000 3.97705e-06 1.800 3.98000e-06 1.800 3.98005e-06 0.000 3.98300e-06 0.000
+ 3.98305e-06 1.800 3.98400e-06 1.800 3.98405e-06 0.000 3.98700e-06 0.000 3.98705e-06 1.800 3.98800e-06 1.800
+ 3.98805e-06 0.000 3.99000e-06 0.000 3.99005e-06 1.800 3.99400e-06 1.800 3.99405e-06 0.000 3.99500e-06 0.000
+ 3.99505e-06 1.800 3.99600e-06 1.800 3.99605e-06 0.000 3.99700e-06 0.000 3.99705e-06 1.800 4.00000e-06 1.800
+ 4.00005e-06 0.000 4.00100e-06 0.000 4.00105e-06 1.800 4.00500e-06 1.800 4.00505e-06 0.000 4.00600e-06 0.000
+ 4.00605e-06 1.800 4.00700e-06 1.800 4.00705e-06 0.000 4.00800e-06 0.000 4.00805e-06 1.800 4.01100e-06 1.800
+ 4.01105e-06 0.000 4.01400e-06 0.000 4.01405e-06 1.800 4.01700e-06 1.800 4.01705e-06 0.000 4.01800e-06 0.000
+ 4.01805e-06 1.800 4.02100e-06 1.800 4.02105e-06 0.000 4.02500e-06 0.000 4.02505e-06 1.800 4.02700e-06 1.800
+ 4.02705e-06 0.000 4.02900e-06 0.000 4.02905e-06 1.800 4.03000e-06 1.800 4.03005e-06 0.000 4.03100e-06 0.000
+ 4.03105e-06 1.800 4.03300e-06 1.800 4.03305e-06 0.000 4.03400e-06 0.000 4.03405e-06 1.800 4.03500e-06 1.800
+ 4.03505e-06 0.000 4.03600e-06 0.000 4.03605e-06 1.800 4.03700e-06 1.800 4.03705e-06 0.000 4.03900e-06 0.000
+ 4.03905e-06 1.800 4.04000e-06 1.800 4.04005e-06 0.000 4.04100e-06 0.000 4.04105e-06 1.800 4.04200e-06 1.800
+ 4.04205e-06 0.000 4.04400e-06 0.000 4.04405e-06 1.800 4.04700e-06 1.800 4.04705e-06 0.000 4.04900e-06 0.000
+ 4.04905e-06 1.800 4.05200e-06 1.800 4.05205e-06 0.000 4.05600e-06 0.000 4.05605e-06 1.800 4.05700e-06 1.800
+ 4.05705e-06 0.000 4.05800e-06 0.000 4.05805e-06 1.800 4.05900e-06 1.800 4.05905e-06 0.000 4.06100e-06 0.000
+ 4.06105e-06 1.800 4.06200e-06 1.800 4.06205e-06 0.000 4.06400e-06 0.000 4.06405e-06 1.800 4.06700e-06 1.800
+ 4.06705e-06 0.000 4.06900e-06 0.000 4.06905e-06 1.800 4.07100e-06 1.800 4.07105e-06 0.000 4.07500e-06 0.000
+ 4.07505e-06 1.800 4.07700e-06 1.800 4.07705e-06 0.000 4.07800e-06 0.000 4.07805e-06 1.800 4.08300e-06 1.800
+ 4.08305e-06 0.000 4.08400e-06 0.000 4.08405e-06 1.800 4.08500e-06 1.800 4.08505e-06 0.000 4.08900e-06 0.000
+ 4.08905e-06 1.800 4.09100e-06 1.800 4.09105e-06 0.000 4.09200e-06 0.000 4.09205e-06 1.800 4.09600e-06 1.800
+ )
Xd_c0 src_c0 c0 vdd gnd tb_inv
Va2 src_a2 gnd PWL(
+ 0.00000e+00 1.800 8.00000e-09 1.800 8.05000e-09 0.000 1.60000e-08 0.000 1.60500e-08 1.800 2.40000e-08 1.800
+ 2.40500e-08 0.000 3.20000e-08 0.000 3.20500e-08 1.800 4.00000e-08 1.800 4.00500e-08 0.000 4.80000e-08 0.000
+ 4.80500e-08 1.800 5.60000e-08 1.800 5.60500e-08 0.000 6.40000e-08 0.000 6.40500e-08 1.800 7.20000e-08 1.800
+ 7.20500e-08 0.000 8.00000e-08 0.000 8.00500e-08 1.800 8.80000e-08 1.800 8.80500e-08 0.000 9.60000e-08 0.000
+ 9.60500e-08 1.800 1.04000e-07 1.800 1.04050e-07 0.000 1.12000e-07 0.000 1.12050e-07 1.800 1.20000e-07 1.800
+ 1.20050e-07 0.000 1.28000e-07 0.000 1.28050e-07 1.800 1.36000e-07 1.800 1.36050e-07 0.000 1.44000e-07 0.000
+ 1.44050e-07 1.800 1.52000e-07 1.800 1.52050e-07 0.000 1.60000e-07 0.000 1.60050e-07 1.800 1.68000e-07 1.800
+ 1.68050e-07 0.000 1.76000e-07 0.000 1.76050e-07 1.800 1.84000e-07 1.800 1.84050e-07 0.000 1.92000e-07 0.000
+ 1.92050e-07 1.800 2.00000e-07 1.800 2.00050e-07 0.000 2.08000e-07 0.000 2.08050e-07 1.800 2.16000e-07 1.800
+ 2.16050e-07 0.000 2.24000e-07 0.000 2.24050e-07 1.800 2.32000e-07 1.800 2.32050e-07 0.000 2.40000e-07 0.000
+ 2.40050e-07 1.800 2.48000e-07 1.800 2.48050e-07 0.000 2.56000e-07 0.000 2.56050e-07 1.800 2.64000e-07 1.800
+ 2.64050e-07 0.000 2.72000e-07 0.000 2.72050e-07 1.800 2.80000e-07 1.800 2.80050e-07 0.000 2.88000e-07 0.000
+ 2.88050e-07 1.800 2.96000e-07 1.800 2.96050e-07 0.000 3.04000e-07 0.000 3.04050e-07 1.800 3.12000e-07 1.800
+ 3.12050e-07 0.000 3.20000e-07 0.000 3.20050e-07 1.800 3.28000e-07 1.800 3.28050e-07 0.000 3.36000e-07 0.000
+ 3.36050e-07 1.800 3.44000e-07 1.800 3.44050e-07 0.000 3.52000e-07 0.000 3.52050e-07 1.800 3.60000e-07 1.800
+ 3.60050e-07 0.000 3.68000e-07 0.000 3.68050e-07 1.800 3.76000e-07 1.800 3.76050e-07 0.000 3.84000e-07 0.000
+ 3.84050e-07 1.800 3.92000e-07 1.800 3.92050e-07 0.000 4.00000e-07 0.000 4.00050e-07 1.800 4.08000e-07 1.800
+ 4.08050e-07 0.000 4.16000e-07 0.000 4.16050e-07 1.800 4.24000e-07 1.800 4.24050e-07 0.000 4.32000e-07 0.000
+ 4.32050e-07 1.800 4.40000e-07 1.800 4.40050e-07 0.000 4.48000e-07 0.000 4.48050e-07 1.800 4.56000e-07 1.800
+ 4.56050e-07 0.000 4.64000e-07 0.000 4.64050e-07 1.800 4.72000e-07 1.800 4.72050e-07 0.000 4.80000e-07 0.000
+ 4.80050e-07 1.800 4.88000e-07 1.800 4.88050e-07 0.000 4.96000e-07 0.000 4.96050e-07 1.800 5.04000e-07 1.800
+ 5.04050e-07 0.000 5.12000e-07 0.000 5.12050e-07 1.800 5.20000e-07 1.800 5.20050e-07 0.000 5.28000e-07 0.000
+ 5.28050e-07 1.800 5.36000e-07 1.800 5.36050e-07 0.000 5.44000e-07 0.000 5.44050e-07 1.800 5.52000e-07 1.800
+ 5.52050e-07 0.000 5.60000e-07 0.000 5.60050e-07 1.800 5.68000e-07 1.800 5.68050e-07 0.000 5.76000e-07 0.000
+ 5.76050e-07 1.800 5.84000e-07 1.800 5.84050e-07 0.000 5.92000e-07 0.000 5.92050e-07 1.800 6.00000e-07 1.800
+ 6.00050e-07 0.000 6.08000e-07 0.000 6.08050e-07 1.800 6.16000e-07 1.800 6.16050e-07 0.000 6.24000e-07 0.000
+ 6.24050e-07 1.800 6.32000e-07 1.800 6.32050e-07 0.000 6.40000e-07 0.000 6.40050e-07 1.800 6.48000e-07 1.800
+ 6.48050e-07 0.000 6.56000e-07 0.000 6.56050e-07 1.800 6.64000e-07 1.800 6.64050e-07 0.000 6.72000e-07 0.000
+ 6.72050e-07 1.800 6.80000e-07 1.800 6.80050e-07 0.000 6.88000e-07 0.000 6.88050e-07 1.800 6.96000e-07 1.800
+ 6.96050e-07 0.000 7.04000e-07 0.000 7.04050e-07 1.800 7.12000e-07 1.800 7.12050e-07 0.000 7.20000e-07 0.000
+ 7.20050e-07 1.800 7.28000e-07 1.800 7.28050e-07 0.000 7.36000e-07 0.000 7.36050e-07 1.800 7.44000e-07 1.800
+ 7.44050e-07 0.000 7.52000e-07 0.000 7.52050e-07 1.800 7.60000e-07 1.800 7.60050e-07 0.000 7.68000e-07 0.000
+ 7.68050e-07 1.800 7.76000e-07 1.800 7.76050e-07 0.000 7.84000e-07 0.000 7.84050e-07 1.800 7.92000e-07 1.800
+ 7.92050e-07 0.000 8.00000e-07 0.000 8.00050e-07 1.800 8.08000e-07 1.800 8.08050e-07 0.000 8.16000e-07 0.000
+ 8.16050e-07 1.800 8.24000e-07 1.800 8.24050e-07 0.000 8.32000e-07 0.000 8.32050e-07 1.800 8.40000e-07 1.800
+ 8.40050e-07 0.000 8.48000e-07 0.000 8.48050e-07 1.800 8.56000e-07 1.800 8.56050e-07 0.000 8.64000e-07 0.000
+ 8.64050e-07 1.800 8.72000e-07 1.800 8.72050e-07 0.000 8.80000e-07 0.000 8.80050e-07 1.800 8.88000e-07 1.800
+ 8.88050e-07 0.000 8.96000e-07 0.000 8.96050e-07 1.800 9.04000e-07 1.800 9.04050e-07 0.000 9.12000e-07 0.000
+ 9.12050e-07 1.800 9.20000e-07 1.800 9.20050e-07 0.000 9.28000e-07 0.000 9.28050e-07 1.800 9.36000e-07 1.800
+ 9.36050e-07 0.000 9.44000e-07 0.000 9.44050e-07 1.800 9.52000e-07 1.800 9.52050e-07 0.000 9.60000e-07 0.000
+ 9.60050e-07 1.800 9.68000e-07 1.800 9.68050e-07 0.000 9.76000e-07 0.000 9.76050e-07 1.800 9.84000e-07 1.800
+ 9.84050e-07 0.000 9.92000e-07 0.000 9.92050e-07 1.800 1.00000e-06 1.800 1.00005e-06 0.000 1.00800e-06 0.000
+ 1.00805e-06 1.800 1.01600e-06 1.800 1.01605e-06 0.000 1.02400e-06 0.000 1.02405e-06 1.800 1.03200e-06 1.800
+ 1.03205e-06 0.000 1.04000e-06 0.000 1.04005e-06 1.800 1.04800e-06 1.800 1.04805e-06 0.000 1.05600e-06 0.000
+ 1.05605e-06 1.800 1.06400e-06 1.800 1.06405e-06 0.000 1.07200e-06 0.000 1.07205e-06 1.800 1.08000e-06 1.800
+ 1.08005e-06 0.000 1.08800e-06 0.000 1.08805e-06 1.800 1.09600e-06 1.800 1.09605e-06 0.000 1.10400e-06 0.000
+ 1.10405e-06 1.800 1.11200e-06 1.800 1.11205e-06 0.000 1.12000e-06 0.000 1.12005e-06 1.800 1.12800e-06 1.800
+ 1.12805e-06 0.000 1.13600e-06 0.000 1.13605e-06 1.800 1.14400e-06 1.800 1.14405e-06 0.000 1.15200e-06 0.000
+ 1.15205e-06 1.800 1.16000e-06 1.800 1.16005e-06 0.000 1.16800e-06 0.000 1.16805e-06 1.800 1.17600e-06 1.800
+ 1.17605e-06 0.000 1.18400e-06 0.000 1.18405e-06 1.800 1.19200e-06 1.800 1.19205e-06 0.000 1.20000e-06 0.000
+ 1.20005e-06 1.800 1.20800e-06 1.800 1.20805e-06 0.000 1.21600e-06 0.000 1.21605e-06 1.800 1.22400e-06 1.800
+ 1.22405e-06 0.000 1.23200e-06 0.000 1.23205e-06 1.800 1.24000e-06 1.800 1.24005e-06 0.000 1.24800e-06 0.000
+ 1.24805e-06 1.800 1.25600e-06 1.800 1.25605e-06 0.000 1.26400e-06 0.000 1.26405e-06 1.800 1.27200e-06 1.800
+ 1.27205e-06 0.000 1.28000e-06 0.000 1.28005e-06 1.800 1.28800e-06 1.800 1.28805e-06 0.000 1.29600e-06 0.000
+ 1.29605e-06 1.800 1.30400e-06 1.800 1.30405e-06 0.000 1.31200e-06 0.000 1.31205e-06 1.800 1.32000e-06 1.800
+ 1.32005e-06 0.000 1.32800e-06 0.000 1.32805e-06 1.800 1.33600e-06 1.800 1.33605e-06 0.000 1.34400e-06 0.000
+ 1.34405e-06 1.800 1.35200e-06 1.800 1.35205e-06 0.000 1.36000e-06 0.000 1.36005e-06 1.800 1.36800e-06 1.800
+ 1.36805e-06 0.000 1.37600e-06 0.000 1.37605e-06 1.800 1.38400e-06 1.800 1.38405e-06 0.000 1.39200e-06 0.000
+ 1.39205e-06 1.800 1.40000e-06 1.800 1.40005e-06 0.000 1.40800e-06 0.000 1.40805e-06 1.800 1.41600e-06 1.800
+ 1.41605e-06 0.000 1.42400e-06 0.000 1.42405e-06 1.800 1.43200e-06 1.800 1.43205e-06 0.000 1.44000e-06 0.000
+ 1.44005e-06 1.800 1.44800e-06 1.800 1.44805e-06 0.000 1.45600e-06 0.000 1.45605e-06 1.800 1.46400e-06 1.800
+ 1.46405e-06 0.000 1.47200e-06 0.000 1.47205e-06 1.800 1.48000e-06 1.800 1.48005e-06 0.000 1.48800e-06 0.000
+ 1.48805e-06 1.800 1.49600e-06 1.800 1.49605e-06 0.000 1.50400e-06 0.000 1.50405e-06 1.800 1.51200e-06 1.800
+ 1.51205e-06 0.000 1.52000e-06 0.000 1.52005e-06 1.800 1.52800e-06 1.800 1.52805e-06 0.000 1.53600e-06 0.000
+ 1.53605e-06 1.800 1.54400e-06 1.800 1.54405e-06 0.000 1.55200e-06 0.000 1.55205e-06 1.800 1.56000e-06 1.800
+ 1.56005e-06 0.000 1.56800e-06 0.000 1.56805e-06 1.800 1.57600e-06 1.800 1.57605e-06 0.000 1.58400e-06 0.000
+ 1.58405e-06 1.800 1.59200e-06 1.800 1.59205e-06 0.000 1.60000e-06 0.000 1.60005e-06 1.800 1.60800e-06 1.800
+ 1.60805e-06 0.000 1.61600e-06 0.000 1.61605e-06 1.800 1.62400e-06 1.800 1.62405e-06 0.000 1.63200e-06 0.000
+ 1.63205e-06 1.800 1.64000e-06 1.800 1.64005e-06 0.000 1.64800e-06 0.000 1.64805e-06 1.800 1.65600e-06 1.800
+ 1.65605e-06 0.000 1.66400e-06 0.000 1.66405e-06 1.800 1.67200e-06 1.800 1.67205e-06 0.000 1.68000e-06 0.000
+ 1.68005e-06 1.800 1.68800e-06 1.800 1.68805e-06 0.000 1.69600e-06 0.000 1.69605e-06 1.800 1.70400e-06 1.800
+ 1.70405e-06 0.000 1.71200e-06 0.000 1.71205e-06 1.800 1.72000e-06 1.800 1.72005e-06 0.000 1.72800e-06 0.000
+ 1.72805e-06 1.800 1.73600e-06 1.800 1.73605e-06 0.000 1.74400e-06 0.000 1.74405e-06 1.800 1.75200e-06 1.800
+ 1.75205e-06 0.000 1.76000e-06 0.000 1.76005e-06 1.800 1.76800e-06 1.800 1.76805e-06 0.000 1.77600e-06 0.000
+ 1.77605e-06 1.800 1.78400e-06 1.800 1.78405e-06 0.000 1.79200e-06 0.000 1.79205e-06 1.800 1.80000e-06 1.800
+ 1.80005e-06 0.000 1.80800e-06 0.000 1.80805e-06 1.800 1.81600e-06 1.800 1.81605e-06 0.000 1.82400e-06 0.000
+ 1.82405e-06 1.800 1.83200e-06 1.800 1.83205e-06 0.000 1.84000e-06 0.000 1.84005e-06 1.800 1.84800e-06 1.800
+ 1.84805e-06 0.000 1.85600e-06 0.000 1.85605e-06 1.800 1.86400e-06 1.800 1.86405e-06 0.000 1.87200e-06 0.000
+ 1.87205e-06 1.800 1.88000e-06 1.800 1.88005e-06 0.000 1.88800e-06 0.000 1.88805e-06 1.800 1.89600e-06 1.800
+ 1.89605e-06 0.000 1.90400e-06 0.000 1.90405e-06 1.800 1.91200e-06 1.800 1.91205e-06 0.000 1.92000e-06 0.000
+ 1.92005e-06 1.800 1.92800e-06 1.800 1.92805e-06 0.000 1.93600e-06 0.000 1.93605e-06 1.800 1.94400e-06 1.800
+ 1.94405e-06 0.000 1.95200e-06 0.000 1.95205e-06 1.800 1.96000e-06 1.800 1.96005e-06 0.000 1.96800e-06 0.000
+ 1.96805e-06 1.800 1.97600e-06 1.800 1.97605e-06 0.000 1.98400e-06 0.000 1.98405e-06 1.800 1.99200e-06 1.800
+ 1.99205e-06 0.000 2.00000e-06 0.000 2.00005e-06 1.800 2.00800e-06 1.800 2.00805e-06 0.000 2.01600e-06 0.000
+ 2.01605e-06 1.800 2.02400e-06 1.800 2.02405e-06 0.000 2.03200e-06 0.000 2.03205e-06 1.800 2.04000e-06 1.800
+ 2.04005e-06 0.000 2.04800e-06 0.000 2.04805e-06 1.800 2.04900e-06 1.800 2.04905e-06 0.000 2.05000e-06 0.000
+ 2.05005e-06 1.800 2.05200e-06 1.800 2.05205e-06 0.000 2.05500e-06 0.000 2.05505e-06 1.800 2.05900e-06 1.800
+ 2.05905e-06 0.000 2.06100e-06 0.000 2.06105e-06 1.800 2.06600e-06 1.800 2.06605e-06 0.000 2.06700e-06 0.000
+ 2.06705e-06 1.800 2.06800e-06 1.800 2.06805e-06 0.000 2.06900e-06 0.000 2.06905e-06 1.800 2.07400e-06 1.800
+ 2.07405e-06 0.000 2.07500e-06 0.000 2.07505e-06 1.800 2.07700e-06 1.800 2.07705e-06 0.000 2.08000e-06 0.000
+ 2.08005e-06 1.800 2.08300e-06 1.800 2.08305e-06 0.000 2.08500e-06 0.000 2.08505e-06 1.800 2.08600e-06 1.800
+ 2.08605e-06 0.000 2.08900e-06 0.000 2.08905e-06 1.800 2.09100e-06 1.800 2.09105e-06 0.000 2.09200e-06 0.000
+ 2.09205e-06 1.800 2.09500e-06 1.800 2.09505e-06 0.000 2.09700e-06 0.000 2.09705e-06 1.800 2.09800e-06 1.800
+ 2.09805e-06 0.000 2.10400e-06 0.000 2.10405e-06 1.800 2.10500e-06 1.800 2.10505e-06 0.000 2.10600e-06 0.000
+ 2.10605e-06 1.800 2.10700e-06 1.800 2.10705e-06 0.000 2.11100e-06 0.000 2.11105e-06 1.800 2.11200e-06 1.800
+ 2.11205e-06 0.000 2.11500e-06 0.000 2.11505e-06 1.800 2.11600e-06 1.800 2.11605e-06 0.000 2.11700e-06 0.000
+ 2.11705e-06 1.800 2.11900e-06 1.800 2.11905e-06 0.000 2.12100e-06 0.000 2.12105e-06 1.800 2.12200e-06 1.800
+ 2.12205e-06 0.000 2.12600e-06 0.000 2.12605e-06 1.800 2.12700e-06 1.800 2.12705e-06 0.000 2.12800e-06 0.000
+ 2.12805e-06 1.800 2.13000e-06 1.800 2.13005e-06 0.000 2.13100e-06 0.000 2.13105e-06 1.800 2.13300e-06 1.800
+ 2.13305e-06 0.000 2.13700e-06 0.000 2.13705e-06 1.800 2.14100e-06 1.800 2.14105e-06 0.000 2.14200e-06 0.000
+ 2.14205e-06 1.800 2.14400e-06 1.800 2.14405e-06 0.000 2.14500e-06 0.000 2.14505e-06 1.800 2.14700e-06 1.800
+ 2.14705e-06 0.000 2.14800e-06 0.000 2.14805e-06 1.800 2.15300e-06 1.800 2.15305e-06 0.000 2.15400e-06 0.000
+ 2.15405e-06 1.800 2.15500e-06 1.800 2.15505e-06 0.000 2.15700e-06 0.000 2.15705e-06 1.800 2.15800e-06 1.800
+ 2.15805e-06 0.000 2.15900e-06 0.000 2.15905e-06 1.800 2.16000e-06 1.800 2.16005e-06 0.000 2.16200e-06 0.000
+ 2.16205e-06 1.800 2.16300e-06 1.800 2.16305e-06 0.000 2.16400e-06 0.000 2.16405e-06 1.800 2.16500e-06 1.800
+ 2.16505e-06 0.000 2.16700e-06 0.000 2.16705e-06 1.800 2.16800e-06 1.800 2.16805e-06 0.000 2.16900e-06 0.000
+ 2.16905e-06 1.800 2.17900e-06 1.800 2.17905e-06 0.000 2.18400e-06 0.000 2.18405e-06 1.800 2.18500e-06 1.800
+ 2.18505e-06 0.000 2.18600e-06 0.000 2.18605e-06 1.800 2.18700e-06 1.800 2.18705e-06 0.000 2.18800e-06 0.000
+ 2.18805e-06 1.800 2.18900e-06 1.800 2.18905e-06 0.000 2.19200e-06 0.000 2.19205e-06 1.800 2.19700e-06 1.800
+ 2.19705e-06 0.000 2.19800e-06 0.000 2.19805e-06 1.800 2.20000e-06 1.800 2.20005e-06 0.000 2.20200e-06 0.000
+ 2.20205e-06 1.800 2.20500e-06 1.800 2.20505e-06 0.000 2.20700e-06 0.000 2.20705e-06 1.800 2.20800e-06 1.800
+ 2.20805e-06 0.000 2.20900e-06 0.000 2.20905e-06 1.800 2.21000e-06 1.800 2.21005e-06 0.000 2.21100e-06 0.000
+ 2.21105e-06 1.800 2.21400e-06 1.800 2.21405e-06 0.000 2.21600e-06 0.000 2.21605e-06 1.800 2.21700e-06 1.800
+ 2.21705e-06 0.000 2.21800e-06 0.000 2.21805e-06 1.800 2.21900e-06 1.800 2.21905e-06 0.000 2.22000e-06 0.000
+ 2.22005e-06 1.800 2.22100e-06 1.800 2.22105e-06 0.000 2.22200e-06 0.000 2.22205e-06 1.800 2.22600e-06 1.800
+ 2.22605e-06 0.000 2.22700e-06 0.000 2.22705e-06 1.800 2.22900e-06 1.800 2.22905e-06 0.000 2.23000e-06 0.000
+ 2.23005e-06 1.800 2.23100e-06 1.800 2.23105e-06 0.000 2.24100e-06 0.000 2.24105e-06 1.800 2.24300e-06 1.800
+ 2.24305e-06 0.000 2.24700e-06 0.000 2.24705e-06 1.800 2.24800e-06 1.800 2.24805e-06 0.000 2.24900e-06 0.000
+ 2.24905e-06 1.800 2.25300e-06 1.800 2.25305e-06 0.000 2.25400e-06 0.000 2.25405e-06 1.800 2.25500e-06 1.800
+ 2.25505e-06 0.000 2.25600e-06 0.000 2.25605e-06 1.800 2.25700e-06 1.800 2.25705e-06 0.000 2.26000e-06 0.000
+ 2.26005e-06 1.800 2.26200e-06 1.800 2.26205e-06 0.000 2.26400e-06 0.000 2.26405e-06 1.800 2.26500e-06 1.800
+ 2.26505e-06 0.000 2.26900e-06 0.000 2.26905e-06 1.800 2.27000e-06 1.800 2.27005e-06 0.000 2.27100e-06 0.000
+ 2.27105e-06 1.800 2.27200e-06 1.800 2.27205e-06 0.000 2.27300e-06 0.000 2.27305e-06 1.800 2.27500e-06 1.800
+ 2.27505e-06 0.000 2.27800e-06 0.000 2.27805e-06 1.800 2.28000e-06 1.800 2.28005e-06 0.000 2.28100e-06 0.000
+ 2.28105e-06 1.800 2.29000e-06 1.800 2.29005e-06 0.000 2.29200e-06 0.000 2.29205e-06 1.800 2.29300e-06 1.800
+ 2.29305e-06 0.000 2.29400e-06 0.000 2.29405e-06 1.800 2.29600e-06 1.800 2.29605e-06 0.000 2.29900e-06 0.000
+ 2.29905e-06 1.800 2.30100e-06 1.800 2.30105e-06 0.000 2.30700e-06 0.000 2.30705e-06 1.800 2.30800e-06 1.800
+ 2.30805e-06 0.000 2.30900e-06 0.000 2.30905e-06 1.800 2.31000e-06 1.800 2.31005e-06 0.000 2.31100e-06 0.000
+ 2.31105e-06 1.800 2.31200e-06 1.800 2.31205e-06 0.000 2.31300e-06 0.000 2.31305e-06 1.800 2.31400e-06 1.800
+ 2.31405e-06 0.000 2.31500e-06 0.000 2.31505e-06 1.800 2.31600e-06 1.800 2.31605e-06 0.000 2.31700e-06 0.000
+ 2.31705e-06 1.800 2.32000e-06 1.800 2.32005e-06 0.000 2.32100e-06 0.000 2.32105e-06 1.800 2.32800e-06 1.800
+ 2.32805e-06 0.000 2.33000e-06 0.000 2.33005e-06 1.800 2.33300e-06 1.800 2.33305e-06 0.000 2.33400e-06 0.000
+ 2.33405e-06 1.800 2.33600e-06 1.800 2.33605e-06 0.000 2.33800e-06 0.000 2.33805e-06 1.800 2.34000e-06 1.800
+ 2.34005e-06 0.000 2.34100e-06 0.000 2.34105e-06 1.800 2.34300e-06 1.800 2.34305e-06 0.000 2.34700e-06 0.000
+ 2.34705e-06 1.800 2.35000e-06 1.800 2.35005e-06 0.000 2.35100e-06 0.000 2.35105e-06 1.800 2.35200e-06 1.800
+ 2.35205e-06 0.000 2.35500e-06 0.000 2.35505e-06 1.800 2.35700e-06 1.800 2.35705e-06 0.000 2.35800e-06 0.000
+ 2.35805e-06 1.800 2.36000e-06 1.800 2.36005e-06 0.000 2.36200e-06 0.000 2.36205e-06 1.800 2.36300e-06 1.800
+ 2.36305e-06 0.000 2.36400e-06 0.000 2.36405e-06 1.800 2.36900e-06 1.800 2.36905e-06 0.000 2.37100e-06 0.000
+ 2.37105e-06 1.800 2.37200e-06 1.800 2.37205e-06 0.000 2.37600e-06 0.000 2.37605e-06 1.800 2.37700e-06 1.800
+ 2.37705e-06 0.000 2.38100e-06 0.000 2.38105e-06 1.800 2.38300e-06 1.800 2.38305e-06 0.000 2.38400e-06 0.000
+ 2.38405e-06 1.800 2.39000e-06 1.800 2.39005e-06 0.000 2.39100e-06 0.000 2.39105e-06 1.800 2.39200e-06 1.800
+ 2.39205e-06 0.000 2.39600e-06 0.000 2.39605e-06 1.800 2.39700e-06 1.800 2.39705e-06 0.000 2.40300e-06 0.000
+ 2.40305e-06 1.800 2.40500e-06 1.800 2.40505e-06 0.000 2.40900e-06 0.000 2.40905e-06 1.800 2.41000e-06 1.800
+ 2.41005e-06 0.000 2.41300e-06 0.000 2.41305e-06 1.800 2.41500e-06 1.800 2.41505e-06 0.000 2.41700e-06 0.000
+ 2.41705e-06 1.800 2.42200e-06 1.800 2.42205e-06 0.000 2.42300e-06 0.000 2.42305e-06 1.800 2.42400e-06 1.800
+ 2.42405e-06 0.000 2.42500e-06 0.000 2.42505e-06 1.800 2.42700e-06 1.800 2.42705e-06 0.000 2.43200e-06 0.000
+ 2.43205e-06 1.800 2.43700e-06 1.800 2.43705e-06 0.000 2.43800e-06 0.000 2.43805e-06 1.800 2.44000e-06 1.800
+ 2.44005e-06 0.000 2.44100e-06 0.000 2.44105e-06 1.800 2.44600e-06 1.800 2.44605e-06 0.000 2.44700e-06 0.000
+ 2.44705e-06 1.800 2.44800e-06 1.800 2.44805e-06 0.000 2.44900e-06 0.000 2.44905e-06 1.800 2.45000e-06 1.800
+ 2.45005e-06 0.000 2.45100e-06 0.000 2.45105e-06 1.800 2.45200e-06 1.800 2.45205e-06 0.000 2.45300e-06 0.000
+ 2.45305e-06 1.800 2.45700e-06 1.800 2.45705e-06 0.000 2.45900e-06 0.000 2.45905e-06 1.800 2.46500e-06 1.800
+ 2.46505e-06 0.000 2.46700e-06 0.000 2.46705e-06 1.800 2.47000e-06 1.800 2.47005e-06 0.000 2.47200e-06 0.000
+ 2.47205e-06 1.800 2.47700e-06 1.800 2.47705e-06 0.000 2.47900e-06 0.000 2.47905e-06 1.800 2.48100e-06 1.800
+ 2.48105e-06 0.000 2.48200e-06 0.000 2.48205e-06 1.800 2.48300e-06 1.800 2.48305e-06 0.000 2.48400e-06 0.000
+ 2.48405e-06 1.800 2.48500e-06 1.800 2.48505e-06 0.000 2.48700e-06 0.000 2.48705e-06 1.800 2.48900e-06 1.800
+ 2.48905e-06 0.000 2.49200e-06 0.000 2.49205e-06 1.800 2.49600e-06 1.800 2.49605e-06 0.000 2.49700e-06 0.000
+ 2.49705e-06 1.800 2.49900e-06 1.800 2.49905e-06 0.000 2.50100e-06 0.000 2.50105e-06 1.800 2.50300e-06 1.800
+ 2.50305e-06 0.000 2.50700e-06 0.000 2.50705e-06 1.800 2.50800e-06 1.800 2.50805e-06 0.000 2.50900e-06 0.000
+ 2.50905e-06 1.800 2.51000e-06 1.800 2.51005e-06 0.000 2.51500e-06 0.000 2.51505e-06 1.800 2.51600e-06 1.800
+ 2.51605e-06 0.000 2.51800e-06 0.000 2.51805e-06 1.800 2.52100e-06 1.800 2.52105e-06 0.000 2.52400e-06 0.000
+ 2.52405e-06 1.800 2.52600e-06 1.800 2.52605e-06 0.000 2.52700e-06 0.000 2.52705e-06 1.800 2.53400e-06 1.800
+ 2.53405e-06 0.000 2.53500e-06 0.000 2.53505e-06 1.800 2.53800e-06 1.800 2.53805e-06 0.000 2.53900e-06 0.000
+ 2.53905e-06 1.800 2.54000e-06 1.800 2.54005e-06 0.000 2.54600e-06 0.000 2.54605e-06 1.800 2.54800e-06 1.800
+ 2.54805e-06 0.000 2.54900e-06 0.000 2.54905e-06 1.800 2.55100e-06 1.800 2.55105e-06 0.000 2.55400e-06 0.000
+ 2.55405e-06 1.800 2.55800e-06 1.800 2.55805e-06 0.000 2.55900e-06 0.000 2.55905e-06 1.800 2.56000e-06 1.800
+ 2.56005e-06 0.000 2.56100e-06 0.000 2.56105e-06 1.800 2.56200e-06 1.800 2.56205e-06 0.000 2.56600e-06 0.000
+ 2.56605e-06 1.800 2.56800e-06 1.800 2.56805e-06 0.000 2.56900e-06 0.000 2.56905e-06 1.800 2.57000e-06 1.800
+ 2.57005e-06 0.000 2.57100e-06 0.000 2.57105e-06 1.800 2.57200e-06 1.800 2.57205e-06 0.000 2.57400e-06 0.000
+ 2.57405e-06 1.800 2.57500e-06 1.800 2.57505e-06 0.000 2.57800e-06 0.000 2.57805e-06 1.800 2.58100e-06 1.800
+ 2.58105e-06 0.000 2.58300e-06 0.000 2.58305e-06 1.800 2.58400e-06 1.800 2.58405e-06 0.000 2.58600e-06 0.000
+ 2.58605e-06 1.800 2.58700e-06 1.800 2.58705e-06 0.000 2.58900e-06 0.000 2.58905e-06 1.800 2.59000e-06 1.800
+ 2.59005e-06 0.000 2.59200e-06 0.000 2.59205e-06 1.800 2.59300e-06 1.800 2.59305e-06 0.000 2.59500e-06 0.000
+ 2.59505e-06 1.800 2.59600e-06 1.800 2.59605e-06 0.000 2.59700e-06 0.000 2.59705e-06 1.800 2.59800e-06 1.800
+ 2.59805e-06 0.000 2.60200e-06 0.000 2.60205e-06 1.800 2.60600e-06 1.800 2.60605e-06 0.000 2.60800e-06 0.000
+ 2.60805e-06 1.800 2.60900e-06 1.800 2.60905e-06 0.000 2.61100e-06 0.000 2.61105e-06 1.800 2.61300e-06 1.800
+ 2.61305e-06 0.000 2.61400e-06 0.000 2.61405e-06 1.800 2.61500e-06 1.800 2.61505e-06 0.000 2.61800e-06 0.000
+ 2.61805e-06 1.800 2.61900e-06 1.800 2.61905e-06 0.000 2.62000e-06 0.000 2.62005e-06 1.800 2.62200e-06 1.800
+ 2.62205e-06 0.000 2.62300e-06 0.000 2.62305e-06 1.800 2.62600e-06 1.800 2.62605e-06 0.000 2.62800e-06 0.000
+ 2.62805e-06 1.800 2.62900e-06 1.800 2.62905e-06 0.000 2.63200e-06 0.000 2.63205e-06 1.800 2.63400e-06 1.800
+ 2.63405e-06 0.000 2.63500e-06 0.000 2.63505e-06 1.800 2.63600e-06 1.800 2.63605e-06 0.000 2.63700e-06 0.000
+ 2.63705e-06 1.800 2.64100e-06 1.800 2.64105e-06 0.000 2.64200e-06 0.000 2.64205e-06 1.800 2.64400e-06 1.800
+ 2.64405e-06 0.000 2.64600e-06 0.000 2.64605e-06 1.800 2.64700e-06 1.800 2.64705e-06 0.000 2.65200e-06 0.000
+ 2.65205e-06 1.800 2.65300e-06 1.800 2.65305e-06 0.000 2.65400e-06 0.000 2.65405e-06 1.800 2.65600e-06 1.800
+ 2.65605e-06 0.000 2.65800e-06 0.000 2.65805e-06 1.800 2.66000e-06 1.800 2.66005e-06 0.000 2.66100e-06 0.000
+ 2.66105e-06 1.800 2.66200e-06 1.800 2.66205e-06 0.000 2.66500e-06 0.000 2.66505e-06 1.800 2.66600e-06 1.800
+ 2.66605e-06 0.000 2.66700e-06 0.000 2.66705e-06 1.800 2.66800e-06 1.800 2.66805e-06 0.000 2.66900e-06 0.000
+ 2.66905e-06 1.800 2.67000e-06 1.800 2.67005e-06 0.000 2.67200e-06 0.000 2.67205e-06 1.800 2.67300e-06 1.800
+ 2.67305e-06 0.000 2.67400e-06 0.000 2.67405e-06 1.800 2.67500e-06 1.800 2.67505e-06 0.000 2.67700e-06 0.000
+ 2.67705e-06 1.800 2.67900e-06 1.800 2.67905e-06 0.000 2.68000e-06 0.000 2.68005e-06 1.800 2.68200e-06 1.800
+ 2.68205e-06 0.000 2.68300e-06 0.000 2.68305e-06 1.800 2.68500e-06 1.800 2.68505e-06 0.000 2.68600e-06 0.000
+ 2.68605e-06 1.800 2.68700e-06 1.800 2.68705e-06 0.000 2.68900e-06 0.000 2.68905e-06 1.800 2.69000e-06 1.800
+ 2.69005e-06 0.000 2.69400e-06 0.000 2.69405e-06 1.800 2.69800e-06 1.800 2.69805e-06 0.000 2.70000e-06 0.000
+ 2.70005e-06 1.800 2.70100e-06 1.800 2.70105e-06 0.000 2.70400e-06 0.000 2.70405e-06 1.800 2.70500e-06 1.800
+ 2.70505e-06 0.000 2.70800e-06 0.000 2.70805e-06 1.800 2.70900e-06 1.800 2.70905e-06 0.000 2.71200e-06 0.000
+ 2.71205e-06 1.800 2.71400e-06 1.800 2.71405e-06 0.000 2.71600e-06 0.000 2.71605e-06 1.800 2.71900e-06 1.800
+ 2.71905e-06 0.000 2.72100e-06 0.000 2.72105e-06 1.800 2.72500e-06 1.800 2.72505e-06 0.000 2.72600e-06 0.000
+ 2.72605e-06 1.800 2.72700e-06 1.800 2.72705e-06 0.000 2.73300e-06 0.000 2.73305e-06 1.800 2.73400e-06 1.800
+ 2.73405e-06 0.000 2.73600e-06 0.000 2.73605e-06 1.800 2.73900e-06 1.800 2.73905e-06 0.000 2.74000e-06 0.000
+ 2.74005e-06 1.800 2.74100e-06 1.800 2.74105e-06 0.000 2.74300e-06 0.000 2.74305e-06 1.800 2.74400e-06 1.800
+ 2.74405e-06 0.000 2.74700e-06 0.000 2.74705e-06 1.800 2.74900e-06 1.800 2.74905e-06 0.000 2.75100e-06 0.000
+ 2.75105e-06 1.800 2.75200e-06 1.800 2.75205e-06 0.000 2.75300e-06 0.000 2.75305e-06 1.800 2.75400e-06 1.800
+ 2.75405e-06 0.000 2.75500e-06 0.000 2.75505e-06 1.800 2.75600e-06 1.800 2.75605e-06 0.000 2.75700e-06 0.000
+ 2.75705e-06 1.800 2.75800e-06 1.800 2.75805e-06 0.000 2.75900e-06 0.000 2.75905e-06 1.800 2.76100e-06 1.800
+ 2.76105e-06 0.000 2.76400e-06 0.000 2.76405e-06 1.800 2.76600e-06 1.800 2.76605e-06 0.000 2.76800e-06 0.000
+ 2.76805e-06 1.800 2.76900e-06 1.800 2.76905e-06 0.000 2.77400e-06 0.000 2.77405e-06 1.800 2.77700e-06 1.800
+ 2.77705e-06 0.000 2.77800e-06 0.000 2.77805e-06 1.800 2.77900e-06 1.800 2.77905e-06 0.000 2.78100e-06 0.000
+ 2.78105e-06 1.800 2.78200e-06 1.800 2.78205e-06 0.000 2.78300e-06 0.000 2.78305e-06 1.800 2.78500e-06 1.800
+ 2.78505e-06 0.000 2.78900e-06 0.000 2.78905e-06 1.800 2.79100e-06 1.800 2.79105e-06 0.000 2.79400e-06 0.000
+ 2.79405e-06 1.800 2.79500e-06 1.800 2.79505e-06 0.000 2.79700e-06 0.000 2.79705e-06 1.800 2.79800e-06 1.800
+ 2.79805e-06 0.000 2.79900e-06 0.000 2.79905e-06 1.800 2.80300e-06 1.800 2.80305e-06 0.000 2.80500e-06 0.000
+ 2.80505e-06 1.800 2.80700e-06 1.800 2.80705e-06 0.000 2.80800e-06 0.000 2.80805e-06 1.800 2.80900e-06 1.800
+ 2.80905e-06 0.000 2.81100e-06 0.000 2.81105e-06 1.800 2.81200e-06 1.800 2.81205e-06 0.000 2.81300e-06 0.000
+ 2.81305e-06 1.800 2.81400e-06 1.800 2.81405e-06 0.000 2.81600e-06 0.000 2.81605e-06 1.800 2.81700e-06 1.800
+ 2.81705e-06 0.000 2.82300e-06 0.000 2.82305e-06 1.800 2.82700e-06 1.800 2.82705e-06 0.000 2.82800e-06 0.000
+ 2.82805e-06 1.800 2.83200e-06 1.800 2.83205e-06 0.000 2.83300e-06 0.000 2.83305e-06 1.800 2.83400e-06 1.800
+ 2.83405e-06 0.000 2.83500e-06 0.000 2.83505e-06 1.800 2.83900e-06 1.800 2.83905e-06 0.000 2.84400e-06 0.000
+ 2.84405e-06 1.800 2.84500e-06 1.800 2.84505e-06 0.000 2.84900e-06 0.000 2.84905e-06 1.800 2.85100e-06 1.800
+ 2.85105e-06 0.000 2.85200e-06 0.000 2.85205e-06 1.800 2.85300e-06 1.800 2.85305e-06 0.000 2.85400e-06 0.000
+ 2.85405e-06 1.800 2.85500e-06 1.800 2.85505e-06 0.000 2.85700e-06 0.000 2.85705e-06 1.800 2.85800e-06 1.800
+ 2.85805e-06 0.000 2.86000e-06 0.000 2.86005e-06 1.800 2.86100e-06 1.800 2.86105e-06 0.000 2.86400e-06 0.000
+ 2.86405e-06 1.800 2.86600e-06 1.800 2.86605e-06 0.000 2.86700e-06 0.000 2.86705e-06 1.800 2.86800e-06 1.800
+ 2.86805e-06 0.000 2.87300e-06 0.000 2.87305e-06 1.800 2.87400e-06 1.800 2.87405e-06 0.000 2.87600e-06 0.000
+ 2.87605e-06 1.800 2.87700e-06 1.800 2.87705e-06 0.000 2.87800e-06 0.000 2.87805e-06 1.800 2.87900e-06 1.800
+ 2.87905e-06 0.000 2.88200e-06 0.000 2.88205e-06 1.800 2.88500e-06 1.800 2.88505e-06 0.000 2.88800e-06 0.000
+ 2.88805e-06 1.800 2.88900e-06 1.800 2.88905e-06 0.000 2.89000e-06 0.000 2.89005e-06 1.800 2.89200e-06 1.800
+ 2.89205e-06 0.000 2.89300e-06 0.000 2.89305e-06 1.800 2.89400e-06 1.800 2.89405e-06 0.000 2.89600e-06 0.000
+ 2.89605e-06 1.800 2.89800e-06 1.800 2.89805e-06 0.000 2.89900e-06 0.000 2.89905e-06 1.800 2.90000e-06 1.800
+ 2.90005e-06 0.000 2.90200e-06 0.000 2.90205e-06 1.800 2.90600e-06 1.800 2.90605e-06 0.000 2.90900e-06 0.000
+ 2.90905e-06 1.800 2.91100e-06 1.800 2.91105e-06 0.000 2.91600e-06 0.000 2.91605e-06 1.800 2.91700e-06 1.800
+ 2.91705e-06 0.000 2.91800e-06 0.000 2.91805e-06 1.800 2.92000e-06 1.800 2.92005e-06 0.000 2.92300e-06 0.000
+ 2.92305e-06 1.800 2.92400e-06 1.800 2.92405e-06 0.000 2.92500e-06 0.000 2.92505e-06 1.800 2.92700e-06 1.800
+ 2.92705e-06 0.000 2.92800e-06 0.000 2.92805e-06 1.800 2.93100e-06 1.800 2.93105e-06 0.000 2.93400e-06 0.000
+ 2.93405e-06 1.800 2.93500e-06 1.800 2.93505e-06 0.000 2.93600e-06 0.000 2.93605e-06 1.800 2.93700e-06 1.800
+ 2.93705e-06 0.000 2.93800e-06 0.000 2.93805e-06 1.800 2.94000e-06 1.800 2.94005e-06 0.000 2.94300e-06 0.000
+ 2.94305e-06 1.800 2.94500e-06 1.800 2.94505e-06 0.000 2.95200e-06 0.000 2.95205e-06 1.800 2.95300e-06 1.800
+ 2.95305e-06 0.000 2.95400e-06 0.000 2.95405e-06 1.800 2.95600e-06 1.800 2.95605e-06 0.000 2.96300e-06 0.000
+ 2.96305e-06 1.800 2.96400e-06 1.800 2.96405e-06 0.000 2.96500e-06 0.000 2.96505e-06 1.800 2.96900e-06 1.800
+ 2.96905e-06 0.000 2.97000e-06 0.000 2.97005e-06 1.800 2.97200e-06 1.800 2.97205e-06 0.000 2.97600e-06 0.000
+ 2.97605e-06 1.800 2.97700e-06 1.800 2.97705e-06 0.000 2.98100e-06 0.000 2.98105e-06 1.800 2.98400e-06 1.800
+ 2.98405e-06 0.000 2.98600e-06 0.000 2.98605e-06 1.800 2.98800e-06 1.800 2.98805e-06 0.000 2.98900e-06 0.000
+ 2.98905e-06 1.800 2.99000e-06 1.800 2.99005e-06 0.000 2.99200e-06 0.000 2.99205e-06 1.800 2.99600e-06 1.800
+ 2.99605e-06 0.000 2.99700e-06 0.000 2.99705e-06 1.800 2.99800e-06 1.800 2.99805e-06 0.000 2.99900e-06 0.000
+ 2.99905e-06 1.800 3.00000e-06 1.800 3.00005e-06 0.000 3.00100e-06 0.000 3.00105e-06 1.800 3.00200e-06 1.800
+ 3.00205e-06 0.000 3.00300e-06 0.000 3.00305e-06 1.800 3.00800e-06 1.800 3.00805e-06 0.000 3.01100e-06 0.000
+ 3.01105e-06 1.800 3.01300e-06 1.800 3.01305e-06 0.000 3.01400e-06 0.000 3.01405e-06 1.800 3.01500e-06 1.800
+ 3.01505e-06 0.000 3.01700e-06 0.000 3.01705e-06 1.800 3.01900e-06 1.800 3.01905e-06 0.000 3.02000e-06 0.000
+ 3.02005e-06 1.800 3.02100e-06 1.800 3.02105e-06 0.000 3.02200e-06 0.000 3.02205e-06 1.800 3.02300e-06 1.800
+ 3.02305e-06 0.000 3.02400e-06 0.000 3.02405e-06 1.800 3.02600e-06 1.800 3.02605e-06 0.000 3.02800e-06 0.000
+ 3.02805e-06 1.800 3.02900e-06 1.800 3.02905e-06 0.000 3.03000e-06 0.000 3.03005e-06 1.800 3.03100e-06 1.800
+ 3.03105e-06 0.000 3.03500e-06 0.000 3.03505e-06 1.800 3.03600e-06 1.800 3.03605e-06 0.000 3.03700e-06 0.000
+ 3.03705e-06 1.800 3.03800e-06 1.800 3.03805e-06 0.000 3.03900e-06 0.000 3.03905e-06 1.800 3.04000e-06 1.800
+ 3.04005e-06 0.000 3.04100e-06 0.000 3.04105e-06 1.800 3.04200e-06 1.800 3.04205e-06 0.000 3.04400e-06 0.000
+ 3.04405e-06 1.800 3.04500e-06 1.800 3.04505e-06 0.000 3.04700e-06 0.000 3.04705e-06 1.800 3.05000e-06 1.800
+ 3.05005e-06 0.000 3.05100e-06 0.000 3.05105e-06 1.800 3.05200e-06 1.800 3.05205e-06 0.000 3.05300e-06 0.000
+ 3.05305e-06 1.800 3.05400e-06 1.800 3.05405e-06 0.000 3.05500e-06 0.000 3.05505e-06 1.800 3.05800e-06 1.800
+ 3.05805e-06 0.000 3.05900e-06 0.000 3.05905e-06 1.800 3.06100e-06 1.800 3.06105e-06 0.000 3.06200e-06 0.000
+ 3.06205e-06 1.800 3.06300e-06 1.800 3.06305e-06 0.000 3.06800e-06 0.000 3.06805e-06 1.800 3.06900e-06 1.800
+ 3.06905e-06 0.000 3.07400e-06 0.000 3.07405e-06 1.800 3.07500e-06 1.800 3.07505e-06 0.000 3.07600e-06 0.000
+ 3.07605e-06 1.800 3.07800e-06 1.800 3.07805e-06 0.000 3.07900e-06 0.000 3.07905e-06 1.800 3.08000e-06 1.800
+ 3.08005e-06 0.000 3.08300e-06 0.000 3.08305e-06 1.800 3.08500e-06 1.800 3.08505e-06 0.000 3.08700e-06 0.000
+ 3.08705e-06 1.800 3.08800e-06 1.800 3.08805e-06 0.000 3.09000e-06 0.000 3.09005e-06 1.800 3.09100e-06 1.800
+ 3.09105e-06 0.000 3.09200e-06 0.000 3.09205e-06 1.800 3.09500e-06 1.800 3.09505e-06 0.000 3.09600e-06 0.000
+ 3.09605e-06 1.800 3.09700e-06 1.800 3.09705e-06 0.000 3.09800e-06 0.000 3.09805e-06 1.800 3.09900e-06 1.800
+ 3.09905e-06 0.000 3.10200e-06 0.000 3.10205e-06 1.800 3.10300e-06 1.800 3.10305e-06 0.000 3.10400e-06 0.000
+ 3.10405e-06 1.800 3.10500e-06 1.800 3.10505e-06 0.000 3.10600e-06 0.000 3.10605e-06 1.800 3.11100e-06 1.800
+ 3.11105e-06 0.000 3.11200e-06 0.000 3.11205e-06 1.800 3.11400e-06 1.800 3.11405e-06 0.000 3.11600e-06 0.000
+ 3.11605e-06 1.800 3.11700e-06 1.800 3.11705e-06 0.000 3.11900e-06 0.000 3.11905e-06 1.800 3.12100e-06 1.800
+ 3.12105e-06 0.000 3.12500e-06 0.000 3.12505e-06 1.800 3.12900e-06 1.800 3.12905e-06 0.000 3.13000e-06 0.000
+ 3.13005e-06 1.800 3.13300e-06 1.800 3.13305e-06 0.000 3.13600e-06 0.000 3.13605e-06 1.800 3.13900e-06 1.800
+ 3.13905e-06 0.000 3.14000e-06 0.000 3.14005e-06 1.800 3.14100e-06 1.800 3.14105e-06 0.000 3.14300e-06 0.000
+ 3.14305e-06 1.800 3.14400e-06 1.800 3.14405e-06 0.000 3.14500e-06 0.000 3.14505e-06 1.800 3.14800e-06 1.800
+ 3.14805e-06 0.000 3.14900e-06 0.000 3.14905e-06 1.800 3.15000e-06 1.800 3.15005e-06 0.000 3.15300e-06 0.000
+ 3.15305e-06 1.800 3.15400e-06 1.800 3.15405e-06 0.000 3.15600e-06 0.000 3.15605e-06 1.800 3.15800e-06 1.800
+ 3.15805e-06 0.000 3.15900e-06 0.000 3.15905e-06 1.800 3.16000e-06 1.800 3.16005e-06 0.000 3.16200e-06 0.000
+ 3.16205e-06 1.800 3.16500e-06 1.800 3.16505e-06 0.000 3.16700e-06 0.000 3.16705e-06 1.800 3.16900e-06 1.800
+ 3.16905e-06 0.000 3.17000e-06 0.000 3.17005e-06 1.800 3.17300e-06 1.800 3.17305e-06 0.000 3.17400e-06 0.000
+ 3.17405e-06 1.800 3.17500e-06 1.800 3.17505e-06 0.000 3.17700e-06 0.000 3.17705e-06 1.800 3.17900e-06 1.800
+ 3.17905e-06 0.000 3.18100e-06 0.000 3.18105e-06 1.800 3.18200e-06 1.800 3.18205e-06 0.000 3.18300e-06 0.000
+ 3.18305e-06 1.800 3.18500e-06 1.800 3.18505e-06 0.000 3.18800e-06 0.000 3.18805e-06 1.800 3.18900e-06 1.800
+ 3.18905e-06 0.000 3.19100e-06 0.000 3.19105e-06 1.800 3.19200e-06 1.800 3.19205e-06 0.000 3.19300e-06 0.000
+ 3.19305e-06 1.800 3.19400e-06 1.800 3.19405e-06 0.000 3.19500e-06 0.000 3.19505e-06 1.800 3.19600e-06 1.800
+ 3.19605e-06 0.000 3.20200e-06 0.000 3.20205e-06 1.800 3.20300e-06 1.800 3.20305e-06 0.000 3.20400e-06 0.000
+ 3.20405e-06 1.800 3.20700e-06 1.800 3.20705e-06 0.000 3.20800e-06 0.000 3.20805e-06 1.800 3.21200e-06 1.800
+ 3.21205e-06 0.000 3.21300e-06 0.000 3.21305e-06 1.800 3.21400e-06 1.800 3.21405e-06 0.000 3.21500e-06 0.000
+ 3.21505e-06 1.800 3.21700e-06 1.800 3.21705e-06 0.000 3.21800e-06 0.000 3.21805e-06 1.800 3.22100e-06 1.800
+ 3.22105e-06 0.000 3.22200e-06 0.000 3.22205e-06 1.800 3.22300e-06 1.800 3.22305e-06 0.000 3.22600e-06 0.000
+ 3.22605e-06 1.800 3.22700e-06 1.800 3.22705e-06 0.000 3.22800e-06 0.000 3.22805e-06 1.800 3.22900e-06 1.800
+ 3.22905e-06 0.000 3.23100e-06 0.000 3.23105e-06 1.800 3.23200e-06 1.800 3.23205e-06 0.000 3.23300e-06 0.000
+ 3.23305e-06 1.800 3.23500e-06 1.800 3.23505e-06 0.000 3.23800e-06 0.000 3.23805e-06 1.800 3.23900e-06 1.800
+ 3.23905e-06 0.000 3.24200e-06 0.000 3.24205e-06 1.800 3.24500e-06 1.800 3.24505e-06 0.000 3.24600e-06 0.000
+ 3.24605e-06 1.800 3.24700e-06 1.800 3.24705e-06 0.000 3.24900e-06 0.000 3.24905e-06 1.800 3.25000e-06 1.800
+ 3.25005e-06 0.000 3.25100e-06 0.000 3.25105e-06 1.800 3.25200e-06 1.800 3.25205e-06 0.000 3.25300e-06 0.000
+ 3.25305e-06 1.800 3.25600e-06 1.800 3.25605e-06 0.000 3.25700e-06 0.000 3.25705e-06 1.800 3.25800e-06 1.800
+ 3.25805e-06 0.000 3.26100e-06 0.000 3.26105e-06 1.800 3.26300e-06 1.800 3.26305e-06 0.000 3.26500e-06 0.000
+ 3.26505e-06 1.800 3.27000e-06 1.800 3.27005e-06 0.000 3.27100e-06 0.000 3.27105e-06 1.800 3.27200e-06 1.800
+ 3.27205e-06 0.000 3.27400e-06 0.000 3.27405e-06 1.800 3.27500e-06 1.800 3.27505e-06 0.000 3.27600e-06 0.000
+ 3.27605e-06 1.800 3.27800e-06 1.800 3.27805e-06 0.000 3.27900e-06 0.000 3.27905e-06 1.800 3.28300e-06 1.800
+ 3.28305e-06 0.000 3.28600e-06 0.000 3.28605e-06 1.800 3.28900e-06 1.800 3.28905e-06 0.000 3.29000e-06 0.000
+ 3.29005e-06 1.800 3.29100e-06 1.800 3.29105e-06 0.000 3.29200e-06 0.000 3.29205e-06 1.800 3.29300e-06 1.800
+ 3.29305e-06 0.000 3.29400e-06 0.000 3.29405e-06 1.800 3.29700e-06 1.800 3.29705e-06 0.000 3.29900e-06 0.000
+ 3.29905e-06 1.800 3.30100e-06 1.800 3.30105e-06 0.000 3.30200e-06 0.000 3.30205e-06 1.800 3.30700e-06 1.800
+ 3.30705e-06 0.000 3.30800e-06 0.000 3.30805e-06 1.800 3.30900e-06 1.800 3.30905e-06 0.000 3.31100e-06 0.000
+ 3.31105e-06 1.800 3.31600e-06 1.800 3.31605e-06 0.000 3.31700e-06 0.000 3.31705e-06 1.800 3.31900e-06 1.800
+ 3.31905e-06 0.000 3.32000e-06 0.000 3.32005e-06 1.800 3.32300e-06 1.800 3.32305e-06 0.000 3.32400e-06 0.000
+ 3.32405e-06 1.800 3.32500e-06 1.800 3.32505e-06 0.000 3.32800e-06 0.000 3.32805e-06 1.800 3.32900e-06 1.800
+ 3.32905e-06 0.000 3.33100e-06 0.000 3.33105e-06 1.800 3.33400e-06 1.800 3.33405e-06 0.000 3.34000e-06 0.000
+ 3.34005e-06 1.800 3.34200e-06 1.800 3.34205e-06 0.000 3.34600e-06 0.000 3.34605e-06 1.800 3.34800e-06 1.800
+ 3.34805e-06 0.000 3.34900e-06 0.000 3.34905e-06 1.800 3.35000e-06 1.800 3.35005e-06 0.000 3.35200e-06 0.000
+ 3.35205e-06 1.800 3.35400e-06 1.800 3.35405e-06 0.000 3.35500e-06 0.000 3.35505e-06 1.800 3.35600e-06 1.800
+ 3.35605e-06 0.000 3.35800e-06 0.000 3.35805e-06 1.800 3.36100e-06 1.800 3.36105e-06 0.000 3.36400e-06 0.000
+ 3.36405e-06 1.800 3.36500e-06 1.800 3.36505e-06 0.000 3.36900e-06 0.000 3.36905e-06 1.800 3.37100e-06 1.800
+ 3.37105e-06 0.000 3.37200e-06 0.000 3.37205e-06 1.800 3.37500e-06 1.800 3.37505e-06 0.000 3.37900e-06 0.000
+ 3.37905e-06 1.800 3.38200e-06 1.800 3.38205e-06 0.000 3.38600e-06 0.000 3.38605e-06 1.800 3.38700e-06 1.800
+ 3.38705e-06 0.000 3.39000e-06 0.000 3.39005e-06 1.800 3.39100e-06 1.800 3.39105e-06 0.000 3.39200e-06 0.000
+ 3.39205e-06 1.800 3.39900e-06 1.800 3.39905e-06 0.000 3.40000e-06 0.000 3.40005e-06 1.800 3.40100e-06 1.800
+ 3.40105e-06 0.000 3.40400e-06 0.000 3.40405e-06 1.800 3.40500e-06 1.800 3.40505e-06 0.000 3.40800e-06 0.000
+ 3.40805e-06 1.800 3.41000e-06 1.800 3.41005e-06 0.000 3.41200e-06 0.000 3.41205e-06 1.800 3.41400e-06 1.800
+ 3.41405e-06 0.000 3.41800e-06 0.000 3.41805e-06 1.800 3.42100e-06 1.800 3.42105e-06 0.000 3.42300e-06 0.000
+ 3.42305e-06 1.800 3.43000e-06 1.800 3.43005e-06 0.000 3.43100e-06 0.000 3.43105e-06 1.800 3.43700e-06 1.800
+ 3.43705e-06 0.000 3.43800e-06 0.000 3.43805e-06 1.800 3.43900e-06 1.800 3.43905e-06 0.000 3.44000e-06 0.000
+ 3.44005e-06 1.800 3.44100e-06 1.800 3.44105e-06 0.000 3.44300e-06 0.000 3.44305e-06 1.800 3.44600e-06 1.800
+ 3.44605e-06 0.000 3.44900e-06 0.000 3.44905e-06 1.800 3.45000e-06 1.800 3.45005e-06 0.000 3.45100e-06 0.000
+ 3.45105e-06 1.800 3.45200e-06 1.800 3.45205e-06 0.000 3.45600e-06 0.000 3.45605e-06 1.800 3.45700e-06 1.800
+ 3.45705e-06 0.000 3.45800e-06 0.000 3.45805e-06 1.800 3.45900e-06 1.800 3.45905e-06 0.000 3.46000e-06 0.000
+ 3.46005e-06 1.800 3.46300e-06 1.800 3.46305e-06 0.000 3.46500e-06 0.000 3.46505e-06 1.800 3.46600e-06 1.800
+ 3.46605e-06 0.000 3.46700e-06 0.000 3.46705e-06 1.800 3.46800e-06 1.800 3.46805e-06 0.000 3.47100e-06 0.000
+ 3.47105e-06 1.800 3.47200e-06 1.800 3.47205e-06 0.000 3.47400e-06 0.000 3.47405e-06 1.800 3.47500e-06 1.800
+ 3.47505e-06 0.000 3.47600e-06 0.000 3.47605e-06 1.800 3.47700e-06 1.800 3.47705e-06 0.000 3.47800e-06 0.000
+ 3.47805e-06 1.800 3.48100e-06 1.800 3.48105e-06 0.000 3.48400e-06 0.000 3.48405e-06 1.800 3.48600e-06 1.800
+ 3.48605e-06 0.000 3.48700e-06 0.000 3.48705e-06 1.800 3.49400e-06 1.800 3.49405e-06 0.000 3.49500e-06 0.000
+ 3.49505e-06 1.800 3.49600e-06 1.800 3.49605e-06 0.000 3.49700e-06 0.000 3.49705e-06 1.800 3.50000e-06 1.800
+ 3.50005e-06 0.000 3.50200e-06 0.000 3.50205e-06 1.800 3.50300e-06 1.800 3.50305e-06 0.000 3.50400e-06 0.000
+ 3.50405e-06 1.800 3.51100e-06 1.800 3.51105e-06 0.000 3.51200e-06 0.000 3.51205e-06 1.800 3.51500e-06 1.800
+ 3.51505e-06 0.000 3.51600e-06 0.000 3.51605e-06 1.800 3.51700e-06 1.800 3.51705e-06 0.000 3.52000e-06 0.000
+ 3.52005e-06 1.800 3.52100e-06 1.800 3.52105e-06 0.000 3.52200e-06 0.000 3.52205e-06 1.800 3.52400e-06 1.800
+ 3.52405e-06 0.000 3.52600e-06 0.000 3.52605e-06 1.800 3.52800e-06 1.800 3.52805e-06 0.000 3.53000e-06 0.000
+ 3.53005e-06 1.800 3.53200e-06 1.800 3.53205e-06 0.000 3.53300e-06 0.000 3.53305e-06 1.800 3.53500e-06 1.800
+ 3.53505e-06 0.000 3.53600e-06 0.000 3.53605e-06 1.800 3.53800e-06 1.800 3.53805e-06 0.000 3.54100e-06 0.000
+ 3.54105e-06 1.800 3.54300e-06 1.800 3.54305e-06 0.000 3.54500e-06 0.000 3.54505e-06 1.800 3.54800e-06 1.800
+ 3.54805e-06 0.000 3.54900e-06 0.000 3.54905e-06 1.800 3.55100e-06 1.800 3.55105e-06 0.000 3.55200e-06 0.000
+ 3.55205e-06 1.800 3.55300e-06 1.800 3.55305e-06 0.000 3.55400e-06 0.000 3.55405e-06 1.800 3.55500e-06 1.800
+ 3.55505e-06 0.000 3.55800e-06 0.000 3.55805e-06 1.800 3.55900e-06 1.800 3.55905e-06 0.000 3.56000e-06 0.000
+ 3.56005e-06 1.800 3.56100e-06 1.800 3.56105e-06 0.000 3.56400e-06 0.000 3.56405e-06 1.800 3.56600e-06 1.800
+ 3.56605e-06 0.000 3.56700e-06 0.000 3.56705e-06 1.800 3.57000e-06 1.800 3.57005e-06 0.000 3.57300e-06 0.000
+ 3.57305e-06 1.800 3.57800e-06 1.800 3.57805e-06 0.000 3.57900e-06 0.000 3.57905e-06 1.800 3.58100e-06 1.800
+ 3.58105e-06 0.000 3.58200e-06 0.000 3.58205e-06 1.800 3.58500e-06 1.800 3.58505e-06 0.000 3.58700e-06 0.000
+ 3.58705e-06 1.800 3.58900e-06 1.800 3.58905e-06 0.000 3.59000e-06 0.000 3.59005e-06 1.800 3.59100e-06 1.800
+ 3.59105e-06 0.000 3.59200e-06 0.000 3.59205e-06 1.800 3.59500e-06 1.800 3.59505e-06 0.000 3.59700e-06 0.000
+ 3.59705e-06 1.800 3.60200e-06 1.800 3.60205e-06 0.000 3.60400e-06 0.000 3.60405e-06 1.800 3.60500e-06 1.800
+ 3.60505e-06 0.000 3.60600e-06 0.000 3.60605e-06 1.800 3.60900e-06 1.800 3.60905e-06 0.000 3.61100e-06 0.000
+ 3.61105e-06 1.800 3.61200e-06 1.800 3.61205e-06 0.000 3.61400e-06 0.000 3.61405e-06 1.800 3.61600e-06 1.800
+ 3.61605e-06 0.000 3.61700e-06 0.000 3.61705e-06 1.800 3.61900e-06 1.800 3.61905e-06 0.000 3.62000e-06 0.000
+ 3.62005e-06 1.800 3.62100e-06 1.800 3.62105e-06 0.000 3.62300e-06 0.000 3.62305e-06 1.800 3.62400e-06 1.800
+ 3.62405e-06 0.000 3.62500e-06 0.000 3.62505e-06 1.800 3.62600e-06 1.800 3.62605e-06 0.000 3.62700e-06 0.000
+ 3.62705e-06 1.800 3.63000e-06 1.800 3.63005e-06 0.000 3.63200e-06 0.000 3.63205e-06 1.800 3.63400e-06 1.800
+ 3.63405e-06 0.000 3.63500e-06 0.000 3.63505e-06 1.800 3.63700e-06 1.800 3.63705e-06 0.000 3.63900e-06 0.000
+ 3.63905e-06 1.800 3.64100e-06 1.800 3.64105e-06 0.000 3.64300e-06 0.000 3.64305e-06 1.800 3.64400e-06 1.800
+ 3.64405e-06 0.000 3.64700e-06 0.000 3.64705e-06 1.800 3.64800e-06 1.800 3.64805e-06 0.000 3.64900e-06 0.000
+ 3.64905e-06 1.800 3.65000e-06 1.800 3.65005e-06 0.000 3.65100e-06 0.000 3.65105e-06 1.800 3.65200e-06 1.800
+ 3.65205e-06 0.000 3.65400e-06 0.000 3.65405e-06 1.800 3.65700e-06 1.800 3.65705e-06 0.000 3.65800e-06 0.000
+ 3.65805e-06 1.800 3.66000e-06 1.800 3.66005e-06 0.000 3.66100e-06 0.000 3.66105e-06 1.800 3.66300e-06 1.800
+ 3.66305e-06 0.000 3.66700e-06 0.000 3.66705e-06 1.800 3.66800e-06 1.800 3.66805e-06 0.000 3.67100e-06 0.000
+ 3.67105e-06 1.800 3.67500e-06 1.800 3.67505e-06 0.000 3.67700e-06 0.000 3.67705e-06 1.800 3.68000e-06 1.800
+ 3.68005e-06 0.000 3.68300e-06 0.000 3.68305e-06 1.800 3.68700e-06 1.800 3.68705e-06 0.000 3.68800e-06 0.000
+ 3.68805e-06 1.800 3.69100e-06 1.800 3.69105e-06 0.000 3.69400e-06 0.000 3.69405e-06 1.800 3.69900e-06 1.800
+ 3.69905e-06 0.000 3.70000e-06 0.000 3.70005e-06 1.800 3.70100e-06 1.800 3.70105e-06 0.000 3.70200e-06 0.000
+ 3.70205e-06 1.800 3.70300e-06 1.800 3.70305e-06 0.000 3.70400e-06 0.000 3.70405e-06 1.800 3.71000e-06 1.800
+ 3.71005e-06 0.000 3.71100e-06 0.000 3.71105e-06 1.800 3.71300e-06 1.800 3.71305e-06 0.000 3.71400e-06 0.000
+ 3.71405e-06 1.800 3.71800e-06 1.800 3.71805e-06 0.000 3.71900e-06 0.000 3.71905e-06 1.800 3.72300e-06 1.800
+ 3.72305e-06 0.000 3.72600e-06 0.000 3.72605e-06 1.800 3.73100e-06 1.800 3.73105e-06 0.000 3.73200e-06 0.000
+ 3.73205e-06 1.800 3.73300e-06 1.800 3.73305e-06 0.000 3.73700e-06 0.000 3.73705e-06 1.800 3.74000e-06 1.800
+ 3.74005e-06 0.000 3.74300e-06 0.000 3.74305e-06 1.800 3.74600e-06 1.800 3.74605e-06 0.000 3.74700e-06 0.000
+ 3.74705e-06 1.800 3.74800e-06 1.800 3.74805e-06 0.000 3.74900e-06 0.000 3.74905e-06 1.800 3.75000e-06 1.800
+ 3.75005e-06 0.000 3.75100e-06 0.000 3.75105e-06 1.800 3.75200e-06 1.800 3.75205e-06 0.000 3.75300e-06 0.000
+ 3.75305e-06 1.800 3.75400e-06 1.800 3.75405e-06 0.000 3.76400e-06 0.000 3.76405e-06 1.800 3.76500e-06 1.800
+ 3.76505e-06 0.000 3.76600e-06 0.000 3.76605e-06 1.800 3.76800e-06 1.800 3.76805e-06 0.000 3.76900e-06 0.000
+ 3.76905e-06 1.800 3.77200e-06 1.800 3.77205e-06 0.000 3.77500e-06 0.000 3.77505e-06 1.800 3.78100e-06 1.800
+ 3.78105e-06 0.000 3.78400e-06 0.000 3.78405e-06 1.800 3.78600e-06 1.800 3.78605e-06 0.000 3.78800e-06 0.000
+ 3.78805e-06 1.800 3.78900e-06 1.800 3.78905e-06 0.000 3.79100e-06 0.000 3.79105e-06 1.800 3.79300e-06 1.800
+ 3.79305e-06 0.000 3.79500e-06 0.000 3.79505e-06 1.800 3.79600e-06 1.800 3.79605e-06 0.000 3.79900e-06 0.000
+ 3.79905e-06 1.800 3.80000e-06 1.800 3.80005e-06 0.000 3.80500e-06 0.000 3.80505e-06 1.800 3.80700e-06 1.800
+ 3.80705e-06 0.000 3.80800e-06 0.000 3.80805e-06 1.800 3.80900e-06 1.800 3.80905e-06 0.000 3.81200e-06 0.000
+ 3.81205e-06 1.800 3.81300e-06 1.800 3.81305e-06 0.000 3.81600e-06 0.000 3.81605e-06 1.800 3.81700e-06 1.800
+ 3.81705e-06 0.000 3.81900e-06 0.000 3.81905e-06 1.800 3.82200e-06 1.800 3.82205e-06 0.000 3.82300e-06 0.000
+ 3.82305e-06 1.800 3.82500e-06 1.800 3.82505e-06 0.000 3.82800e-06 0.000 3.82805e-06 1.800 3.82900e-06 1.800
+ 3.82905e-06 0.000 3.83000e-06 0.000 3.83005e-06 1.800 3.83100e-06 1.800 3.83105e-06 0.000 3.83400e-06 0.000
+ 3.83405e-06 1.800 3.83500e-06 1.800 3.83505e-06 0.000 3.83600e-06 0.000 3.83605e-06 1.800 3.83700e-06 1.800
+ 3.83705e-06 0.000 3.83800e-06 0.000 3.83805e-06 1.800 3.83900e-06 1.800 3.83905e-06 0.000 3.84100e-06 0.000
+ 3.84105e-06 1.800 3.84200e-06 1.800 3.84205e-06 0.000 3.84500e-06 0.000 3.84505e-06 1.800 3.84700e-06 1.800
+ 3.84705e-06 0.000 3.84800e-06 0.000 3.84805e-06 1.800 3.85000e-06 1.800 3.85005e-06 0.000 3.85300e-06 0.000
+ 3.85305e-06 1.800 3.85400e-06 1.800 3.85405e-06 0.000 3.86100e-06 0.000 3.86105e-06 1.800 3.86300e-06 1.800
+ 3.86305e-06 0.000 3.86400e-06 0.000 3.86405e-06 1.800 3.86600e-06 1.800 3.86605e-06 0.000 3.86700e-06 0.000
+ 3.86705e-06 1.800 3.86800e-06 1.800 3.86805e-06 0.000 3.87100e-06 0.000 3.87105e-06 1.800 3.87200e-06 1.800
+ 3.87205e-06 0.000 3.87300e-06 0.000 3.87305e-06 1.800 3.87400e-06 1.800 3.87405e-06 0.000 3.87500e-06 0.000
+ 3.87505e-06 1.800 3.87700e-06 1.800 3.87705e-06 0.000 3.87800e-06 0.000 3.87805e-06 1.800 3.87900e-06 1.800
+ 3.87905e-06 0.000 3.88000e-06 0.000 3.88005e-06 1.800 3.88200e-06 1.800 3.88205e-06 0.000 3.88600e-06 0.000
+ 3.88605e-06 1.800 3.88800e-06 1.800 3.88805e-06 0.000 3.89000e-06 0.000 3.89005e-06 1.800 3.89100e-06 1.800
+ 3.89105e-06 0.000 3.89200e-06 0.000 3.89205e-06 1.800 3.89400e-06 1.800 3.89405e-06 0.000 3.89600e-06 0.000
+ 3.89605e-06 1.800 3.89800e-06 1.800 3.89805e-06 0.000 3.90400e-06 0.000 3.90405e-06 1.800 3.90500e-06 1.800
+ 3.90505e-06 0.000 3.90600e-06 0.000 3.90605e-06 1.800 3.90700e-06 1.800 3.90705e-06 0.000 3.90800e-06 0.000
+ 3.90805e-06 1.800 3.90900e-06 1.800 3.90905e-06 0.000 3.91100e-06 0.000 3.91105e-06 1.800 3.91200e-06 1.800
+ 3.91205e-06 0.000 3.91600e-06 0.000 3.91605e-06 1.800 3.91800e-06 1.800 3.91805e-06 0.000 3.91900e-06 0.000
+ 3.91905e-06 1.800 3.92100e-06 1.800 3.92105e-06 0.000 3.92200e-06 0.000 3.92205e-06 1.800 3.92300e-06 1.800
+ 3.92305e-06 0.000 3.92400e-06 0.000 3.92405e-06 1.800 3.92800e-06 1.800 3.92805e-06 0.000 3.92900e-06 0.000
+ 3.92905e-06 1.800 3.93000e-06 1.800 3.93005e-06 0.000 3.93200e-06 0.000 3.93205e-06 1.800 3.93300e-06 1.800
+ 3.93305e-06 0.000 3.93600e-06 0.000 3.93605e-06 1.800 3.93700e-06 1.800 3.93705e-06 0.000 3.93900e-06 0.000
+ 3.93905e-06 1.800 3.94000e-06 1.800 3.94005e-06 0.000 3.94300e-06 0.000 3.94305e-06 1.800 3.94500e-06 1.800
+ 3.94505e-06 0.000 3.94800e-06 0.000 3.94805e-06 1.800 3.95000e-06 1.800 3.95005e-06 0.000 3.95300e-06 0.000
+ 3.95305e-06 1.800 3.95500e-06 1.800 3.95505e-06 0.000 3.95600e-06 0.000 3.95605e-06 1.800 3.95700e-06 1.800
+ 3.95705e-06 0.000 3.96000e-06 0.000 3.96005e-06 1.800 3.96200e-06 1.800 3.96205e-06 0.000 3.96700e-06 0.000
+ 3.96705e-06 1.800 3.96800e-06 1.800 3.96805e-06 0.000 3.96900e-06 0.000 3.96905e-06 1.800 3.97100e-06 1.800
+ 3.97105e-06 0.000 3.97200e-06 0.000 3.97205e-06 1.800 3.97500e-06 1.800 3.97505e-06 0.000 3.97700e-06 0.000
+ 3.97705e-06 1.800 3.97800e-06 1.800 3.97805e-06 0.000 3.97900e-06 0.000 3.97905e-06 1.800 3.98200e-06 1.800
+ 3.98205e-06 0.000 3.98300e-06 0.000 3.98305e-06 1.800 3.99100e-06 1.800 3.99105e-06 0.000 3.99200e-06 0.000
+ 3.99205e-06 1.800 3.99400e-06 1.800 3.99405e-06 0.000 3.99600e-06 0.000 3.99605e-06 1.800 3.99800e-06 1.800
+ 3.99805e-06 0.000 3.99900e-06 0.000 3.99905e-06 1.800 4.00000e-06 1.800 4.00005e-06 0.000 4.00200e-06 0.000
+ 4.00205e-06 1.800 4.00300e-06 1.800 4.00305e-06 0.000 4.00600e-06 0.000 4.00605e-06 1.800 4.00900e-06 1.800
+ 4.00905e-06 0.000 4.01100e-06 0.000 4.01105e-06 1.800 4.01300e-06 1.800 4.01305e-06 0.000 4.01400e-06 0.000
+ 4.01405e-06 1.800 4.01500e-06 1.800 4.01505e-06 0.000 4.01900e-06 0.000 4.01905e-06 1.800 4.02500e-06 1.800
+ 4.02505e-06 0.000 4.02700e-06 0.000 4.02705e-06 1.800 4.02800e-06 1.800 4.02805e-06 0.000 4.03000e-06 0.000
+ 4.03005e-06 1.800 4.03200e-06 1.800 4.03205e-06 0.000 4.03400e-06 0.000 4.03405e-06 1.800 4.03500e-06 1.800
+ 4.03505e-06 0.000 4.03700e-06 0.000 4.03705e-06 1.800 4.04000e-06 1.800 4.04005e-06 0.000 4.04100e-06 0.000
+ 4.04105e-06 1.800 4.04200e-06 1.800 4.04205e-06 0.000 4.04500e-06 0.000 4.04505e-06 1.800 4.04700e-06 1.800
+ 4.04705e-06 0.000 4.05100e-06 0.000 4.05105e-06 1.800 4.05600e-06 1.800 4.05605e-06 0.000 4.05900e-06 0.000
+ 4.05905e-06 1.800 4.06100e-06 1.800 4.06105e-06 0.000 4.06300e-06 0.000 4.06305e-06 1.800 4.06400e-06 1.800
+ 4.06405e-06 0.000 4.06500e-06 0.000 4.06505e-06 1.800 4.07100e-06 1.800 4.07105e-06 0.000 4.07300e-06 0.000
+ 4.07305e-06 1.800 4.07400e-06 1.800 4.07405e-06 0.000 4.07600e-06 0.000 4.07605e-06 1.800 4.07700e-06 1.800
+ 4.07705e-06 0.000 4.07800e-06 0.000 4.07805e-06 1.800 4.08000e-06 1.800 4.08005e-06 0.000 4.08300e-06 0.000
+ 4.08305e-06 1.800 4.08500e-06 1.800 4.08505e-06 0.000 4.08600e-06 0.000 4.08605e-06 1.800 4.08900e-06 1.800
+ 4.08905e-06 0.000 4.09000e-06 0.000 4.09005e-06 1.800 4.09100e-06 1.800 4.09105e-06 0.000 4.09300e-06 0.000
+ 4.09305e-06 1.800 4.09400e-06 1.800 4.09405e-06 0.000 4.09500e-06 0.000 4.09505e-06 1.800 4.09600e-06 1.800
+ )
Xd_a2 src_a2 a2 vdd gnd tb_inv
Vb2 src_b2 gnd PWL(
+ 0.00000e+00 1.800 4.00000e-09 1.800 4.05000e-09 0.000 8.00000e-09 0.000 8.05000e-09 1.800 1.20000e-08 1.800
+ 1.20500e-08 0.000 1.60000e-08 0.000 1.60500e-08 1.800 2.00000e-08 1.800 2.00500e-08 0.000 2.40000e-08 0.000
+ 2.40500e-08 1.800 2.80000e-08 1.800 2.80500e-08 0.000 3.20000e-08 0.000 3.20500e-08 1.800 3.60000e-08 1.800
+ 3.60500e-08 0.000 4.00000e-08 0.000 4.00500e-08 1.800 4.40000e-08 1.800 4.40500e-08 0.000 4.80000e-08 0.000
+ 4.80500e-08 1.800 5.20000e-08 1.800 5.20500e-08 0.000 5.60000e-08 0.000 5.60500e-08 1.800 6.00000e-08 1.800
+ 6.00500e-08 0.000 6.40000e-08 0.000 6.40500e-08 1.800 6.80000e-08 1.800 6.80500e-08 0.000 7.20000e-08 0.000
+ 7.20500e-08 1.800 7.60000e-08 1.800 7.60500e-08 0.000 8.00000e-08 0.000 8.00500e-08 1.800 8.40000e-08 1.800
+ 8.40500e-08 0.000 8.80000e-08 0.000 8.80500e-08 1.800 9.20000e-08 1.800 9.20500e-08 0.000 9.60000e-08 0.000
+ 9.60500e-08 1.800 1.00000e-07 1.800 1.00050e-07 0.000 1.04000e-07 0.000 1.04050e-07 1.800 1.08000e-07 1.800
+ 1.08050e-07 0.000 1.12000e-07 0.000 1.12050e-07 1.800 1.16000e-07 1.800 1.16050e-07 0.000 1.20000e-07 0.000
+ 1.20050e-07 1.800 1.24000e-07 1.800 1.24050e-07 0.000 1.28000e-07 0.000 1.28050e-07 1.800 1.32000e-07 1.800
+ 1.32050e-07 0.000 1.36000e-07 0.000 1.36050e-07 1.800 1.40000e-07 1.800 1.40050e-07 0.000 1.44000e-07 0.000
+ 1.44050e-07 1.800 1.48000e-07 1.800 1.48050e-07 0.000 1.52000e-07 0.000 1.52050e-07 1.800 1.56000e-07 1.800
+ 1.56050e-07 0.000 1.60000e-07 0.000 1.60050e-07 1.800 1.64000e-07 1.800 1.64050e-07 0.000 1.68000e-07 0.000
+ 1.68050e-07 1.800 1.72000e-07 1.800 1.72050e-07 0.000 1.76000e-07 0.000 1.76050e-07 1.800 1.80000e-07 1.800
+ 1.80050e-07 0.000 1.84000e-07 0.000 1.84050e-07 1.800 1.88000e-07 1.800 1.88050e-07 0.000 1.92000e-07 0.000
+ 1.92050e-07 1.800 1.96000e-07 1.800 1.96050e-07 0.000 2.00000e-07 0.000 2.00050e-07 1.800 2.04000e-07 1.800
+ 2.04050e-07 0.000 2.08000e-07 0.000 2.08050e-07 1.800 2.12000e-07 1.800 2.12050e-07 0.000 2.16000e-07 0.000
+ 2.16050e-07 1.800 2.20000e-07 1.800 2.20050e-07 0.000 2.24000e-07 0.000 2.24050e-07 1.800 2.28000e-07 1.800
+ 2.28050e-07 0.000 2.32000e-07 0.000 2.32050e-07 1.800 2.36000e-07 1.800 2.36050e-07 0.000 2.40000e-07 0.000
+ 2.40050e-07 1.800 2.44000e-07 1.800 2.44050e-07 0.000 2.48000e-07 0.000 2.48050e-07 1.800 2.52000e-07 1.800
+ 2.52050e-07 0.000 2.56000e-07 0.000 2.56050e-07 1.800 2.60000e-07 1.800 2.60050e-07 0.000 2.64000e-07 0.000
+ 2.64050e-07 1.800 2.68000e-07 1.800 2.68050e-07 0.000 2.72000e-07 0.000 2.72050e-07 1.800 2.76000e-07 1.800
+ 2.76050e-07 0.000 2.80000e-07 0.000 2.80050e-07 1.800 2.84000e-07 1.800 2.84050e-07 0.000 2.88000e-07 0.000
+ 2.88050e-07 1.800 2.92000e-07 1.800 2.92050e-07 0.000 2.96000e-07 0.000 2.96050e-07 1.800 3.00000e-07 1.800
+ 3.00050e-07 0.000 3.04000e-07 0.000 3.04050e-07 1.800 3.08000e-07 1.800 3.08050e-07 0.000 3.12000e-07 0.000
+ 3.12050e-07 1.800 3.16000e-07 1.800 3.16050e-07 0.000 3.20000e-07 0.000 3.20050e-07 1.800 3.24000e-07 1.800
+ 3.24050e-07 0.000 3.28000e-07 0.000 3.28050e-07 1.800 3.32000e-07 1.800 3.32050e-07 0.000 3.36000e-07 0.000
+ 3.36050e-07 1.800 3.40000e-07 1.800 3.40050e-07 0.000 3.44000e-07 0.000 3.44050e-07 1.800 3.48000e-07 1.800
+ 3.48050e-07 0.000 3.52000e-07 0.000 3.52050e-07 1.800 3.56000e-07 1.800 3.56050e-07 0.000 3.60000e-07 0.000
+ 3.60050e-07 1.800 3.64000e-07 1.800 3.64050e-07 0.000 3.68000e-07 0.000 3.68050e-07 1.800 3.72000e-07 1.800
+ 3.72050e-07 0.000 3.76000e-07 0.000 3.76050e-07 1.800 3.80000e-07 1.800 3.80050e-07 0.000 3.84000e-07 0.000
+ 3.84050e-07 1.800 3.88000e-07 1.800 3.88050e-07 0.000 3.92000e-07 0.000 3.92050e-07 1.800 3.96000e-07 1.800
+ 3.96050e-07 0.000 4.00000e-07 0.000 4.00050e-07 1.800 4.04000e-07 1.800 4.04050e-07 0.000 4.08000e-07 0.000
+ 4.08050e-07 1.800 4.12000e-07 1.800 4.12050e-07 0.000 4.16000e-07 0.000 4.16050e-07 1.800 4.20000e-07 1.800
+ 4.20050e-07 0.000 4.24000e-07 0.000 4.24050e-07 1.800 4.28000e-07 1.800 4.28050e-07 0.000 4.32000e-07 0.000
+ 4.32050e-07 1.800 4.36000e-07 1.800 4.36050e-07 0.000 4.40000e-07 0.000 4.40050e-07 1.800 4.44000e-07 1.800
+ 4.44050e-07 0.000 4.48000e-07 0.000 4.48050e-07 1.800 4.52000e-07 1.800 4.52050e-07 0.000 4.56000e-07 0.000
+ 4.56050e-07 1.800 4.60000e-07 1.800 4.60050e-07 0.000 4.64000e-07 0.000 4.64050e-07 1.800 4.68000e-07 1.800
+ 4.68050e-07 0.000 4.72000e-07 0.000 4.72050e-07 1.800 4.76000e-07 1.800 4.76050e-07 0.000 4.80000e-07 0.000
+ 4.80050e-07 1.800 4.84000e-07 1.800 4.84050e-07 0.000 4.88000e-07 0.000 4.88050e-07 1.800 4.92000e-07 1.800
+ 4.92050e-07 0.000 4.96000e-07 0.000 4.96050e-07 1.800 5.00000e-07 1.800 5.00050e-07 0.000 5.04000e-07 0.000
+ 5.04050e-07 1.800 5.08000e-07 1.800 5.08050e-07 0.000 5.12000e-07 0.000 5.12050e-07 1.800 5.16000e-07 1.800
+ 5.16050e-07 0.000 5.20000e-07 0.000 5.20050e-07 1.800 5.24000e-07 1.800 5.24050e-07 0.000 5.28000e-07 0.000
+ 5.28050e-07 1.800 5.32000e-07 1.800 5.32050e-07 0.000 5.36000e-07 0.000 5.36050e-07 1.800 5.40000e-07 1.800
+ 5.40050e-07 0.000 5.44000e-07 0.000 5.44050e-07 1.800 5.48000e-07 1.800 5.48050e-07 0.000 5.52000e-07 0.000
+ 5.52050e-07 1.800 5.56000e-07 1.800 5.56050e-07 0.000 5.60000e-07 0.000 5.60050e-07 1.800 5.64000e-07 1.800
+ 5.64050e-07 0.000 5.68000e-07 0.000 5.68050e-07 1.800 5.72000e-07 1.800 5.72050e-07 0.000 5.76000e-07 0.000
+ 5.76050e-07 1.800 5.80000e-07 1.800 5.80050e-07 0.000 5.84000e-07 0.000 5.84050e-07 1.800 5.88000e-07 1.800
+ 5.88050e-07 0.000 5.92000e-07 0.000 5.92050e-07 1.800 5.96000e-07 1.800 5.96050e-07 0.000 6.00000e-07 0.000
+ 6.00050e-07 1.800 6.04000e-07 1.800 6.04050e-07 0.000 6.08000e-07 0.000 6.08050e-07 1.800 6.12000e-07 1.800
+ 6.12050e-07 0.000 6.16000e-07 0.000 6.16050e-07 1.800 6.20000e-07 1.800 6.20050e-07 0.000 6.24000e-07 0.000
+ 6.24050e-07 1.800 6.28000e-07 1.800 6.28050e-07 0.000 6.32000e-07 0.000 6.32050e-07 1.800 6.36000e-07 1.800
+ 6.36050e-07 0.000 6.40000e-07 0.000 6.40050e-07 1.800 6.44000e-07 1.800 6.44050e-07 0.000 6.48000e-07 0.000
+ 6.48050e-07 1.800 6.52000e-07 1.800 6.52050e-07 0.000 6.56000e-07 0.000 6.56050e-07 1.800 6.60000e-07 1.800
+ 6.60050e-07 0.000 6.64000e-07 0.000 6.64050e-07 1.800 6.68000e-07 1.800 6.68050e-07 0.000 6.72000e-07 0.000
+ 6.72050e-07 1.800 6.76000e-07 1.800 6.76050e-07 0.000 6.80000e-07 0.000 6.80050e-07 1.800 6.84000e-07 1.800
+ 6.84050e-07 0.000 6.88000e-07 0.000 6.88050e-07 1.800 6.92000e-07 1.800 6.92050e-07 0.000 6.96000e-07 0.000
+ 6.96050e-07 1.800 7.00000e-07 1.800 7.00050e-07 0.000 7.04000e-07 0.000 7.04050e-07 1.800 7.08000e-07 1.800
+ 7.08050e-07 0.000 7.12000e-07 0.000 7.12050e-07 1.800 7.16000e-07 1.800 7.16050e-07 0.000 7.20000e-07 0.000
+ 7.20050e-07 1.800 7.24000e-07 1.800 7.24050e-07 0.000 7.28000e-07 0.000 7.28050e-07 1.800 7.32000e-07 1.800
+ 7.32050e-07 0.000 7.36000e-07 0.000 7.36050e-07 1.800 7.40000e-07 1.800 7.40050e-07 0.000 7.44000e-07 0.000
+ 7.44050e-07 1.800 7.48000e-07 1.800 7.48050e-07 0.000 7.52000e-07 0.000 7.52050e-07 1.800 7.56000e-07 1.800
+ 7.56050e-07 0.000 7.60000e-07 0.000 7.60050e-07 1.800 7.64000e-07 1.800 7.64050e-07 0.000 7.68000e-07 0.000
+ 7.68050e-07 1.800 7.72000e-07 1.800 7.72050e-07 0.000 7.76000e-07 0.000 7.76050e-07 1.800 7.80000e-07 1.800
+ 7.80050e-07 0.000 7.84000e-07 0.000 7.84050e-07 1.800 7.88000e-07 1.800 7.88050e-07 0.000 7.92000e-07 0.000
+ 7.92050e-07 1.800 7.96000e-07 1.800 7.96050e-07 0.000 8.00000e-07 0.000 8.00050e-07 1.800 8.04000e-07 1.800
+ 8.04050e-07 0.000 8.08000e-07 0.000 8.08050e-07 1.800 8.12000e-07 1.800 8.12050e-07 0.000 8.16000e-07 0.000
+ 8.16050e-07 1.800 8.20000e-07 1.800 8.20050e-07 0.000 8.24000e-07 0.000 8.24050e-07 1.800 8.28000e-07 1.800
+ 8.28050e-07 0.000 8.32000e-07 0.000 8.32050e-07 1.800 8.36000e-07 1.800 8.36050e-07 0.000 8.40000e-07 0.000
+ 8.40050e-07 1.800 8.44000e-07 1.800 8.44050e-07 0.000 8.48000e-07 0.000 8.48050e-07 1.800 8.52000e-07 1.800
+ 8.52050e-07 0.000 8.56000e-07 0.000 8.56050e-07 1.800 8.60000e-07 1.800 8.60050e-07 0.000 8.64000e-07 0.000
+ 8.64050e-07 1.800 8.68000e-07 1.800 8.68050e-07 0.000 8.72000e-07 0.000 8.72050e-07 1.800 8.76000e-07 1.800
+ 8.76050e-07 0.000 8.80000e-07 0.000 8.80050e-07 1.800 8.84000e-07 1.800 8.84050e-07 0.000 8.88000e-07 0.000
+ 8.88050e-07 1.800 8.92000e-07 1.800 8.92050e-07 0.000 8.96000e-07 0.000 8.96050e-07 1.800 9.00000e-07 1.800
+ 9.00050e-07 0.000 9.04000e-07 0.000 9.04050e-07 1.800 9.08000e-07 1.800 9.08050e-07 0.000 9.12000e-07 0.000
+ 9.12050e-07 1.800 9.16000e-07 1.800 9.16050e-07 0.000 9.20000e-07 0.000 9.20050e-07 1.800 9.24000e-07 1.800
+ 9.24050e-07 0.000 9.28000e-07 0.000 9.28050e-07 1.800 9.32000e-07 1.800 9.32050e-07 0.000 9.36000e-07 0.000
+ 9.36050e-07 1.800 9.40000e-07 1.800 9.40050e-07 0.000 9.44000e-07 0.000 9.44050e-07 1.800 9.48000e-07 1.800
+ 9.48050e-07 0.000 9.52000e-07 0.000 9.52050e-07 1.800 9.56000e-07 1.800 9.56050e-07 0.000 9.60000e-07 0.000
+ 9.60050e-07 1.800 9.64000e-07 1.800 9.64050e-07 0.000 9.68000e-07 0.000 9.68050e-07 1.800 9.72000e-07 1.800
+ 9.72050e-07 0.000 9.76000e-07 0.000 9.76050e-07 1.800 9.80000e-07 1.800 9.80050e-07 0.000 9.84000e-07 0.000
+ 9.84050e-07 1.800 9.88000e-07 1.800 9.88050e-07 0.000 9.92000e-07 0.000 9.92050e-07 1.800 9.96000e-07 1.800
+ 9.96050e-07 0.000 1.00000e-06 0.000 1.00005e-06 1.800 1.00400e-06 1.800 1.00405e-06 0.000 1.00800e-06 0.000
+ 1.00805e-06 1.800 1.01200e-06 1.800 1.01205e-06 0.000 1.01600e-06 0.000 1.01605e-06 1.800 1.02000e-06 1.800
+ 1.02005e-06 0.000 1.02400e-06 0.000 1.02405e-06 1.800 1.02800e-06 1.800 1.02805e-06 0.000 1.03200e-06 0.000
+ 1.03205e-06 1.800 1.03600e-06 1.800 1.03605e-06 0.000 1.04000e-06 0.000 1.04005e-06 1.800 1.04400e-06 1.800
+ 1.04405e-06 0.000 1.04800e-06 0.000 1.04805e-06 1.800 1.05200e-06 1.800 1.05205e-06 0.000 1.05600e-06 0.000
+ 1.05605e-06 1.800 1.06000e-06 1.800 1.06005e-06 0.000 1.06400e-06 0.000 1.06405e-06 1.800 1.06800e-06 1.800
+ 1.06805e-06 0.000 1.07200e-06 0.000 1.07205e-06 1.800 1.07600e-06 1.800 1.07605e-06 0.000 1.08000e-06 0.000
+ 1.08005e-06 1.800 1.08400e-06 1.800 1.08405e-06 0.000 1.08800e-06 0.000 1.08805e-06 1.800 1.09200e-06 1.800
+ 1.09205e-06 0.000 1.09600e-06 0.000 1.09605e-06 1.800 1.10000e-06 1.800 1.10005e-06 0.000 1.10400e-06 0.000
+ 1.10405e-06 1.800 1.10800e-06 1.800 1.10805e-06 0.000 1.11200e-06 0.000 1.11205e-06 1.800 1.11600e-06 1.800
+ 1.11605e-06 0.000 1.12000e-06 0.000 1.12005e-06 1.800 1.12400e-06 1.800 1.12405e-06 0.000 1.12800e-06 0.000
+ 1.12805e-06 1.800 1.13200e-06 1.800 1.13205e-06 0.000 1.13600e-06 0.000 1.13605e-06 1.800 1.14000e-06 1.800
+ 1.14005e-06 0.000 1.14400e-06 0.000 1.14405e-06 1.800 1.14800e-06 1.800 1.14805e-06 0.000 1.15200e-06 0.000
+ 1.15205e-06 1.800 1.15600e-06 1.800 1.15605e-06 0.000 1.16000e-06 0.000 1.16005e-06 1.800 1.16400e-06 1.800
+ 1.16405e-06 0.000 1.16800e-06 0.000 1.16805e-06 1.800 1.17200e-06 1.800 1.17205e-06 0.000 1.17600e-06 0.000
+ 1.17605e-06 1.800 1.18000e-06 1.800 1.18005e-06 0.000 1.18400e-06 0.000 1.18405e-06 1.800 1.18800e-06 1.800
+ 1.18805e-06 0.000 1.19200e-06 0.000 1.19205e-06 1.800 1.19600e-06 1.800 1.19605e-06 0.000 1.20000e-06 0.000
+ 1.20005e-06 1.800 1.20400e-06 1.800 1.20405e-06 0.000 1.20800e-06 0.000 1.20805e-06 1.800 1.21200e-06 1.800
+ 1.21205e-06 0.000 1.21600e-06 0.000 1.21605e-06 1.800 1.22000e-06 1.800 1.22005e-06 0.000 1.22400e-06 0.000
+ 1.22405e-06 1.800 1.22800e-06 1.800 1.22805e-06 0.000 1.23200e-06 0.000 1.23205e-06 1.800 1.23600e-06 1.800
+ 1.23605e-06 0.000 1.24000e-06 0.000 1.24005e-06 1.800 1.24400e-06 1.800 1.24405e-06 0.000 1.24800e-06 0.000
+ 1.24805e-06 1.800 1.25200e-06 1.800 1.25205e-06 0.000 1.25600e-06 0.000 1.25605e-06 1.800 1.26000e-06 1.800
+ 1.26005e-06 0.000 1.26400e-06 0.000 1.26405e-06 1.800 1.26800e-06 1.800 1.26805e-06 0.000 1.27200e-06 0.000
+ 1.27205e-06 1.800 1.27600e-06 1.800 1.27605e-06 0.000 1.28000e-06 0.000 1.28005e-06 1.800 1.28400e-06 1.800
+ 1.28405e-06 0.000 1.28800e-06 0.000 1.28805e-06 1.800 1.29200e-06 1.800 1.29205e-06 0.000 1.29600e-06 0.000
+ 1.29605e-06 1.800 1.30000e-06 1.800 1.30005e-06 0.000 1.30400e-06 0.000 1.30405e-06 1.800 1.30800e-06 1.800
+ 1.30805e-06 0.000 1.31200e-06 0.000 1.31205e-06 1.800 1.31600e-06 1.800 1.31605e-06 0.000 1.32000e-06 0.000
+ 1.32005e-06 1.800 1.32400e-06 1.800 1.32405e-06 0.000 1.32800e-06 0.000 1.32805e-06 1.800 1.33200e-06 1.800
+ 1.33205e-06 0.000 1.33600e-06 0.000 1.33605e-06 1.800 1.34000e-06 1.800 1.34005e-06 0.000 1.34400e-06 0.000
+ 1.34405e-06 1.800 1.34800e-06 1.800 1.34805e-06 0.000 1.35200e-06 0.000 1.35205e-06 1.800 1.35600e-06 1.800
+ 1.35605e-06 0.000 1.36000e-06 0.000 1.36005e-06 1.800 1.36400e-06 1.800 1.36405e-06 0.000 1.36800e-06 0.000
+ 1.36805e-06 1.800 1.37200e-06 1.800 1.37205e-06 0.000 1.37600e-06 0.000 1.37605e-06 1.800 1.38000e-06 1.800
+ 1.38005e-06 0.000 1.38400e-06 0.000 1.38405e-06 1.800 1.38800e-06 1.800 1.38805e-06 0.000 1.39200e-06 0.000
+ 1.39205e-06 1.800 1.39600e-06 1.800 1.39605e-06 0.000 1.40000e-06 0.000 1.40005e-06 1.800 1.40400e-06 1.800
+ 1.40405e-06 0.000 1.40800e-06 0.000 1.40805e-06 1.800 1.41200e-06 1.800 1.41205e-06 0.000 1.41600e-06 0.000
+ 1.41605e-06 1.800 1.42000e-06 1.800 1.42005e-06 0.000 1.42400e-06 0.000 1.42405e-06 1.800 1.42800e-06 1.800
+ 1.42805e-06 0.000 1.43200e-06 0.000 1.43205e-06 1.800 1.43600e-06 1.800 1.43605e-06 0.000 1.44000e-06 0.000
+ 1.44005e-06 1.800 1.44400e-06 1.800 1.44405e-06 0.000 1.44800e-06 0.000 1.44805e-06 1.800 1.45200e-06 1.800
+ 1.45205e-06 0.000 1.45600e-06 0.000 1.45605e-06 1.800 1.46000e-06 1.800 1.46005e-06 0.000 1.46400e-06 0.000
+ 1.46405e-06 1.800 1.46800e-06 1.800 1.46805e-06 0.000 1.47200e-06 0.000 1.47205e-06 1.800 1.47600e-06 1.800
+ 1.47605e-06 0.000 1.48000e-06 0.000 1.48005e-06 1.800 1.48400e-06 1.800 1.48405e-06 0.000 1.48800e-06 0.000
+ 1.48805e-06 1.800 1.49200e-06 1.800 1.49205e-06 0.000 1.49600e-06 0.000 1.49605e-06 1.800 1.50000e-06 1.800
+ 1.50005e-06 0.000 1.50400e-06 0.000 1.50405e-06 1.800 1.50800e-06 1.800 1.50805e-06 0.000 1.51200e-06 0.000
+ 1.51205e-06 1.800 1.51600e-06 1.800 1.51605e-06 0.000 1.52000e-06 0.000 1.52005e-06 1.800 1.52400e-06 1.800
+ 1.52405e-06 0.000 1.52800e-06 0.000 1.52805e-06 1.800 1.53200e-06 1.800 1.53205e-06 0.000 1.53600e-06 0.000
+ 1.53605e-06 1.800 1.54000e-06 1.800 1.54005e-06 0.000 1.54400e-06 0.000 1.54405e-06 1.800 1.54800e-06 1.800
+ 1.54805e-06 0.000 1.55200e-06 0.000 1.55205e-06 1.800 1.55600e-06 1.800 1.55605e-06 0.000 1.56000e-06 0.000
+ 1.56005e-06 1.800 1.56400e-06 1.800 1.56405e-06 0.000 1.56800e-06 0.000 1.56805e-06 1.800 1.57200e-06 1.800
+ 1.57205e-06 0.000 1.57600e-06 0.000 1.57605e-06 1.800 1.58000e-06 1.800 1.58005e-06 0.000 1.58400e-06 0.000
+ 1.58405e-06 1.800 1.58800e-06 1.800 1.58805e-06 0.000 1.59200e-06 0.000 1.59205e-06 1.800 1.59600e-06 1.800
+ 1.59605e-06 0.000 1.60000e-06 0.000 1.60005e-06 1.800 1.60400e-06 1.800 1.60405e-06 0.000 1.60800e-06 0.000
+ 1.60805e-06 1.800 1.61200e-06 1.800 1.61205e-06 0.000 1.61600e-06 0.000 1.61605e-06 1.800 1.62000e-06 1.800
+ 1.62005e-06 0.000 1.62400e-06 0.000 1.62405e-06 1.800 1.62800e-06 1.800 1.62805e-06 0.000 1.63200e-06 0.000
+ 1.63205e-06 1.800 1.63600e-06 1.800 1.63605e-06 0.000 1.64000e-06 0.000 1.64005e-06 1.800 1.64400e-06 1.800
+ 1.64405e-06 0.000 1.64800e-06 0.000 1.64805e-06 1.800 1.65200e-06 1.800 1.65205e-06 0.000 1.65600e-06 0.000
+ 1.65605e-06 1.800 1.66000e-06 1.800 1.66005e-06 0.000 1.66400e-06 0.000 1.66405e-06 1.800 1.66800e-06 1.800
+ 1.66805e-06 0.000 1.67200e-06 0.000 1.67205e-06 1.800 1.67600e-06 1.800 1.67605e-06 0.000 1.68000e-06 0.000
+ 1.68005e-06 1.800 1.68400e-06 1.800 1.68405e-06 0.000 1.68800e-06 0.000 1.68805e-06 1.800 1.69200e-06 1.800
+ 1.69205e-06 0.000 1.69600e-06 0.000 1.69605e-06 1.800 1.70000e-06 1.800 1.70005e-06 0.000 1.70400e-06 0.000
+ 1.70405e-06 1.800 1.70800e-06 1.800 1.70805e-06 0.000 1.71200e-06 0.000 1.71205e-06 1.800 1.71600e-06 1.800
+ 1.71605e-06 0.000 1.72000e-06 0.000 1.72005e-06 1.800 1.72400e-06 1.800 1.72405e-06 0.000 1.72800e-06 0.000
+ 1.72805e-06 1.800 1.73200e-06 1.800 1.73205e-06 0.000 1.73600e-06 0.000 1.73605e-06 1.800 1.74000e-06 1.800
+ 1.74005e-06 0.000 1.74400e-06 0.000 1.74405e-06 1.800 1.74800e-06 1.800 1.74805e-06 0.000 1.75200e-06 0.000
+ 1.75205e-06 1.800 1.75600e-06 1.800 1.75605e-06 0.000 1.76000e-06 0.000 1.76005e-06 1.800 1.76400e-06 1.800
+ 1.76405e-06 0.000 1.76800e-06 0.000 1.76805e-06 1.800 1.77200e-06 1.800 1.77205e-06 0.000 1.77600e-06 0.000
+ 1.77605e-06 1.800 1.78000e-06 1.800 1.78005e-06 0.000 1.78400e-06 0.000 1.78405e-06 1.800 1.78800e-06 1.800
+ 1.78805e-06 0.000 1.79200e-06 0.000 1.79205e-06 1.800 1.79600e-06 1.800 1.79605e-06 0.000 1.80000e-06 0.000
+ 1.80005e-06 1.800 1.80400e-06 1.800 1.80405e-06 0.000 1.80800e-06 0.000 1.80805e-06 1.800 1.81200e-06 1.800
+ 1.81205e-06 0.000 1.81600e-06 0.000 1.81605e-06 1.800 1.82000e-06 1.800 1.82005e-06 0.000 1.82400e-06 0.000
+ 1.82405e-06 1.800 1.82800e-06 1.800 1.82805e-06 0.000 1.83200e-06 0.000 1.83205e-06 1.800 1.83600e-06 1.800
+ 1.83605e-06 0.000 1.84000e-06 0.000 1.84005e-06 1.800 1.84400e-06 1.800 1.84405e-06 0.000 1.84800e-06 0.000
+ 1.84805e-06 1.800 1.85200e-06 1.800 1.85205e-06 0.000 1.85600e-06 0.000 1.85605e-06 1.800 1.86000e-06 1.800
+ 1.86005e-06 0.000 1.86400e-06 0.000 1.86405e-06 1.800 1.86800e-06 1.800 1.86805e-06 0.000 1.87200e-06 0.000
+ 1.87205e-06 1.800 1.87600e-06 1.800 1.87605e-06 0.000 1.88000e-06 0.000 1.88005e-06 1.800 1.88400e-06 1.800
+ 1.88405e-06 0.000 1.88800e-06 0.000 1.88805e-06 1.800 1.89200e-06 1.800 1.89205e-06 0.000 1.89600e-06 0.000
+ 1.89605e-06 1.800 1.90000e-06 1.800 1.90005e-06 0.000 1.90400e-06 0.000 1.90405e-06 1.800 1.90800e-06 1.800
+ 1.90805e-06 0.000 1.91200e-06 0.000 1.91205e-06 1.800 1.91600e-06 1.800 1.91605e-06 0.000 1.92000e-06 0.000
+ 1.92005e-06 1.800 1.92400e-06 1.800 1.92405e-06 0.000 1.92800e-06 0.000 1.92805e-06 1.800 1.93200e-06 1.800
+ 1.93205e-06 0.000 1.93600e-06 0.000 1.93605e-06 1.800 1.94000e-06 1.800 1.94005e-06 0.000 1.94400e-06 0.000
+ 1.94405e-06 1.800 1.94800e-06 1.800 1.94805e-06 0.000 1.95200e-06 0.000 1.95205e-06 1.800 1.95600e-06 1.800
+ 1.95605e-06 0.000 1.96000e-06 0.000 1.96005e-06 1.800 1.96400e-06 1.800 1.96405e-06 0.000 1.96800e-06 0.000
+ 1.96805e-06 1.800 1.97200e-06 1.800 1.97205e-06 0.000 1.97600e-06 0.000 1.97605e-06 1.800 1.98000e-06 1.800
+ 1.98005e-06 0.000 1.98400e-06 0.000 1.98405e-06 1.800 1.98800e-06 1.800 1.98805e-06 0.000 1.99200e-06 0.000
+ 1.99205e-06 1.800 1.99600e-06 1.800 1.99605e-06 0.000 2.00000e-06 0.000 2.00005e-06 1.800 2.00400e-06 1.800
+ 2.00405e-06 0.000 2.00800e-06 0.000 2.00805e-06 1.800 2.01200e-06 1.800 2.01205e-06 0.000 2.01600e-06 0.000
+ 2.01605e-06 1.800 2.02000e-06 1.800 2.02005e-06 0.000 2.02400e-06 0.000 2.02405e-06 1.800 2.02800e-06 1.800
+ 2.02805e-06 0.000 2.03200e-06 0.000 2.03205e-06 1.800 2.03600e-06 1.800 2.03605e-06 0.000 2.04000e-06 0.000
+ 2.04005e-06 1.800 2.04400e-06 1.800 2.04405e-06 0.000 2.04800e-06 0.000 2.04805e-06 1.800 2.05000e-06 1.800
+ 2.05005e-06 0.000 2.05100e-06 0.000 2.05105e-06 1.800 2.05200e-06 1.800 2.05205e-06 0.000 2.05300e-06 0.000
+ 2.05305e-06 1.800 2.05400e-06 1.800 2.05405e-06 0.000 2.06100e-06 0.000 2.06105e-06 1.800 2.06200e-06 1.800
+ 2.06205e-06 0.000 2.06600e-06 0.000 2.06605e-06 1.800 2.06700e-06 1.800 2.06705e-06 0.000 2.06900e-06 0.000
+ 2.06905e-06 1.800 2.07000e-06 1.800 2.07005e-06 0.000 2.07100e-06 0.000 2.07105e-06 1.800 2.07200e-06 1.800
+ 2.07205e-06 0.000 2.07500e-06 0.000 2.07505e-06 1.800 2.07800e-06 1.800 2.07805e-06 0.000 2.08100e-06 0.000
+ 2.08105e-06 1.800 2.08200e-06 1.800 2.08205e-06 0.000 2.08600e-06 0.000 2.08605e-06 1.800 2.08800e-06 1.800
+ 2.08805e-06 0.000 2.09300e-06 0.000 2.09305e-06 1.800 2.09400e-06 1.800 2.09405e-06 0.000 2.09500e-06 0.000
+ 2.09505e-06 1.800 2.09600e-06 1.800 2.09605e-06 0.000 2.09900e-06 0.000 2.09905e-06 1.800 2.10000e-06 1.800
+ 2.10005e-06 0.000 2.10100e-06 0.000 2.10105e-06 1.800 2.10200e-06 1.800 2.10205e-06 0.000 2.10400e-06 0.000
+ 2.10405e-06 1.800 2.10500e-06 1.800 2.10505e-06 0.000 2.11100e-06 0.000 2.11105e-06 1.800 2.11200e-06 1.800
+ 2.11205e-06 0.000 2.11300e-06 0.000 2.11305e-06 1.800 2.11600e-06 1.800 2.11605e-06 0.000 2.12100e-06 0.000
+ 2.12105e-06 1.800 2.12200e-06 1.800 2.12205e-06 0.000 2.12300e-06 0.000 2.12305e-06 1.800 2.12400e-06 1.800
+ 2.12405e-06 0.000 2.12600e-06 0.000 2.12605e-06 1.800 2.12800e-06 1.800 2.12805e-06 0.000 2.12900e-06 0.000
+ 2.12905e-06 1.800 2.13100e-06 1.800 2.13105e-06 0.000 2.13300e-06 0.000 2.13305e-06 1.800 2.13500e-06 1.800
+ 2.13505e-06 0.000 2.13600e-06 0.000 2.13605e-06 1.800 2.13800e-06 1.800 2.13805e-06 0.000 2.14000e-06 0.000
+ 2.14005e-06 1.800 2.14100e-06 1.800 2.14105e-06 0.000 2.14200e-06 0.000 2.14205e-06 1.800 2.14300e-06 1.800
+ 2.14305e-06 0.000 2.14600e-06 0.000 2.14605e-06 1.800 2.14900e-06 1.800 2.14905e-06 0.000 2.15000e-06 0.000
+ 2.15005e-06 1.800 2.15100e-06 1.800 2.15105e-06 0.000 2.15200e-06 0.000 2.15205e-06 1.800 2.15700e-06 1.800
+ 2.15705e-06 0.000 2.16300e-06 0.000 2.16305e-06 1.800 2.16400e-06 1.800 2.16405e-06 0.000 2.16500e-06 0.000
+ 2.16505e-06 1.800 2.16600e-06 1.800 2.16605e-06 0.000 2.16700e-06 0.000 2.16705e-06 1.800 2.16800e-06 1.800
+ 2.16805e-06 0.000 2.16900e-06 0.000 2.16905e-06 1.800 2.17000e-06 1.800 2.17005e-06 0.000 2.17100e-06 0.000
+ 2.17105e-06 1.800 2.17200e-06 1.800 2.17205e-06 0.000 2.17300e-06 0.000 2.17305e-06 1.800 2.17400e-06 1.800
+ 2.17405e-06 0.000 2.17500e-06 0.000 2.17505e-06 1.800 2.17600e-06 1.800 2.17605e-06 0.000 2.17800e-06 0.000
+ 2.17805e-06 1.800 2.18000e-06 1.800 2.18005e-06 0.000 2.18600e-06 0.000 2.18605e-06 1.800 2.19100e-06 1.800
+ 2.19105e-06 0.000 2.19500e-06 0.000 2.19505e-06 1.800 2.19600e-06 1.800 2.19605e-06 0.000 2.19900e-06 0.000
+ 2.19905e-06 1.800 2.20000e-06 1.800 2.20005e-06 0.000 2.20100e-06 0.000 2.20105e-06 1.800 2.20200e-06 1.800
+ 2.20205e-06 0.000 2.21100e-06 0.000 2.21105e-06 1.800 2.21400e-06 1.800 2.21405e-06 0.000 2.21500e-06 0.000
+ 2.21505e-06 1.800 2.21700e-06 1.800 2.21705e-06 0.000 2.21900e-06 0.000 2.21905e-06 1.800 2.22200e-06 1.800
+ 2.22205e-06 0.000 2.22600e-06 0.000 2.22605e-06 1.800 2.22700e-06 1.800 2.22705e-06 0.000 2.22800e-06 0.000
+ 2.22805e-06 1.800 2.22900e-06 1.800 2.22905e-06 0.000 2.23200e-06 0.000 2.23205e-06 1.800 2.23300e-06 1.800
+ 2.23305e-06 0.000 2.23600e-06 0.000 2.23605e-06 1.800 2.23700e-06 1.800 2.23705e-06 0.000 2.23800e-06 0.000
+ 2.23805e-06 1.800 2.24100e-06 1.800 2.24105e-06 0.000 2.24600e-06 0.000 2.24605e-06 1.800 2.24700e-06 1.800
+ 2.24705e-06 0.000 2.24800e-06 0.000 2.24805e-06 1.800 2.24900e-06 1.800 2.24905e-06 0.000 2.25200e-06 0.000
+ 2.25205e-06 1.800 2.25400e-06 1.800 2.25405e-06 0.000 2.25500e-06 0.000 2.25505e-06 1.800 2.25600e-06 1.800
+ 2.25605e-06 0.000 2.25700e-06 0.000 2.25705e-06 1.800 2.25900e-06 1.800 2.25905e-06 0.000 2.26300e-06 0.000
+ 2.26305e-06 1.800 2.26400e-06 1.800 2.26405e-06 0.000 2.26500e-06 0.000 2.26505e-06 1.800 2.26700e-06 1.800
+ 2.26705e-06 0.000 2.26800e-06 0.000 2.26805e-06 1.800 2.26900e-06 1.800 2.26905e-06 0.000 2.27100e-06 0.000
+ 2.27105e-06 1.800 2.27600e-06 1.800 2.27605e-06 0.000 2.27800e-06 0.000 2.27805e-06 1.800 2.28000e-06 1.800
+ 2.28005e-06 0.000 2.28300e-06 0.000 2.28305e-06 1.800 2.28500e-06 1.800 2.28505e-06 0.000 2.28600e-06 0.000
+ 2.28605e-06 1.800 2.28700e-06 1.800 2.28705e-06 0.000 2.28900e-06 0.000 2.28905e-06 1.800 2.29000e-06 1.800
+ 2.29005e-06 0.000 2.29100e-06 0.000 2.29105e-06 1.800 2.29200e-06 1.800 2.29205e-06 0.000 2.29300e-06 0.000
+ 2.29305e-06 1.800 2.29500e-06 1.800 2.29505e-06 0.000 2.29600e-06 0.000 2.29605e-06 1.800 2.29800e-06 1.800
+ 2.29805e-06 0.000 2.29900e-06 0.000 2.29905e-06 1.800 2.30300e-06 1.800 2.30305e-06 0.000 2.30600e-06 0.000
+ 2.30605e-06 1.800 2.30700e-06 1.800 2.30705e-06 0.000 2.30800e-06 0.000 2.30805e-06 1.800 2.31000e-06 1.800
+ 2.31005e-06 0.000 2.31100e-06 0.000 2.31105e-06 1.800 2.31300e-06 1.800 2.31305e-06 0.000 2.31500e-06 0.000
+ 2.31505e-06 1.800 2.31700e-06 1.800 2.31705e-06 0.000 2.31800e-06 0.000 2.31805e-06 1.800 2.32000e-06 1.800
+ 2.32005e-06 0.000 2.32400e-06 0.000 2.32405e-06 1.800 2.32500e-06 1.800 2.32505e-06 0.000 2.32600e-06 0.000
+ 2.32605e-06 1.800 2.32900e-06 1.800 2.32905e-06 0.000 2.33200e-06 0.000 2.33205e-06 1.800 2.33300e-06 1.800
+ 2.33305e-06 0.000 2.33400e-06 0.000 2.33405e-06 1.800 2.33700e-06 1.800 2.33705e-06 0.000 2.34500e-06 0.000
+ 2.34505e-06 1.800 2.34600e-06 1.800 2.34605e-06 0.000 2.34700e-06 0.000 2.34705e-06 1.800 2.35000e-06 1.800
+ 2.35005e-06 0.000 2.35200e-06 0.000 2.35205e-06 1.800 2.35300e-06 1.800 2.35305e-06 0.000 2.35400e-06 0.000
+ 2.35405e-06 1.800 2.35700e-06 1.800 2.35705e-06 0.000 2.36000e-06 0.000 2.36005e-06 1.800 2.36100e-06 1.800
+ 2.36105e-06 0.000 2.36800e-06 0.000 2.36805e-06 1.800 2.37000e-06 1.800 2.37005e-06 0.000 2.37100e-06 0.000
+ 2.37105e-06 1.800 2.37300e-06 1.800 2.37305e-06 0.000 2.37400e-06 0.000 2.37405e-06 1.800 2.37500e-06 1.800
+ 2.37505e-06 0.000 2.37700e-06 0.000 2.37705e-06 1.800 2.38100e-06 1.800 2.38105e-06 0.000 2.38300e-06 0.000
+ 2.38305e-06 1.800 2.38400e-06 1.800 2.38405e-06 0.000 2.38500e-06 0.000 2.38505e-06 1.800 2.38700e-06 1.800
+ 2.38705e-06 0.000 2.38900e-06 0.000 2.38905e-06 1.800 2.39000e-06 1.800 2.39005e-06 0.000 2.39100e-06 0.000
+ 2.39105e-06 1.800 2.39200e-06 1.800 2.39205e-06 0.000 2.39300e-06 0.000 2.39305e-06 1.800 2.39400e-06 1.800
+ 2.39405e-06 0.000 2.39600e-06 0.000 2.39605e-06 1.800 2.39800e-06 1.800 2.39805e-06 0.000 2.39900e-06 0.000
+ 2.39905e-06 1.800 2.40100e-06 1.800 2.40105e-06 0.000 2.40500e-06 0.000 2.40505e-06 1.800 2.40600e-06 1.800
+ 2.40605e-06 0.000 2.41400e-06 0.000 2.41405e-06 1.800 2.41500e-06 1.800 2.41505e-06 0.000 2.41600e-06 0.000
+ 2.41605e-06 1.800 2.41700e-06 1.800 2.41705e-06 0.000 2.41900e-06 0.000 2.41905e-06 1.800 2.42100e-06 1.800
+ 2.42105e-06 0.000 2.42300e-06 0.000 2.42305e-06 1.800 2.42500e-06 1.800 2.42505e-06 0.000 2.43200e-06 0.000
+ 2.43205e-06 1.800 2.43300e-06 1.800 2.43305e-06 0.000 2.43500e-06 0.000 2.43505e-06 1.800 2.43700e-06 1.800
+ 2.43705e-06 0.000 2.44100e-06 0.000 2.44105e-06 1.800 2.44200e-06 1.800 2.44205e-06 0.000 2.44300e-06 0.000
+ 2.44305e-06 1.800 2.44400e-06 1.800 2.44405e-06 0.000 2.44500e-06 0.000 2.44505e-06 1.800 2.44800e-06 1.800
+ 2.44805e-06 0.000 2.44900e-06 0.000 2.44905e-06 1.800 2.45200e-06 1.800 2.45205e-06 0.000 2.45600e-06 0.000
+ 2.45605e-06 1.800 2.45700e-06 1.800 2.45705e-06 0.000 2.45800e-06 0.000 2.45805e-06 1.800 2.46200e-06 1.800
+ 2.46205e-06 0.000 2.46300e-06 0.000 2.46305e-06 1.800 2.46400e-06 1.800 2.46405e-06 0.000 2.46500e-06 0.000
+ 2.46505e-06 1.800 2.46600e-06 1.800 2.46605e-06 0.000 2.46700e-06 0.000 2.46705e-06 1.800 2.46800e-06 1.800
+ 2.46805e-06 0.000 2.47000e-06 0.000 2.47005e-06 1.800 2.47200e-06 1.800 2.47205e-06 0.000 2.47600e-06 0.000
+ 2.47605e-06 1.800 2.47700e-06 1.800 2.47705e-06 0.000 2.47800e-06 0.000 2.47805e-06 1.800 2.48000e-06 1.800
+ 2.48005e-06 0.000 2.48100e-06 0.000 2.48105e-06 1.800 2.48200e-06 1.800 2.48205e-06 0.000 2.48300e-06 0.000
+ 2.48305e-06 1.800 2.48400e-06 1.800 2.48405e-06 0.000 2.48600e-06 0.000 2.48605e-06 1.800 2.48700e-06 1.800
+ 2.48705e-06 0.000 2.48800e-06 0.000 2.48805e-06 1.800 2.49000e-06 1.800 2.49005e-06 0.000 2.49100e-06 0.000
+ 2.49105e-06 1.800 2.49200e-06 1.800 2.49205e-06 0.000 2.49600e-06 0.000 2.49605e-06 1.800 2.49700e-06 1.800
+ 2.49705e-06 0.000 2.49800e-06 0.000 2.49805e-06 1.800 2.49900e-06 1.800 2.49905e-06 0.000 2.50000e-06 0.000
+ 2.50005e-06 1.800 2.50100e-06 1.800 2.50105e-06 0.000 2.50500e-06 0.000 2.50505e-06 1.800 2.51300e-06 1.800
+ 2.51305e-06 0.000 2.51500e-06 0.000 2.51505e-06 1.800 2.51600e-06 1.800 2.51605e-06 0.000 2.52000e-06 0.000
+ 2.52005e-06 1.800 2.52100e-06 1.800 2.52105e-06 0.000 2.52500e-06 0.000 2.52505e-06 1.800 2.52700e-06 1.800
+ 2.52705e-06 0.000 2.53100e-06 0.000 2.53105e-06 1.800 2.53700e-06 1.800 2.53705e-06 0.000 2.54200e-06 0.000
+ 2.54205e-06 1.800 2.54300e-06 1.800 2.54305e-06 0.000 2.54400e-06 0.000 2.54405e-06 1.800 2.54500e-06 1.800
+ 2.54505e-06 0.000 2.54600e-06 0.000 2.54605e-06 1.800 2.54800e-06 1.800 2.54805e-06 0.000 2.55000e-06 0.000
+ 2.55005e-06 1.800 2.55100e-06 1.800 2.55105e-06 0.000 2.55200e-06 0.000 2.55205e-06 1.800 2.55400e-06 1.800
+ 2.55405e-06 0.000 2.55500e-06 0.000 2.55505e-06 1.800 2.55700e-06 1.800 2.55705e-06 0.000 2.55800e-06 0.000
+ 2.55805e-06 1.800 2.56100e-06 1.800 2.56105e-06 0.000 2.56200e-06 0.000 2.56205e-06 1.800 2.56300e-06 1.800
+ 2.56305e-06 0.000 2.56600e-06 0.000 2.56605e-06 1.800 2.57100e-06 1.800 2.57105e-06 0.000 2.57200e-06 0.000
+ 2.57205e-06 1.800 2.57700e-06 1.800 2.57705e-06 0.000 2.57800e-06 0.000 2.57805e-06 1.800 2.57900e-06 1.800
+ 2.57905e-06 0.000 2.58000e-06 0.000 2.58005e-06 1.800 2.58100e-06 1.800 2.58105e-06 0.000 2.58300e-06 0.000
+ 2.58305e-06 1.800 2.58400e-06 1.800 2.58405e-06 0.000 2.58600e-06 0.000 2.58605e-06 1.800 2.58700e-06 1.800
+ 2.58705e-06 0.000 2.58800e-06 0.000 2.58805e-06 1.800 2.59400e-06 1.800 2.59405e-06 0.000 2.59500e-06 0.000
+ 2.59505e-06 1.800 2.59700e-06 1.800 2.59705e-06 0.000 2.59900e-06 0.000 2.59905e-06 1.800 2.60000e-06 1.800
+ 2.60005e-06 0.000 2.60600e-06 0.000 2.60605e-06 1.800 2.60700e-06 1.800 2.60705e-06 0.000 2.60800e-06 0.000
+ 2.60805e-06 1.800 2.60900e-06 1.800 2.60905e-06 0.000 2.61000e-06 0.000 2.61005e-06 1.800 2.61100e-06 1.800
+ 2.61105e-06 0.000 2.61400e-06 0.000 2.61405e-06 1.800 2.61500e-06 1.800 2.61505e-06 0.000 2.61600e-06 0.000
+ 2.61605e-06 1.800 2.61700e-06 1.800 2.61705e-06 0.000 2.61900e-06 0.000 2.61905e-06 1.800 2.62000e-06 1.800
+ 2.62005e-06 0.000 2.62600e-06 0.000 2.62605e-06 1.800 2.62700e-06 1.800 2.62705e-06 0.000 2.62800e-06 0.000
+ 2.62805e-06 1.800 2.62900e-06 1.800 2.62905e-06 0.000 2.63000e-06 0.000 2.63005e-06 1.800 2.63100e-06 1.800
+ 2.63105e-06 0.000 2.63400e-06 0.000 2.63405e-06 1.800 2.63700e-06 1.800 2.63705e-06 0.000 2.63800e-06 0.000
+ 2.63805e-06 1.800 2.63900e-06 1.800 2.63905e-06 0.000 2.64300e-06 0.000 2.64305e-06 1.800 2.64400e-06 1.800
+ 2.64405e-06 0.000 2.64500e-06 0.000 2.64505e-06 1.800 2.64600e-06 1.800 2.64605e-06 0.000 2.64700e-06 0.000
+ 2.64705e-06 1.800 2.65000e-06 1.800 2.65005e-06 0.000 2.65100e-06 0.000 2.65105e-06 1.800 2.65200e-06 1.800
+ 2.65205e-06 0.000 2.65600e-06 0.000 2.65605e-06 1.800 2.65700e-06 1.800 2.65705e-06 0.000 2.65800e-06 0.000
+ 2.65805e-06 1.800 2.65900e-06 1.800 2.65905e-06 0.000 2.66100e-06 0.000 2.66105e-06 1.800 2.66500e-06 1.800
+ 2.66505e-06 0.000 2.66600e-06 0.000 2.66605e-06 1.800 2.66900e-06 1.800 2.66905e-06 0.000 2.67000e-06 0.000
+ 2.67005e-06 1.800 2.67100e-06 1.800 2.67105e-06 0.000 2.67400e-06 0.000 2.67405e-06 1.800 2.67500e-06 1.800
+ 2.67505e-06 0.000 2.67800e-06 0.000 2.67805e-06 1.800 2.68000e-06 1.800 2.68005e-06 0.000 2.68200e-06 0.000
+ 2.68205e-06 1.800 2.68300e-06 1.800 2.68305e-06 0.000 2.68500e-06 0.000 2.68505e-06 1.800 2.68600e-06 1.800
+ 2.68605e-06 0.000 2.68800e-06 0.000 2.68805e-06 1.800 2.69000e-06 1.800 2.69005e-06 0.000 2.69100e-06 0.000
+ 2.69105e-06 1.800 2.69200e-06 1.800 2.69205e-06 0.000 2.69300e-06 0.000 2.69305e-06 1.800 2.69500e-06 1.800
+ 2.69505e-06 0.000 2.69700e-06 0.000 2.69705e-06 1.800 2.69800e-06 1.800 2.69805e-06 0.000 2.70100e-06 0.000
+ 2.70105e-06 1.800 2.70200e-06 1.800 2.70205e-06 0.000 2.70400e-06 0.000 2.70405e-06 1.800 2.70800e-06 1.800
+ 2.70805e-06 0.000 2.71100e-06 0.000 2.71105e-06 1.800 2.71300e-06 1.800 2.71305e-06 0.000 2.71500e-06 0.000
+ 2.71505e-06 1.800 2.71600e-06 1.800 2.71605e-06 0.000 2.71700e-06 0.000 2.71705e-06 1.800 2.72000e-06 1.800
+ 2.72005e-06 0.000 2.72300e-06 0.000 2.72305e-06 1.800 2.72600e-06 1.800 2.72605e-06 0.000 2.72800e-06 0.000
+ 2.72805e-06 1.800 2.72900e-06 1.800 2.72905e-06 0.000 2.73000e-06 0.000 2.73005e-06 1.800 2.73100e-06 1.800
+ 2.73105e-06 0.000 2.73300e-06 0.000 2.73305e-06 1.800 2.73600e-06 1.800 2.73605e-06 0.000 2.73700e-06 0.000
+ 2.73705e-06 1.800 2.74000e-06 1.800 2.74005e-06 0.000 2.74200e-06 0.000 2.74205e-06 1.800 2.74500e-06 1.800
+ 2.74505e-06 0.000 2.74900e-06 0.000 2.74905e-06 1.800 2.75100e-06 1.800 2.75105e-06 0.000 2.75200e-06 0.000
+ 2.75205e-06 1.800 2.75300e-06 1.800 2.75305e-06 0.000 2.75400e-06 0.000 2.75405e-06 1.800 2.75500e-06 1.800
+ 2.75505e-06 0.000 2.75700e-06 0.000 2.75705e-06 1.800 2.76100e-06 1.800 2.76105e-06 0.000 2.76200e-06 0.000
+ 2.76205e-06 1.800 2.76300e-06 1.800 2.76305e-06 0.000 2.76500e-06 0.000 2.76505e-06 1.800 2.76600e-06 1.800
+ 2.76605e-06 0.000 2.76800e-06 0.000 2.76805e-06 1.800 2.76900e-06 1.800 2.76905e-06 0.000 2.77000e-06 0.000
+ 2.77005e-06 1.800 2.77200e-06 1.800 2.77205e-06 0.000 2.77600e-06 0.000 2.77605e-06 1.800 2.77800e-06 1.800
+ 2.77805e-06 0.000 2.78000e-06 0.000 2.78005e-06 1.800 2.78100e-06 1.800 2.78105e-06 0.000 2.78300e-06 0.000
+ 2.78305e-06 1.800 2.78500e-06 1.800 2.78505e-06 0.000 2.78700e-06 0.000 2.78705e-06 1.800 2.78800e-06 1.800
+ 2.78805e-06 0.000 2.78900e-06 0.000 2.78905e-06 1.800 2.79000e-06 1.800 2.79005e-06 0.000 2.79200e-06 0.000
+ 2.79205e-06 1.800 2.79600e-06 1.800 2.79605e-06 0.000 2.79800e-06 0.000 2.79805e-06 1.800 2.80100e-06 1.800
+ 2.80105e-06 0.000 2.80200e-06 0.000 2.80205e-06 1.800 2.80400e-06 1.800 2.80405e-06 0.000 2.80500e-06 0.000
+ 2.80505e-06 1.800 2.80600e-06 1.800 2.80605e-06 0.000 2.80700e-06 0.000 2.80705e-06 1.800 2.81400e-06 1.800
+ 2.81405e-06 0.000 2.81500e-06 0.000 2.81505e-06 1.800 2.81600e-06 1.800 2.81605e-06 0.000 2.81800e-06 0.000
+ 2.81805e-06 1.800 2.82000e-06 1.800 2.82005e-06 0.000 2.82200e-06 0.000 2.82205e-06 1.800 2.82400e-06 1.800
+ 2.82405e-06 0.000 2.82500e-06 0.000 2.82505e-06 1.800 2.83000e-06 1.800 2.83005e-06 0.000 2.83200e-06 0.000
+ 2.83205e-06 1.800 2.83800e-06 1.800 2.83805e-06 0.000 2.84300e-06 0.000 2.84305e-06 1.800 2.84400e-06 1.800
+ 2.84405e-06 0.000 2.84500e-06 0.000 2.84505e-06 1.800 2.84600e-06 1.800 2.84605e-06 0.000 2.84700e-06 0.000
+ 2.84705e-06 1.800 2.84800e-06 1.800 2.84805e-06 0.000 2.84900e-06 0.000 2.84905e-06 1.800 2.85000e-06 1.800
+ 2.85005e-06 0.000 2.85100e-06 0.000 2.85105e-06 1.800 2.85200e-06 1.800 2.85205e-06 0.000 2.85300e-06 0.000
+ 2.85305e-06 1.800 2.85500e-06 1.800 2.85505e-06 0.000 2.85700e-06 0.000 2.85705e-06 1.800 2.85800e-06 1.800
+ 2.85805e-06 0.000 2.85900e-06 0.000 2.85905e-06 1.800 2.86200e-06 1.800 2.86205e-06 0.000 2.86400e-06 0.000
+ 2.86405e-06 1.800 2.86500e-06 1.800 2.86505e-06 0.000 2.86600e-06 0.000 2.86605e-06 1.800 2.86900e-06 1.800
+ 2.86905e-06 0.000 2.87100e-06 0.000 2.87105e-06 1.800 2.87500e-06 1.800 2.87505e-06 0.000 2.87600e-06 0.000
+ 2.87605e-06 1.800 2.87800e-06 1.800 2.87805e-06 0.000 2.87900e-06 0.000 2.87905e-06 1.800 2.88200e-06 1.800
+ 2.88205e-06 0.000 2.88700e-06 0.000 2.88705e-06 1.800 2.88800e-06 1.800 2.88805e-06 0.000 2.88900e-06 0.000
+ 2.88905e-06 1.800 2.89100e-06 1.800 2.89105e-06 0.000 2.89300e-06 0.000 2.89305e-06 1.800 2.89400e-06 1.800
+ 2.89405e-06 0.000 2.89500e-06 0.000 2.89505e-06 1.800 2.89600e-06 1.800 2.89605e-06 0.000 2.89700e-06 0.000
+ 2.89705e-06 1.800 2.89800e-06 1.800 2.89805e-06 0.000 2.89900e-06 0.000 2.89905e-06 1.800 2.90100e-06 1.800
+ 2.90105e-06 0.000 2.90200e-06 0.000 2.90205e-06 1.800 2.90400e-06 1.800 2.90405e-06 0.000 2.90600e-06 0.000
+ 2.90605e-06 1.800 2.90700e-06 1.800 2.90705e-06 0.000 2.91300e-06 0.000 2.91305e-06 1.800 2.91400e-06 1.800
+ 2.91405e-06 0.000 2.91500e-06 0.000 2.91505e-06 1.800 2.91700e-06 1.800 2.91705e-06 0.000 2.92100e-06 0.000
+ 2.92105e-06 1.800 2.92200e-06 1.800 2.92205e-06 0.000 2.92500e-06 0.000 2.92505e-06 1.800 2.92700e-06 1.800
+ 2.92705e-06 0.000 2.93000e-06 0.000 2.93005e-06 1.800 2.93300e-06 1.800 2.93305e-06 0.000 2.93400e-06 0.000
+ 2.93405e-06 1.800 2.93700e-06 1.800 2.93705e-06 0.000 2.94100e-06 0.000 2.94105e-06 1.800 2.94200e-06 1.800
+ 2.94205e-06 0.000 2.94400e-06 0.000 2.94405e-06 1.800 2.94600e-06 1.800 2.94605e-06 0.000 2.94700e-06 0.000
+ 2.94705e-06 1.800 2.95600e-06 1.800 2.95605e-06 0.000 2.95900e-06 0.000 2.95905e-06 1.800 2.96600e-06 1.800
+ 2.96605e-06 0.000 2.96700e-06 0.000 2.96705e-06 1.800 2.97300e-06 1.800 2.97305e-06 0.000 2.97600e-06 0.000
+ 2.97605e-06 1.800 2.97800e-06 1.800 2.97805e-06 0.000 2.97900e-06 0.000 2.97905e-06 1.800 2.98000e-06 1.800
+ 2.98005e-06 0.000 2.98300e-06 0.000 2.98305e-06 1.800 2.98700e-06 1.800 2.98705e-06 0.000 2.99000e-06 0.000
+ 2.99005e-06 1.800 2.99100e-06 1.800 2.99105e-06 0.000 2.99500e-06 0.000 2.99505e-06 1.800 2.99600e-06 1.800
+ 2.99605e-06 0.000 2.99700e-06 0.000 2.99705e-06 1.800 3.00000e-06 1.800 3.00005e-06 0.000 3.00200e-06 0.000
+ 3.00205e-06 1.800 3.00400e-06 1.800 3.00405e-06 0.000 3.00600e-06 0.000 3.00605e-06 1.800 3.01200e-06 1.800
+ 3.01205e-06 0.000 3.01300e-06 0.000 3.01305e-06 1.800 3.01600e-06 1.800 3.01605e-06 0.000 3.01700e-06 0.000
+ 3.01705e-06 1.800 3.01900e-06 1.800 3.01905e-06 0.000 3.02000e-06 0.000 3.02005e-06 1.800 3.02200e-06 1.800
+ 3.02205e-06 0.000 3.02300e-06 0.000 3.02305e-06 1.800 3.02500e-06 1.800 3.02505e-06 0.000 3.02700e-06 0.000
+ 3.02705e-06 1.800 3.03000e-06 1.800 3.03005e-06 0.000 3.03200e-06 0.000 3.03205e-06 1.800 3.03400e-06 1.800
+ 3.03405e-06 0.000 3.03600e-06 0.000 3.03605e-06 1.800 3.03700e-06 1.800 3.03705e-06 0.000 3.04000e-06 0.000
+ 3.04005e-06 1.800 3.04200e-06 1.800 3.04205e-06 0.000 3.04300e-06 0.000 3.04305e-06 1.800 3.04700e-06 1.800
+ 3.04705e-06 0.000 3.04800e-06 0.000 3.04805e-06 1.800 3.04900e-06 1.800 3.04905e-06 0.000 3.05100e-06 0.000
+ 3.05105e-06 1.800 3.05300e-06 1.800 3.05305e-06 0.000 3.05400e-06 0.000 3.05405e-06 1.800 3.05500e-06 1.800
+ 3.05505e-06 0.000 3.05600e-06 0.000 3.05605e-06 1.800 3.05900e-06 1.800 3.05905e-06 0.000 3.06000e-06 0.000
+ 3.06005e-06 1.800 3.06400e-06 1.800 3.06405e-06 0.000 3.06500e-06 0.000 3.06505e-06 1.800 3.06600e-06 1.800
+ 3.06605e-06 0.000 3.06700e-06 0.000 3.06705e-06 1.800 3.06800e-06 1.800 3.06805e-06 0.000 3.06900e-06 0.000
+ 3.06905e-06 1.800 3.07000e-06 1.800 3.07005e-06 0.000 3.07200e-06 0.000 3.07205e-06 1.800 3.07300e-06 1.800
+ 3.07305e-06 0.000 3.07400e-06 0.000 3.07405e-06 1.800 3.07600e-06 1.800 3.07605e-06 0.000 3.07700e-06 0.000
+ 3.07705e-06 1.800 3.07800e-06 1.800 3.07805e-06 0.000 3.07900e-06 0.000 3.07905e-06 1.800 3.08100e-06 1.800
+ 3.08105e-06 0.000 3.08600e-06 0.000 3.08605e-06 1.800 3.08700e-06 1.800 3.08705e-06 0.000 3.09100e-06 0.000
+ 3.09105e-06 1.800 3.09200e-06 1.800 3.09205e-06 0.000 3.09300e-06 0.000 3.09305e-06 1.800 3.09400e-06 1.800
+ 3.09405e-06 0.000 3.09500e-06 0.000 3.09505e-06 1.800 3.09600e-06 1.800 3.09605e-06 0.000 3.09700e-06 0.000
+ 3.09705e-06 1.800 3.09800e-06 1.800 3.09805e-06 0.000 3.09900e-06 0.000 3.09905e-06 1.800 3.10100e-06 1.800
+ 3.10105e-06 0.000 3.10300e-06 0.000 3.10305e-06 1.800 3.10400e-06 1.800 3.10405e-06 0.000 3.10500e-06 0.000
+ 3.10505e-06 1.800 3.10600e-06 1.800 3.10605e-06 0.000 3.10700e-06 0.000 3.10705e-06 1.800 3.10900e-06 1.800
+ 3.10905e-06 0.000 3.11000e-06 0.000 3.11005e-06 1.800 3.11100e-06 1.800 3.11105e-06 0.000 3.11200e-06 0.000
+ 3.11205e-06 1.800 3.11300e-06 1.800 3.11305e-06 0.000 3.11400e-06 0.000 3.11405e-06 1.800 3.12000e-06 1.800
+ 3.12005e-06 0.000 3.12100e-06 0.000 3.12105e-06 1.800 3.12300e-06 1.800 3.12305e-06 0.000 3.12400e-06 0.000
+ 3.12405e-06 1.800 3.12500e-06 1.800 3.12505e-06 0.000 3.12700e-06 0.000 3.12705e-06 1.800 3.12900e-06 1.800
+ 3.12905e-06 0.000 3.13100e-06 0.000 3.13105e-06 1.800 3.13400e-06 1.800 3.13405e-06 0.000 3.13600e-06 0.000
+ 3.13605e-06 1.800 3.13700e-06 1.800 3.13705e-06 0.000 3.13800e-06 0.000 3.13805e-06 1.800 3.14000e-06 1.800
+ 3.14005e-06 0.000 3.14100e-06 0.000 3.14105e-06 1.800 3.14200e-06 1.800 3.14205e-06 0.000 3.14300e-06 0.000
+ 3.14305e-06 1.800 3.14600e-06 1.800 3.14605e-06 0.000 3.14700e-06 0.000 3.14705e-06 1.800 3.14900e-06 1.800
+ 3.14905e-06 0.000 3.15300e-06 0.000 3.15305e-06 1.800 3.16000e-06 1.800 3.16005e-06 0.000 3.16700e-06 0.000
+ 3.16705e-06 1.800 3.17700e-06 1.800 3.17705e-06 0.000 3.18200e-06 0.000 3.18205e-06 1.800 3.18400e-06 1.800
+ 3.18405e-06 0.000 3.18500e-06 0.000 3.18505e-06 1.800 3.18700e-06 1.800 3.18705e-06 0.000 3.18900e-06 0.000
+ 3.18905e-06 1.800 3.19100e-06 1.800 3.19105e-06 0.000 3.19300e-06 0.000 3.19305e-06 1.800 3.20100e-06 1.800
+ 3.20105e-06 0.000 3.20500e-06 0.000 3.20505e-06 1.800 3.20600e-06 1.800 3.20605e-06 0.000 3.20800e-06 0.000
+ 3.20805e-06 1.800 3.21000e-06 1.800 3.21005e-06 0.000 3.21100e-06 0.000 3.21105e-06 1.800 3.21200e-06 1.800
+ 3.21205e-06 0.000 3.21300e-06 0.000 3.21305e-06 1.800 3.21500e-06 1.800 3.21505e-06 0.000 3.21600e-06 0.000
+ 3.21605e-06 1.800 3.21800e-06 1.800 3.21805e-06 0.000 3.22000e-06 0.000 3.22005e-06 1.800 3.22100e-06 1.800
+ 3.22105e-06 0.000 3.22200e-06 0.000 3.22205e-06 1.800 3.22300e-06 1.800 3.22305e-06 0.000 3.22400e-06 0.000
+ 3.22405e-06 1.800 3.22500e-06 1.800 3.22505e-06 0.000 3.22700e-06 0.000 3.22705e-06 1.800 3.22800e-06 1.800
+ 3.22805e-06 0.000 3.23000e-06 0.000 3.23005e-06 1.800 3.23100e-06 1.800 3.23105e-06 0.000 3.23400e-06 0.000
+ 3.23405e-06 1.800 3.23500e-06 1.800 3.23505e-06 0.000 3.23800e-06 0.000 3.23805e-06 1.800 3.24200e-06 1.800
+ 3.24205e-06 0.000 3.24400e-06 0.000 3.24405e-06 1.800 3.24800e-06 1.800 3.24805e-06 0.000 3.25100e-06 0.000
+ 3.25105e-06 1.800 3.25200e-06 1.800 3.25205e-06 0.000 3.25300e-06 0.000 3.25305e-06 1.800 3.25500e-06 1.800
+ 3.25505e-06 0.000 3.25800e-06 0.000 3.25805e-06 1.800 3.25900e-06 1.800 3.25905e-06 0.000 3.26000e-06 0.000
+ 3.26005e-06 1.800 3.26200e-06 1.800 3.26205e-06 0.000 3.26400e-06 0.000 3.26405e-06 1.800 3.26500e-06 1.800
+ 3.26505e-06 0.000 3.26700e-06 0.000 3.26705e-06 1.800 3.26800e-06 1.800 3.26805e-06 0.000 3.26900e-06 0.000
+ 3.26905e-06 1.800 3.27300e-06 1.800 3.27305e-06 0.000 3.27400e-06 0.000 3.27405e-06 1.800 3.27500e-06 1.800
+ 3.27505e-06 0.000 3.27600e-06 0.000 3.27605e-06 1.800 3.27800e-06 1.800 3.27805e-06 0.000 3.27900e-06 0.000
+ 3.27905e-06 1.800 3.28000e-06 1.800 3.28005e-06 0.000 3.28100e-06 0.000 3.28105e-06 1.800 3.28200e-06 1.800
+ 3.28205e-06 0.000 3.28500e-06 0.000 3.28505e-06 1.800 3.28700e-06 1.800 3.28705e-06 0.000 3.28800e-06 0.000
+ 3.28805e-06 1.800 3.29200e-06 1.800 3.29205e-06 0.000 3.29300e-06 0.000 3.29305e-06 1.800 3.29400e-06 1.800
+ 3.29405e-06 0.000 3.29700e-06 0.000 3.29705e-06 1.800 3.29900e-06 1.800 3.29905e-06 0.000 3.30100e-06 0.000
+ 3.30105e-06 1.800 3.30300e-06 1.800 3.30305e-06 0.000 3.30400e-06 0.000 3.30405e-06 1.800 3.30700e-06 1.800
+ 3.30705e-06 0.000 3.30900e-06 0.000 3.30905e-06 1.800 3.31000e-06 1.800 3.31005e-06 0.000 3.31100e-06 0.000
+ 3.31105e-06 1.800 3.31200e-06 1.800 3.31205e-06 0.000 3.31300e-06 0.000 3.31305e-06 1.800 3.31400e-06 1.800
+ 3.31405e-06 0.000 3.31700e-06 0.000 3.31705e-06 1.800 3.31800e-06 1.800 3.31805e-06 0.000 3.32000e-06 0.000
+ 3.32005e-06 1.800 3.32100e-06 1.800 3.32105e-06 0.000 3.32500e-06 0.000 3.32505e-06 1.800 3.32600e-06 1.800
+ 3.32605e-06 0.000 3.32700e-06 0.000 3.32705e-06 1.800 3.32800e-06 1.800 3.32805e-06 0.000 3.33100e-06 0.000
+ 3.33105e-06 1.800 3.33600e-06 1.800 3.33605e-06 0.000 3.33800e-06 0.000 3.33805e-06 1.800 3.33900e-06 1.800
+ 3.33905e-06 0.000 3.34000e-06 0.000 3.34005e-06 1.800 3.34100e-06 1.800 3.34105e-06 0.000 3.35000e-06 0.000
+ 3.35005e-06 1.800 3.35200e-06 1.800 3.35205e-06 0.000 3.35300e-06 0.000 3.35305e-06 1.800 3.35500e-06 1.800
+ 3.35505e-06 0.000 3.35700e-06 0.000 3.35705e-06 1.800 3.36100e-06 1.800 3.36105e-06 0.000 3.36200e-06 0.000
+ 3.36205e-06 1.800 3.36400e-06 1.800 3.36405e-06 0.000 3.36600e-06 0.000 3.36605e-06 1.800 3.36700e-06 1.800
+ 3.36705e-06 0.000 3.36800e-06 0.000 3.36805e-06 1.800 3.36900e-06 1.800 3.36905e-06 0.000 3.37200e-06 0.000
+ 3.37205e-06 1.800 3.37300e-06 1.800 3.37305e-06 0.000 3.37400e-06 0.000 3.37405e-06 1.800 3.37500e-06 1.800
+ 3.37505e-06 0.000 3.37600e-06 0.000 3.37605e-06 1.800 3.38000e-06 1.800 3.38005e-06 0.000 3.38100e-06 0.000
+ 3.38105e-06 1.800 3.38200e-06 1.800 3.38205e-06 0.000 3.38900e-06 0.000 3.38905e-06 1.800 3.39200e-06 1.800
+ 3.39205e-06 0.000 3.39300e-06 0.000 3.39305e-06 1.800 3.39400e-06 1.800 3.39405e-06 0.000 3.39500e-06 0.000
+ 3.39505e-06 1.800 3.39900e-06 1.800 3.39905e-06 0.000 3.40000e-06 0.000 3.40005e-06 1.800 3.40300e-06 1.800
+ 3.40305e-06 0.000 3.40500e-06 0.000 3.40505e-06 1.800 3.40600e-06 1.800 3.40605e-06 0.000 3.40700e-06 0.000
+ 3.40705e-06 1.800 3.40800e-06 1.800 3.40805e-06 0.000 3.40900e-06 0.000 3.40905e-06 1.800 3.41000e-06 1.800
+ 3.41005e-06 0.000 3.41100e-06 0.000 3.41105e-06 1.800 3.41200e-06 1.800 3.41205e-06 0.000 3.41300e-06 0.000
+ 3.41305e-06 1.800 3.41400e-06 1.800 3.41405e-06 0.000 3.41500e-06 0.000 3.41505e-06 1.800 3.41600e-06 1.800
+ 3.41605e-06 0.000 3.41800e-06 0.000 3.41805e-06 1.800 3.41900e-06 1.800 3.41905e-06 0.000 3.42000e-06 0.000
+ 3.42005e-06 1.800 3.42300e-06 1.800 3.42305e-06 0.000 3.42400e-06 0.000 3.42405e-06 1.800 3.42700e-06 1.800
+ 3.42705e-06 0.000 3.42900e-06 0.000 3.42905e-06 1.800 3.43100e-06 1.800 3.43105e-06 0.000 3.43200e-06 0.000
+ 3.43205e-06 1.800 3.43500e-06 1.800 3.43505e-06 0.000 3.43600e-06 0.000 3.43605e-06 1.800 3.44100e-06 1.800
+ 3.44105e-06 0.000 3.44500e-06 0.000 3.44505e-06 1.800 3.44700e-06 1.800 3.44705e-06 0.000 3.44900e-06 0.000
+ 3.44905e-06 1.800 3.45000e-06 1.800 3.45005e-06 0.000 3.45300e-06 0.000 3.45305e-06 1.800 3.45500e-06 1.800
+ 3.45505e-06 0.000 3.45600e-06 0.000 3.45605e-06 1.800 3.45700e-06 1.800 3.45705e-06 0.000 3.46000e-06 0.000
+ 3.46005e-06 1.800 3.46100e-06 1.800 3.46105e-06 0.000 3.46200e-06 0.000 3.46205e-06 1.800 3.46300e-06 1.800
+ 3.46305e-06 0.000 3.46500e-06 0.000 3.46505e-06 1.800 3.46600e-06 1.800 3.46605e-06 0.000 3.46700e-06 0.000
+ 3.46705e-06 1.800 3.46800e-06 1.800 3.46805e-06 0.000 3.46900e-06 0.000 3.46905e-06 1.800 3.47000e-06 1.800
+ 3.47005e-06 0.000 3.47200e-06 0.000 3.47205e-06 1.800 3.47300e-06 1.800 3.47305e-06 0.000 3.47500e-06 0.000
+ 3.47505e-06 1.800 3.47600e-06 1.800 3.47605e-06 0.000 3.47700e-06 0.000 3.47705e-06 1.800 3.48100e-06 1.800
+ 3.48105e-06 0.000 3.48200e-06 0.000 3.48205e-06 1.800 3.48400e-06 1.800 3.48405e-06 0.000 3.48500e-06 0.000
+ 3.48505e-06 1.800 3.48600e-06 1.800 3.48605e-06 0.000 3.48700e-06 0.000 3.48705e-06 1.800 3.48800e-06 1.800
+ 3.48805e-06 0.000 3.48900e-06 0.000 3.48905e-06 1.800 3.49000e-06 1.800 3.49005e-06 0.000 3.49100e-06 0.000
+ 3.49105e-06 1.800 3.49300e-06 1.800 3.49305e-06 0.000 3.49600e-06 0.000 3.49605e-06 1.800 3.49700e-06 1.800
+ 3.49705e-06 0.000 3.49800e-06 0.000 3.49805e-06 1.800 3.50000e-06 1.800 3.50005e-06 0.000 3.50700e-06 0.000
+ 3.50705e-06 1.800 3.50900e-06 1.800 3.50905e-06 0.000 3.51000e-06 0.000 3.51005e-06 1.800 3.51100e-06 1.800
+ 3.51105e-06 0.000 3.51200e-06 0.000 3.51205e-06 1.800 3.51300e-06 1.800 3.51305e-06 0.000 3.51400e-06 0.000
+ 3.51405e-06 1.800 3.51700e-06 1.800 3.51705e-06 0.000 3.51900e-06 0.000 3.51905e-06 1.800 3.52100e-06 1.800
+ 3.52105e-06 0.000 3.52200e-06 0.000 3.52205e-06 1.800 3.52400e-06 1.800 3.52405e-06 0.000 3.52500e-06 0.000
+ 3.52505e-06 1.800 3.52700e-06 1.800 3.52705e-06 0.000 3.53000e-06 0.000 3.53005e-06 1.800 3.53100e-06 1.800
+ 3.53105e-06 0.000 3.53200e-06 0.000 3.53205e-06 1.800 3.53500e-06 1.800 3.53505e-06 0.000 3.53600e-06 0.000
+ 3.53605e-06 1.800 3.53700e-06 1.800 3.53705e-06 0.000 3.53800e-06 0.000 3.53805e-06 1.800 3.54300e-06 1.800
+ 3.54305e-06 0.000 3.54400e-06 0.000 3.54405e-06 1.800 3.54500e-06 1.800 3.54505e-06 0.000 3.54700e-06 0.000
+ 3.54705e-06 1.800 3.55000e-06 1.800 3.55005e-06 0.000 3.55300e-06 0.000 3.55305e-06 1.800 3.55400e-06 1.800
+ 3.55405e-06 0.000 3.55500e-06 0.000 3.55505e-06 1.800 3.55600e-06 1.800 3.55605e-06 0.000 3.56000e-06 0.000
+ 3.56005e-06 1.800 3.56200e-06 1.800 3.56205e-06 0.000 3.56700e-06 0.000 3.56705e-06 1.800 3.56800e-06 1.800
+ 3.56805e-06 0.000 3.57000e-06 0.000 3.57005e-06 1.800 3.57300e-06 1.800 3.57305e-06 0.000 3.57500e-06 0.000
+ 3.57505e-06 1.800 3.57600e-06 1.800 3.57605e-06 0.000 3.57700e-06 0.000 3.57705e-06 1.800 3.57900e-06 1.800
+ 3.57905e-06 0.000 3.58100e-06 0.000 3.58105e-06 1.800 3.58200e-06 1.800 3.58205e-06 0.000 3.58400e-06 0.000
+ 3.58405e-06 1.800 3.59300e-06 1.800 3.59305e-06 0.000 3.59600e-06 0.000 3.59605e-06 1.800 3.60300e-06 1.800
+ 3.60305e-06 0.000 3.60600e-06 0.000 3.60605e-06 1.800 3.60700e-06 1.800 3.60705e-06 0.000 3.60900e-06 0.000
+ 3.60905e-06 1.800 3.61100e-06 1.800 3.61105e-06 0.000 3.61200e-06 0.000 3.61205e-06 1.800 3.61300e-06 1.800
+ 3.61305e-06 0.000 3.61500e-06 0.000 3.61505e-06 1.800 3.61600e-06 1.800 3.61605e-06 0.000 3.61800e-06 0.000
+ 3.61805e-06 1.800 3.62000e-06 1.800 3.62005e-06 0.000 3.62200e-06 0.000 3.62205e-06 1.800 3.62500e-06 1.800
+ 3.62505e-06 0.000 3.62700e-06 0.000 3.62705e-06 1.800 3.62800e-06 1.800 3.62805e-06 0.000 3.62900e-06 0.000
+ 3.62905e-06 1.800 3.63000e-06 1.800 3.63005e-06 0.000 3.63100e-06 0.000 3.63105e-06 1.800 3.64100e-06 1.800
+ 3.64105e-06 0.000 3.64200e-06 0.000 3.64205e-06 1.800 3.64300e-06 1.800 3.64305e-06 0.000 3.64800e-06 0.000
+ 3.64805e-06 1.800 3.65200e-06 1.800 3.65205e-06 0.000 3.65300e-06 0.000 3.65305e-06 1.800 3.65500e-06 1.800
+ 3.65505e-06 0.000 3.65700e-06 0.000 3.65705e-06 1.800 3.65800e-06 1.800 3.65805e-06 0.000 3.65900e-06 0.000
+ 3.65905e-06 1.800 3.66000e-06 1.800 3.66005e-06 0.000 3.66200e-06 0.000 3.66205e-06 1.800 3.66300e-06 1.800
+ 3.66305e-06 0.000 3.66500e-06 0.000 3.66505e-06 1.800 3.66800e-06 1.800 3.66805e-06 0.000 3.67000e-06 0.000
+ 3.67005e-06 1.800 3.67100e-06 1.800 3.67105e-06 0.000 3.67200e-06 0.000 3.67205e-06 1.800 3.67900e-06 1.800
+ 3.67905e-06 0.000 3.68000e-06 0.000 3.68005e-06 1.800 3.68200e-06 1.800 3.68205e-06 0.000 3.68400e-06 0.000
+ 3.68405e-06 1.800 3.68500e-06 1.800 3.68505e-06 0.000 3.68700e-06 0.000 3.68705e-06 1.800 3.68800e-06 1.800
+ 3.68805e-06 0.000 3.68900e-06 0.000 3.68905e-06 1.800 3.69000e-06 1.800 3.69005e-06 0.000 3.69300e-06 0.000
+ 3.69305e-06 1.800 3.69500e-06 1.800 3.69505e-06 0.000 3.69700e-06 0.000 3.69705e-06 1.800 3.69800e-06 1.800
+ 3.69805e-06 0.000 3.69900e-06 0.000 3.69905e-06 1.800 3.70100e-06 1.800 3.70105e-06 0.000 3.70200e-06 0.000
+ 3.70205e-06 1.800 3.70300e-06 1.800 3.70305e-06 0.000 3.70500e-06 0.000 3.70505e-06 1.800 3.70700e-06 1.800
+ 3.70705e-06 0.000 3.70800e-06 0.000 3.70805e-06 1.800 3.70900e-06 1.800 3.70905e-06 0.000 3.71100e-06 0.000
+ 3.71105e-06 1.800 3.71400e-06 1.800 3.71405e-06 0.000 3.71600e-06 0.000 3.71605e-06 1.800 3.71700e-06 1.800
+ 3.71705e-06 0.000 3.72100e-06 0.000 3.72105e-06 1.800 3.72300e-06 1.800 3.72305e-06 0.000 3.72500e-06 0.000
+ 3.72505e-06 1.800 3.72700e-06 1.800 3.72705e-06 0.000 3.72800e-06 0.000 3.72805e-06 1.800 3.72900e-06 1.800
+ 3.72905e-06 0.000 3.73100e-06 0.000 3.73105e-06 1.800 3.73300e-06 1.800 3.73305e-06 0.000 3.73400e-06 0.000
+ 3.73405e-06 1.800 3.73500e-06 1.800 3.73505e-06 0.000 3.73600e-06 0.000 3.73605e-06 1.800 3.73800e-06 1.800
+ 3.73805e-06 0.000 3.73900e-06 0.000 3.73905e-06 1.800 3.74000e-06 1.800 3.74005e-06 0.000 3.74100e-06 0.000
+ 3.74105e-06 1.800 3.74300e-06 1.800 3.74305e-06 0.000 3.74600e-06 0.000 3.74605e-06 1.800 3.74700e-06 1.800
+ 3.74705e-06 0.000 3.74800e-06 0.000 3.74805e-06 1.800 3.74900e-06 1.800 3.74905e-06 0.000 3.75100e-06 0.000
+ 3.75105e-06 1.800 3.75400e-06 1.800 3.75405e-06 0.000 3.76100e-06 0.000 3.76105e-06 1.800 3.76200e-06 1.800
+ 3.76205e-06 0.000 3.76400e-06 0.000 3.76405e-06 1.800 3.76600e-06 1.800 3.76605e-06 0.000 3.76800e-06 0.000
+ 3.76805e-06 1.800 3.76900e-06 1.800 3.76905e-06 0.000 3.77000e-06 0.000 3.77005e-06 1.800 3.77300e-06 1.800
+ 3.77305e-06 0.000 3.77400e-06 0.000 3.77405e-06 1.800 3.78000e-06 1.800 3.78005e-06 0.000 3.78100e-06 0.000
+ 3.78105e-06 1.800 3.78300e-06 1.800 3.78305e-06 0.000 3.78500e-06 0.000 3.78505e-06 1.800 3.78600e-06 1.800
+ 3.78605e-06 0.000 3.78700e-06 0.000 3.78705e-06 1.800 3.78800e-06 1.800 3.78805e-06 0.000 3.78900e-06 0.000
+ 3.78905e-06 1.800 3.79600e-06 1.800 3.79605e-06 0.000 3.79800e-06 0.000 3.79805e-06 1.800 3.80300e-06 1.800
+ 3.80305e-06 0.000 3.80500e-06 0.000 3.80505e-06 1.800 3.81100e-06 1.800 3.81105e-06 0.000 3.81400e-06 0.000
+ 3.81405e-06 1.800 3.81600e-06 1.800 3.81605e-06 0.000 3.81700e-06 0.000 3.81705e-06 1.800 3.81800e-06 1.800
+ 3.81805e-06 0.000 3.82300e-06 0.000 3.82305e-06 1.800 3.82500e-06 1.800 3.82505e-06 0.000 3.83000e-06 0.000
+ 3.83005e-06 1.800 3.83500e-06 1.800 3.83505e-06 0.000 3.83600e-06 0.000 3.83605e-06 1.800 3.83900e-06 1.800
+ 3.83905e-06 0.000 3.84100e-06 0.000 3.84105e-06 1.800 3.84400e-06 1.800 3.84405e-06 0.000 3.84800e-06 0.000
+ 3.84805e-06 1.800 3.85100e-06 1.800 3.85105e-06 0.000 3.85300e-06 0.000 3.85305e-06 1.800 3.85400e-06 1.800
+ 3.85405e-06 0.000 3.85700e-06 0.000 3.85705e-06 1.800 3.85900e-06 1.800 3.85905e-06 0.000 3.86100e-06 0.000
+ 3.86105e-06 1.800 3.87000e-06 1.800 3.87005e-06 0.000 3.87100e-06 0.000 3.87105e-06 1.800 3.87700e-06 1.800
+ 3.87705e-06 0.000 3.87900e-06 0.000 3.87905e-06 1.800 3.88000e-06 1.800 3.88005e-06 0.000 3.88300e-06 0.000
+ 3.88305e-06 1.800 3.88400e-06 1.800 3.88405e-06 0.000 3.88500e-06 0.000 3.88505e-06 1.800 3.88600e-06 1.800
+ 3.88605e-06 0.000 3.88800e-06 0.000 3.88805e-06 1.800 3.88900e-06 1.800 3.88905e-06 0.000 3.89000e-06 0.000
+ 3.89005e-06 1.800 3.89100e-06 1.800 3.89105e-06 0.000 3.89200e-06 0.000 3.89205e-06 1.800 3.89300e-06 1.800
+ 3.89305e-06 0.000 3.89500e-06 0.000 3.89505e-06 1.800 3.89800e-06 1.800 3.89805e-06 0.000 3.89900e-06 0.000
+ 3.89905e-06 1.800 3.90100e-06 1.800 3.90105e-06 0.000 3.90300e-06 0.000 3.90305e-06 1.800 3.90400e-06 1.800
+ 3.90405e-06 0.000 3.90500e-06 0.000 3.90505e-06 1.800 3.90800e-06 1.800 3.90805e-06 0.000 3.91000e-06 0.000
+ 3.91005e-06 1.800 3.91100e-06 1.800 3.91105e-06 0.000 3.91200e-06 0.000 3.91205e-06 1.800 3.91500e-06 1.800
+ 3.91505e-06 0.000 3.91700e-06 0.000 3.91705e-06 1.800 3.91900e-06 1.800 3.91905e-06 0.000 3.92000e-06 0.000
+ 3.92005e-06 1.800 3.92200e-06 1.800 3.92205e-06 0.000 3.92900e-06 0.000 3.92905e-06 1.800 3.93000e-06 1.800
+ 3.93005e-06 0.000 3.93200e-06 0.000 3.93205e-06 1.800 3.93300e-06 1.800 3.93305e-06 0.000 3.93500e-06 0.000
+ 3.93505e-06 1.800 3.93700e-06 1.800 3.93705e-06 0.000 3.93900e-06 0.000 3.93905e-06 1.800 3.94400e-06 1.800
+ 3.94405e-06 0.000 3.94500e-06 0.000 3.94505e-06 1.800 3.94600e-06 1.800 3.94605e-06 0.000 3.94900e-06 0.000
+ 3.94905e-06 1.800 3.95000e-06 1.800 3.95005e-06 0.000 3.95100e-06 0.000 3.95105e-06 1.800 3.95400e-06 1.800
+ 3.95405e-06 0.000 3.95500e-06 0.000 3.95505e-06 1.800 3.95700e-06 1.800 3.95705e-06 0.000 3.95900e-06 0.000
+ 3.95905e-06 1.800 3.96000e-06 1.800 3.96005e-06 0.000 3.96200e-06 0.000 3.96205e-06 1.800 3.96400e-06 1.800
+ 3.96405e-06 0.000 3.96500e-06 0.000 3.96505e-06 1.800 3.96600e-06 1.800 3.96605e-06 0.000 3.96700e-06 0.000
+ 3.96705e-06 1.800 3.96800e-06 1.800 3.96805e-06 0.000 3.96900e-06 0.000 3.96905e-06 1.800 3.97100e-06 1.800
+ 3.97105e-06 0.000 3.97600e-06 0.000 3.97605e-06 1.800 3.97800e-06 1.800 3.97805e-06 0.000 3.97900e-06 0.000
+ 3.97905e-06 1.800 3.98600e-06 1.800 3.98605e-06 0.000 3.98800e-06 0.000 3.98805e-06 1.800 3.98900e-06 1.800
+ 3.98905e-06 0.000 3.99100e-06 0.000 3.99105e-06 1.800 3.99200e-06 1.800 3.99205e-06 0.000 3.99600e-06 0.000
+ 3.99605e-06 1.800 3.99700e-06 1.800 3.99705e-06 0.000 4.00100e-06 0.000 4.00105e-06 1.800 4.00300e-06 1.800
+ 4.00305e-06 0.000 4.00600e-06 0.000 4.00605e-06 1.800 4.01200e-06 1.800 4.01205e-06 0.000 4.01400e-06 0.000
+ 4.01405e-06 1.800 4.01700e-06 1.800 4.01705e-06 0.000 4.01900e-06 0.000 4.01905e-06 1.800 4.02200e-06 1.800
+ 4.02205e-06 0.000 4.02300e-06 0.000 4.02305e-06 1.800 4.02400e-06 1.800 4.02405e-06 0.000 4.02600e-06 0.000
+ 4.02605e-06 1.800 4.02800e-06 1.800 4.02805e-06 0.000 4.03100e-06 0.000 4.03105e-06 1.800 4.03500e-06 1.800
+ 4.03505e-06 0.000 4.03800e-06 0.000 4.03805e-06 1.800 4.04100e-06 1.800 4.04105e-06 0.000 4.04200e-06 0.000
+ 4.04205e-06 1.800 4.04400e-06 1.800 4.04405e-06 0.000 4.04500e-06 0.000 4.04505e-06 1.800 4.04800e-06 1.800
+ 4.04805e-06 0.000 4.05100e-06 0.000 4.05105e-06 1.800 4.05300e-06 1.800 4.05305e-06 0.000 4.05400e-06 0.000
+ 4.05405e-06 1.800 4.05500e-06 1.800 4.05505e-06 0.000 4.05800e-06 0.000 4.05805e-06 1.800 4.05900e-06 1.800
+ 4.05905e-06 0.000 4.06000e-06 0.000 4.06005e-06 1.800 4.06100e-06 1.800 4.06105e-06 0.000 4.06200e-06 0.000
+ 4.06205e-06 1.800 4.06300e-06 1.800 4.06305e-06 0.000 4.06400e-06 0.000 4.06405e-06 1.800 4.06500e-06 1.800
+ 4.06505e-06 0.000 4.06600e-06 0.000 4.06605e-06 1.800 4.06900e-06 1.800 4.06905e-06 0.000 4.07000e-06 0.000
+ 4.07005e-06 1.800 4.07200e-06 1.800 4.07205e-06 0.000 4.07700e-06 0.000 4.07705e-06 1.800 4.07800e-06 1.800
+ 4.07805e-06 0.000 4.07900e-06 0.000 4.07905e-06 1.800 4.08000e-06 1.800 4.08005e-06 0.000 4.08200e-06 0.000
+ 4.08205e-06 1.800 4.08300e-06 1.800 4.08305e-06 0.000 4.08500e-06 0.000 4.08505e-06 1.800 4.08600e-06 1.800
+ 4.08605e-06 0.000 4.08800e-06 0.000 4.08805e-06 1.800 4.09100e-06 1.800 4.09105e-06 0.000 4.09200e-06 0.000
+ 4.09205e-06 1.800 4.09300e-06 1.800 4.09305e-06 0.000 4.09600e-06 0.000
+ )
Xd_b2 src_b2 b2 vdd gnd tb_inv
Va3 src_a3 gnd PWL(
+ 0.00000e+00 1.800 2.00000e-09 1.800 2.05000e-09 0.000 4.00000e-09 0.000 4.05000e-09 1.800 6.00000e-09 1.800
+ 6.05000e-09 0.000 8.00000e-09 0.000 8.05000e-09 1.800 1.00000e-08 1.800 1.00500e-08 0.000 1.20000e-08 0.000
+ 1.20500e-08 1.800 1.40000e-08 1.800 1.40500e-08 0.000 1.60000e-08 0.000 1.60500e-08 1.800 1.80000e-08 1.800
+ 1.80500e-08 0.000 2.00000e-08 0.000 2.00500e-08 1.800 2.20000e-08 1.800 2.20500e-08 0.000 2.40000e-08 0.000
+ 2.40500e-08 1.800 2.60000e-08 1.800 2.60500e-08 0.000 2.80000e-08 0.000 2.80500e-08 1.800 3.00000e-08 1.800
+ 3.00500e-08 0.000 3.20000e-08 0.000 3.20500e-08 1.800 3.40000e-08 1.800 3.40500e-08 0.000 3.60000e-08 0.000
+ 3.60500e-08 1.800 3.80000e-08 1.800 3.80500e-08 0.000 4.00000e-08 0.000 4.00500e-08 1.800 4.20000e-08 1.800
+ 4.20500e-08 0.000 4.40000e-08 0.000 4.40500e-08 1.800 4.60000e-08 1.800 4.60500e-08 0.000 4.80000e-08 0.000
+ 4.80500e-08 1.800 5.00000e-08 1.800 5.00500e-08 0.000 5.20000e-08 0.000 5.20500e-08 1.800 5.40000e-08 1.800
+ 5.40500e-08 0.000 5.60000e-08 0.000 5.60500e-08 1.800 5.80000e-08 1.800 5.80500e-08 0.000 6.00000e-08 0.000
+ 6.00500e-08 1.800 6.20000e-08 1.800 6.20500e-08 0.000 6.40000e-08 0.000 6.40500e-08 1.800 6.60000e-08 1.800
+ 6.60500e-08 0.000 6.80000e-08 0.000 6.80500e-08 1.800 7.00000e-08 1.800 7.00500e-08 0.000 7.20000e-08 0.000
+ 7.20500e-08 1.800 7.40000e-08 1.800 7.40500e-08 0.000 7.60000e-08 0.000 7.60500e-08 1.800 7.80000e-08 1.800
+ 7.80500e-08 0.000 8.00000e-08 0.000 8.00500e-08 1.800 8.20000e-08 1.800 8.20500e-08 0.000 8.40000e-08 0.000
+ 8.40500e-08 1.800 8.60000e-08 1.800 8.60500e-08 0.000 8.80000e-08 0.000 8.80500e-08 1.800 9.00000e-08 1.800
+ 9.00500e-08 0.000 9.20000e-08 0.000 9.20500e-08 1.800 9.40000e-08 1.800 9.40500e-08 0.000 9.60000e-08 0.000
+ 9.60500e-08 1.800 9.80000e-08 1.800 9.80500e-08 0.000 1.00000e-07 0.000 1.00050e-07 1.800 1.02000e-07 1.800
+ 1.02050e-07 0.000 1.04000e-07 0.000 1.04050e-07 1.800 1.06000e-07 1.800 1.06050e-07 0.000 1.08000e-07 0.000
+ 1.08050e-07 1.800 1.10000e-07 1.800 1.10050e-07 0.000 1.12000e-07 0.000 1.12050e-07 1.800 1.14000e-07 1.800
+ 1.14050e-07 0.000 1.16000e-07 0.000 1.16050e-07 1.800 1.18000e-07 1.800 1.18050e-07 0.000 1.20000e-07 0.000
+ 1.20050e-07 1.800 1.22000e-07 1.800 1.22050e-07 0.000 1.24000e-07 0.000 1.24050e-07 1.800 1.26000e-07 1.800
+ 1.26050e-07 0.000 1.28000e-07 0.000 1.28050e-07 1.800 1.30000e-07 1.800 1.30050e-07 0.000 1.32000e-07 0.000
+ 1.32050e-07 1.800 1.34000e-07 1.800 1.34050e-07 0.000 1.36000e-07 0.000 1.36050e-07 1.800 1.38000e-07 1.800
+ 1.38050e-07 0.000 1.40000e-07 0.000 1.40050e-07 1.800 1.42000e-07 1.800 1.42050e-07 0.000 1.44000e-07 0.000
+ 1.44050e-07 1.800 1.46000e-07 1.800 1.46050e-07 0.000 1.48000e-07 0.000 1.48050e-07 1.800 1.50000e-07 1.800
+ 1.50050e-07 0.000 1.52000e-07 0.000 1.52050e-07 1.800 1.54000e-07 1.800 1.54050e-07 0.000 1.56000e-07 0.000
+ 1.56050e-07 1.800 1.58000e-07 1.800 1.58050e-07 0.000 1.60000e-07 0.000 1.60050e-07 1.800 1.62000e-07 1.800
+ 1.62050e-07 0.000 1.64000e-07 0.000 1.64050e-07 1.800 1.66000e-07 1.800 1.66050e-07 0.000 1.68000e-07 0.000
+ 1.68050e-07 1.800 1.70000e-07 1.800 1.70050e-07 0.000 1.72000e-07 0.000 1.72050e-07 1.800 1.74000e-07 1.800
+ 1.74050e-07 0.000 1.76000e-07 0.000 1.76050e-07 1.800 1.78000e-07 1.800 1.78050e-07 0.000 1.80000e-07 0.000
+ 1.80050e-07 1.800 1.82000e-07 1.800 1.82050e-07 0.000 1.84000e-07 0.000 1.84050e-07 1.800 1.86000e-07 1.800
+ 1.86050e-07 0.000 1.88000e-07 0.000 1.88050e-07 1.800 1.90000e-07 1.800 1.90050e-07 0.000 1.92000e-07 0.000
+ 1.92050e-07 1.800 1.94000e-07 1.800 1.94050e-07 0.000 1.96000e-07 0.000 1.96050e-07 1.800 1.98000e-07 1.800
+ 1.98050e-07 0.000 2.00000e-07 0.000 2.00050e-07 1.800 2.02000e-07 1.800 2.02050e-07 0.000 2.04000e-07 0.000
+ 2.04050e-07 1.800 2.06000e-07 1.800 2.06050e-07 0.000 2.08000e-07 0.000 2.08050e-07 1.800 2.10000e-07 1.800
+ 2.10050e-07 0.000 2.12000e-07 0.000 2.12050e-07 1.800 2.14000e-07 1.800 2.14050e-07 0.000 2.16000e-07 0.000
+ 2.16050e-07 1.800 2.18000e-07 1.800 2.18050e-07 0.000 2.20000e-07 0.000 2.20050e-07 1.800 2.22000e-07 1.800
+ 2.22050e-07 0.000 2.24000e-07 0.000 2.24050e-07 1.800 2.26000e-07 1.800 2.26050e-07 0.000 2.28000e-07 0.000
+ 2.28050e-07 1.800 2.30000e-07 1.800 2.30050e-07 0.000 2.32000e-07 0.000 2.32050e-07 1.800 2.34000e-07 1.800
+ 2.34050e-07 0.000 2.36000e-07 0.000 2.36050e-07 1.800 2.38000e-07 1.800 2.38050e-07 0.000 2.40000e-07 0.000
+ 2.40050e-07 1.800 2.42000e-07 1.800 2.42050e-07 0.000 2.44000e-07 0.000 2.44050e-07 1.800 2.46000e-07 1.800
+ 2.46050e-07 0.000 2.48000e-07 0.000 2.48050e-07 1.800 2.50000e-07 1.800 2.50050e-07 0.000 2.52000e-07 0.000
+ 2.52050e-07 1.800 2.54000e-07 1.800 2.54050e-07 0.000 2.56000e-07 0.000 2.56050e-07 1.800 2.58000e-07 1.800
+ 2.58050e-07 0.000 2.60000e-07 0.000 2.60050e-07 1.800 2.62000e-07 1.800 2.62050e-07 0.000 2.64000e-07 0.000
+ 2.64050e-07 1.800 2.66000e-07 1.800 2.66050e-07 0.000 2.68000e-07 0.000 2.68050e-07 1.800 2.70000e-07 1.800
+ 2.70050e-07 0.000 2.72000e-07 0.000 2.72050e-07 1.800 2.74000e-07 1.800 2.74050e-07 0.000 2.76000e-07 0.000
+ 2.76050e-07 1.800 2.78000e-07 1.800 2.78050e-07 0.000 2.80000e-07 0.000 2.80050e-07 1.800 2.82000e-07 1.800
+ 2.82050e-07 0.000 2.84000e-07 0.000 2.84050e-07 1.800 2.86000e-07 1.800 2.86050e-07 0.000 2.88000e-07 0.000
+ 2.88050e-07 1.800 2.90000e-07 1.800 2.90050e-07 0.000 2.92000e-07 0.000 2.92050e-07 1.800 2.94000e-07 1.800
+ 2.94050e-07 0.000 2.96000e-07 0.000 2.96050e-07 1.800 2.98000e-07 1.800 2.98050e-07 0.000 3.00000e-07 0.000
+ 3.00050e-07 1.800 3.02000e-07 1.800 3.02050e-07 0.000 3.04000e-07 0.000 3.04050e-07 1.800 3.06000e-07 1.800
+ 3.06050e-07 0.000 3.08000e-07 0.000 3.08050e-07 1.800 3.10000e-07 1.800 3.10050e-07 0.000 3.12000e-07 0.000
+ 3.12050e-07 1.800 3.14000e-07 1.800 3.14050e-07 0.000 3.16000e-07 0.000 3.16050e-07 1.800 3.18000e-07 1.800
+ 3.18050e-07 0.000 3.20000e-07 0.000 3.20050e-07 1.800 3.22000e-07 1.800 3.22050e-07 0.000 3.24000e-07 0.000
+ 3.24050e-07 1.800 3.26000e-07 1.800 3.26050e-07 0.000 3.28000e-07 0.000 3.28050e-07 1.800 3.30000e-07 1.800
+ 3.30050e-07 0.000 3.32000e-07 0.000 3.32050e-07 1.800 3.34000e-07 1.800 3.34050e-07 0.000 3.36000e-07 0.000
+ 3.36050e-07 1.800 3.38000e-07 1.800 3.38050e-07 0.000 3.40000e-07 0.000 3.40050e-07 1.800 3.42000e-07 1.800
+ 3.42050e-07 0.000 3.44000e-07 0.000 3.44050e-07 1.800 3.46000e-07 1.800 3.46050e-07 0.000 3.48000e-07 0.000
+ 3.48050e-07 1.800 3.50000e-07 1.800 3.50050e-07 0.000 3.52000e-07 0.000 3.52050e-07 1.800 3.54000e-07 1.800
+ 3.54050e-07 0.000 3.56000e-07 0.000 3.56050e-07 1.800 3.58000e-07 1.800 3.58050e-07 0.000 3.60000e-07 0.000
+ 3.60050e-07 1.800 3.62000e-07 1.800 3.62050e-07 0.000 3.64000e-07 0.000 3.64050e-07 1.800 3.66000e-07 1.800
+ 3.66050e-07 0.000 3.68000e-07 0.000 3.68050e-07 1.800 3.70000e-07 1.800 3.70050e-07 0.000 3.72000e-07 0.000
+ 3.72050e-07 1.800 3.74000e-07 1.800 3.74050e-07 0.000 3.76000e-07 0.000 3.76050e-07 1.800 3.78000e-07 1.800
+ 3.78050e-07 0.000 3.80000e-07 0.000 3.80050e-07 1.800 3.82000e-07 1.800 3.82050e-07 0.000 3.84000e-07 0.000
+ 3.84050e-07 1.800 3.86000e-07 1.800 3.86050e-07 0.000 3.88000e-07 0.000 3.88050e-07 1.800 3.90000e-07 1.800
+ 3.90050e-07 0.000 3.92000e-07 0.000 3.92050e-07 1.800 3.94000e-07 1.800 3.94050e-07 0.000 3.96000e-07 0.000
+ 3.96050e-07 1.800 3.98000e-07 1.800 3.98050e-07 0.000 4.00000e-07 0.000 4.00050e-07 1.800 4.02000e-07 1.800
+ 4.02050e-07 0.000 4.04000e-07 0.000 4.04050e-07 1.800 4.06000e-07 1.800 4.06050e-07 0.000 4.08000e-07 0.000
+ 4.08050e-07 1.800 4.10000e-07 1.800 4.10050e-07 0.000 4.12000e-07 0.000 4.12050e-07 1.800 4.14000e-07 1.800
+ 4.14050e-07 0.000 4.16000e-07 0.000 4.16050e-07 1.800 4.18000e-07 1.800 4.18050e-07 0.000 4.20000e-07 0.000
+ 4.20050e-07 1.800 4.22000e-07 1.800 4.22050e-07 0.000 4.24000e-07 0.000 4.24050e-07 1.800 4.26000e-07 1.800
+ 4.26050e-07 0.000 4.28000e-07 0.000 4.28050e-07 1.800 4.30000e-07 1.800 4.30050e-07 0.000 4.32000e-07 0.000
+ 4.32050e-07 1.800 4.34000e-07 1.800 4.34050e-07 0.000 4.36000e-07 0.000 4.36050e-07 1.800 4.38000e-07 1.800
+ 4.38050e-07 0.000 4.40000e-07 0.000 4.40050e-07 1.800 4.42000e-07 1.800 4.42050e-07 0.000 4.44000e-07 0.000
+ 4.44050e-07 1.800 4.46000e-07 1.800 4.46050e-07 0.000 4.48000e-07 0.000 4.48050e-07 1.800 4.50000e-07 1.800
+ 4.50050e-07 0.000 4.52000e-07 0.000 4.52050e-07 1.800 4.54000e-07 1.800 4.54050e-07 0.000 4.56000e-07 0.000
+ 4.56050e-07 1.800 4.58000e-07 1.800 4.58050e-07 0.000 4.60000e-07 0.000 4.60050e-07 1.800 4.62000e-07 1.800
+ 4.62050e-07 0.000 4.64000e-07 0.000 4.64050e-07 1.800 4.66000e-07 1.800 4.66050e-07 0.000 4.68000e-07 0.000
+ 4.68050e-07 1.800 4.70000e-07 1.800 4.70050e-07 0.000 4.72000e-07 0.000 4.72050e-07 1.800 4.74000e-07 1.800
+ 4.74050e-07 0.000 4.76000e-07 0.000 4.76050e-07 1.800 4.78000e-07 1.800 4.78050e-07 0.000 4.80000e-07 0.000
+ 4.80050e-07 1.800 4.82000e-07 1.800 4.82050e-07 0.000 4.84000e-07 0.000 4.84050e-07 1.800 4.86000e-07 1.800
+ 4.86050e-07 0.000 4.88000e-07 0.000 4.88050e-07 1.800 4.90000e-07 1.800 4.90050e-07 0.000 4.92000e-07 0.000
+ 4.92050e-07 1.800 4.94000e-07 1.800 4.94050e-07 0.000 4.96000e-07 0.000 4.96050e-07 1.800 4.98000e-07 1.800
+ 4.98050e-07 0.000 5.00000e-07 0.000 5.00050e-07 1.800 5.02000e-07 1.800 5.02050e-07 0.000 5.04000e-07 0.000
+ 5.04050e-07 1.800 5.06000e-07 1.800 5.06050e-07 0.000 5.08000e-07 0.000 5.08050e-07 1.800 5.10000e-07 1.800
+ 5.10050e-07 0.000 5.12000e-07 0.000 5.12050e-07 1.800 5.14000e-07 1.800 5.14050e-07 0.000 5.16000e-07 0.000
+ 5.16050e-07 1.800 5.18000e-07 1.800 5.18050e-07 0.000 5.20000e-07 0.000 5.20050e-07 1.800 5.22000e-07 1.800
+ 5.22050e-07 0.000 5.24000e-07 0.000 5.24050e-07 1.800 5.26000e-07 1.800 5.26050e-07 0.000 5.28000e-07 0.000
+ 5.28050e-07 1.800 5.30000e-07 1.800 5.30050e-07 0.000 5.32000e-07 0.000 5.32050e-07 1.800 5.34000e-07 1.800
+ 5.34050e-07 0.000 5.36000e-07 0.000 5.36050e-07 1.800 5.38000e-07 1.800 5.38050e-07 0.000 5.40000e-07 0.000
+ 5.40050e-07 1.800 5.42000e-07 1.800 5.42050e-07 0.000 5.44000e-07 0.000 5.44050e-07 1.800 5.46000e-07 1.800
+ 5.46050e-07 0.000 5.48000e-07 0.000 5.48050e-07 1.800 5.50000e-07 1.800 5.50050e-07 0.000 5.52000e-07 0.000
+ 5.52050e-07 1.800 5.54000e-07 1.800 5.54050e-07 0.000 5.56000e-07 0.000 5.56050e-07 1.800 5.58000e-07 1.800
+ 5.58050e-07 0.000 5.60000e-07 0.000 5.60050e-07 1.800 5.62000e-07 1.800 5.62050e-07 0.000 5.64000e-07 0.000
+ 5.64050e-07 1.800 5.66000e-07 1.800 5.66050e-07 0.000 5.68000e-07 0.000 5.68050e-07 1.800 5.70000e-07 1.800
+ 5.70050e-07 0.000 5.72000e-07 0.000 5.72050e-07 1.800 5.74000e-07 1.800 5.74050e-07 0.000 5.76000e-07 0.000
+ 5.76050e-07 1.800 5.78000e-07 1.800 5.78050e-07 0.000 5.80000e-07 0.000 5.80050e-07 1.800 5.82000e-07 1.800
+ 5.82050e-07 0.000 5.84000e-07 0.000 5.84050e-07 1.800 5.86000e-07 1.800 5.86050e-07 0.000 5.88000e-07 0.000
+ 5.88050e-07 1.800 5.90000e-07 1.800 5.90050e-07 0.000 5.92000e-07 0.000 5.92050e-07 1.800 5.94000e-07 1.800
+ 5.94050e-07 0.000 5.96000e-07 0.000 5.96050e-07 1.800 5.98000e-07 1.800 5.98050e-07 0.000 6.00000e-07 0.000
+ 6.00050e-07 1.800 6.02000e-07 1.800 6.02050e-07 0.000 6.04000e-07 0.000 6.04050e-07 1.800 6.06000e-07 1.800
+ 6.06050e-07 0.000 6.08000e-07 0.000 6.08050e-07 1.800 6.10000e-07 1.800 6.10050e-07 0.000 6.12000e-07 0.000
+ 6.12050e-07 1.800 6.14000e-07 1.800 6.14050e-07 0.000 6.16000e-07 0.000 6.16050e-07 1.800 6.18000e-07 1.800
+ 6.18050e-07 0.000 6.20000e-07 0.000 6.20050e-07 1.800 6.22000e-07 1.800 6.22050e-07 0.000 6.24000e-07 0.000
+ 6.24050e-07 1.800 6.26000e-07 1.800 6.26050e-07 0.000 6.28000e-07 0.000 6.28050e-07 1.800 6.30000e-07 1.800
+ 6.30050e-07 0.000 6.32000e-07 0.000 6.32050e-07 1.800 6.34000e-07 1.800 6.34050e-07 0.000 6.36000e-07 0.000
+ 6.36050e-07 1.800 6.38000e-07 1.800 6.38050e-07 0.000 6.40000e-07 0.000 6.40050e-07 1.800 6.42000e-07 1.800
+ 6.42050e-07 0.000 6.44000e-07 0.000 6.44050e-07 1.800 6.46000e-07 1.800 6.46050e-07 0.000 6.48000e-07 0.000
+ 6.48050e-07 1.800 6.50000e-07 1.800 6.50050e-07 0.000 6.52000e-07 0.000 6.52050e-07 1.800 6.54000e-07 1.800
+ 6.54050e-07 0.000 6.56000e-07 0.000 6.56050e-07 1.800 6.58000e-07 1.800 6.58050e-07 0.000 6.60000e-07 0.000
+ 6.60050e-07 1.800 6.62000e-07 1.800 6.62050e-07 0.000 6.64000e-07 0.000 6.64050e-07 1.800 6.66000e-07 1.800
+ 6.66050e-07 0.000 6.68000e-07 0.000 6.68050e-07 1.800 6.70000e-07 1.800 6.70050e-07 0.000 6.72000e-07 0.000
+ 6.72050e-07 1.800 6.74000e-07 1.800 6.74050e-07 0.000 6.76000e-07 0.000 6.76050e-07 1.800 6.78000e-07 1.800
+ 6.78050e-07 0.000 6.80000e-07 0.000 6.80050e-07 1.800 6.82000e-07 1.800 6.82050e-07 0.000 6.84000e-07 0.000
+ 6.84050e-07 1.800 6.86000e-07 1.800 6.86050e-07 0.000 6.88000e-07 0.000 6.88050e-07 1.800 6.90000e-07 1.800
+ 6.90050e-07 0.000 6.92000e-07 0.000 6.92050e-07 1.800 6.94000e-07 1.800 6.94050e-07 0.000 6.96000e-07 0.000
+ 6.96050e-07 1.800 6.98000e-07 1.800 6.98050e-07 0.000 7.00000e-07 0.000 7.00050e-07 1.800 7.02000e-07 1.800
+ 7.02050e-07 0.000 7.04000e-07 0.000 7.04050e-07 1.800 7.06000e-07 1.800 7.06050e-07 0.000 7.08000e-07 0.000
+ 7.08050e-07 1.800 7.10000e-07 1.800 7.10050e-07 0.000 7.12000e-07 0.000 7.12050e-07 1.800 7.14000e-07 1.800
+ 7.14050e-07 0.000 7.16000e-07 0.000 7.16050e-07 1.800 7.18000e-07 1.800 7.18050e-07 0.000 7.20000e-07 0.000
+ 7.20050e-07 1.800 7.22000e-07 1.800 7.22050e-07 0.000 7.24000e-07 0.000 7.24050e-07 1.800 7.26000e-07 1.800
+ 7.26050e-07 0.000 7.28000e-07 0.000 7.28050e-07 1.800 7.30000e-07 1.800 7.30050e-07 0.000 7.32000e-07 0.000
+ 7.32050e-07 1.800 7.34000e-07 1.800 7.34050e-07 0.000 7.36000e-07 0.000 7.36050e-07 1.800 7.38000e-07 1.800
+ 7.38050e-07 0.000 7.40000e-07 0.000 7.40050e-07 1.800 7.42000e-07 1.800 7.42050e-07 0.000 7.44000e-07 0.000
+ 7.44050e-07 1.800 7.46000e-07 1.800 7.46050e-07 0.000 7.48000e-07 0.000 7.48050e-07 1.800 7.50000e-07 1.800
+ 7.50050e-07 0.000 7.52000e-07 0.000 7.52050e-07 1.800 7.54000e-07 1.800 7.54050e-07 0.000 7.56000e-07 0.000
+ 7.56050e-07 1.800 7.58000e-07 1.800 7.58050e-07 0.000 7.60000e-07 0.000 7.60050e-07 1.800 7.62000e-07 1.800
+ 7.62050e-07 0.000 7.64000e-07 0.000 7.64050e-07 1.800 7.66000e-07 1.800 7.66050e-07 0.000 7.68000e-07 0.000
+ 7.68050e-07 1.800 7.70000e-07 1.800 7.70050e-07 0.000 7.72000e-07 0.000 7.72050e-07 1.800 7.74000e-07 1.800
+ 7.74050e-07 0.000 7.76000e-07 0.000 7.76050e-07 1.800 7.78000e-07 1.800 7.78050e-07 0.000 7.80000e-07 0.000
+ 7.80050e-07 1.800 7.82000e-07 1.800 7.82050e-07 0.000 7.84000e-07 0.000 7.84050e-07 1.800 7.86000e-07 1.800
+ 7.86050e-07 0.000 7.88000e-07 0.000 7.88050e-07 1.800 7.90000e-07 1.800 7.90050e-07 0.000 7.92000e-07 0.000
+ 7.92050e-07 1.800 7.94000e-07 1.800 7.94050e-07 0.000 7.96000e-07 0.000 7.96050e-07 1.800 7.98000e-07 1.800
+ 7.98050e-07 0.000 8.00000e-07 0.000 8.00050e-07 1.800 8.02000e-07 1.800 8.02050e-07 0.000 8.04000e-07 0.000
+ 8.04050e-07 1.800 8.06000e-07 1.800 8.06050e-07 0.000 8.08000e-07 0.000 8.08050e-07 1.800 8.10000e-07 1.800
+ 8.10050e-07 0.000 8.12000e-07 0.000 8.12050e-07 1.800 8.14000e-07 1.800 8.14050e-07 0.000 8.16000e-07 0.000
+ 8.16050e-07 1.800 8.18000e-07 1.800 8.18050e-07 0.000 8.20000e-07 0.000 8.20050e-07 1.800 8.22000e-07 1.800
+ 8.22050e-07 0.000 8.24000e-07 0.000 8.24050e-07 1.800 8.26000e-07 1.800 8.26050e-07 0.000 8.28000e-07 0.000
+ 8.28050e-07 1.800 8.30000e-07 1.800 8.30050e-07 0.000 8.32000e-07 0.000 8.32050e-07 1.800 8.34000e-07 1.800
+ 8.34050e-07 0.000 8.36000e-07 0.000 8.36050e-07 1.800 8.38000e-07 1.800 8.38050e-07 0.000 8.40000e-07 0.000
+ 8.40050e-07 1.800 8.42000e-07 1.800 8.42050e-07 0.000 8.44000e-07 0.000 8.44050e-07 1.800 8.46000e-07 1.800
+ 8.46050e-07 0.000 8.48000e-07 0.000 8.48050e-07 1.800 8.50000e-07 1.800 8.50050e-07 0.000 8.52000e-07 0.000
+ 8.52050e-07 1.800 8.54000e-07 1.800 8.54050e-07 0.000 8.56000e-07 0.000 8.56050e-07 1.800 8.58000e-07 1.800
+ 8.58050e-07 0.000 8.60000e-07 0.000 8.60050e-07 1.800 8.62000e-07 1.800 8.62050e-07 0.000 8.64000e-07 0.000
+ 8.64050e-07 1.800 8.66000e-07 1.800 8.66050e-07 0.000 8.68000e-07 0.000 8.68050e-07 1.800 8.70000e-07 1.800
+ 8.70050e-07 0.000 8.72000e-07 0.000 8.72050e-07 1.800 8.74000e-07 1.800 8.74050e-07 0.000 8.76000e-07 0.000
+ 8.76050e-07 1.800 8.78000e-07 1.800 8.78050e-07 0.000 8.80000e-07 0.000 8.80050e-07 1.800 8.82000e-07 1.800
+ 8.82050e-07 0.000 8.84000e-07 0.000 8.84050e-07 1.800 8.86000e-07 1.800 8.86050e-07 0.000 8.88000e-07 0.000
+ 8.88050e-07 1.800 8.90000e-07 1.800 8.90050e-07 0.000 8.92000e-07 0.000 8.92050e-07 1.800 8.94000e-07 1.800
+ 8.94050e-07 0.000 8.96000e-07 0.000 8.96050e-07 1.800 8.98000e-07 1.800 8.98050e-07 0.000 9.00000e-07 0.000
+ 9.00050e-07 1.800 9.02000e-07 1.800 9.02050e-07 0.000 9.04000e-07 0.000 9.04050e-07 1.800 9.06000e-07 1.800
+ 9.06050e-07 0.000 9.08000e-07 0.000 9.08050e-07 1.800 9.10000e-07 1.800 9.10050e-07 0.000 9.12000e-07 0.000
+ 9.12050e-07 1.800 9.14000e-07 1.800 9.14050e-07 0.000 9.16000e-07 0.000 9.16050e-07 1.800 9.18000e-07 1.800
+ 9.18050e-07 0.000 9.20000e-07 0.000 9.20050e-07 1.800 9.22000e-07 1.800 9.22050e-07 0.000 9.24000e-07 0.000
+ 9.24050e-07 1.800 9.26000e-07 1.800 9.26050e-07 0.000 9.28000e-07 0.000 9.28050e-07 1.800 9.30000e-07 1.800
+ 9.30050e-07 0.000 9.32000e-07 0.000 9.32050e-07 1.800 9.34000e-07 1.800 9.34050e-07 0.000 9.36000e-07 0.000
+ 9.36050e-07 1.800 9.38000e-07 1.800 9.38050e-07 0.000 9.40000e-07 0.000 9.40050e-07 1.800 9.42000e-07 1.800
+ 9.42050e-07 0.000 9.44000e-07 0.000 9.44050e-07 1.800 9.46000e-07 1.800 9.46050e-07 0.000 9.48000e-07 0.000
+ 9.48050e-07 1.800 9.50000e-07 1.800 9.50050e-07 0.000 9.52000e-07 0.000 9.52050e-07 1.800 9.54000e-07 1.800
+ 9.54050e-07 0.000 9.56000e-07 0.000 9.56050e-07 1.800 9.58000e-07 1.800 9.58050e-07 0.000 9.60000e-07 0.000
+ 9.60050e-07 1.800 9.62000e-07 1.800 9.62050e-07 0.000 9.64000e-07 0.000 9.64050e-07 1.800 9.66000e-07 1.800
+ 9.66050e-07 0.000 9.68000e-07 0.000 9.68050e-07 1.800 9.70000e-07 1.800 9.70050e-07 0.000 9.72000e-07 0.000
+ 9.72050e-07 1.800 9.74000e-07 1.800 9.74050e-07 0.000 9.76000e-07 0.000 9.76050e-07 1.800 9.78000e-07 1.800
+ 9.78050e-07 0.000 9.80000e-07 0.000 9.80050e-07 1.800 9.82000e-07 1.800 9.82050e-07 0.000 9.84000e-07 0.000
+ 9.84050e-07 1.800 9.86000e-07 1.800 9.86050e-07 0.000 9.88000e-07 0.000 9.88050e-07 1.800 9.90000e-07 1.800
+ 9.90050e-07 0.000 9.92000e-07 0.000 9.92050e-07 1.800 9.94000e-07 1.800 9.94050e-07 0.000 9.96000e-07 0.000
+ 9.96050e-07 1.800 9.98000e-07 1.800 9.98050e-07 0.000 1.00000e-06 0.000 1.00005e-06 1.800 1.00200e-06 1.800
+ 1.00205e-06 0.000 1.00400e-06 0.000 1.00405e-06 1.800 1.00600e-06 1.800 1.00605e-06 0.000 1.00800e-06 0.000
+ 1.00805e-06 1.800 1.01000e-06 1.800 1.01005e-06 0.000 1.01200e-06 0.000 1.01205e-06 1.800 1.01400e-06 1.800
+ 1.01405e-06 0.000 1.01600e-06 0.000 1.01605e-06 1.800 1.01800e-06 1.800 1.01805e-06 0.000 1.02000e-06 0.000
+ 1.02005e-06 1.800 1.02200e-06 1.800 1.02205e-06 0.000 1.02400e-06 0.000 1.02405e-06 1.800 1.02600e-06 1.800
+ 1.02605e-06 0.000 1.02800e-06 0.000 1.02805e-06 1.800 1.03000e-06 1.800 1.03005e-06 0.000 1.03200e-06 0.000
+ 1.03205e-06 1.800 1.03400e-06 1.800 1.03405e-06 0.000 1.03600e-06 0.000 1.03605e-06 1.800 1.03800e-06 1.800
+ 1.03805e-06 0.000 1.04000e-06 0.000 1.04005e-06 1.800 1.04200e-06 1.800 1.04205e-06 0.000 1.04400e-06 0.000
+ 1.04405e-06 1.800 1.04600e-06 1.800 1.04605e-06 0.000 1.04800e-06 0.000 1.04805e-06 1.800 1.05000e-06 1.800
+ 1.05005e-06 0.000 1.05200e-06 0.000 1.05205e-06 1.800 1.05400e-06 1.800 1.05405e-06 0.000 1.05600e-06 0.000
+ 1.05605e-06 1.800 1.05800e-06 1.800 1.05805e-06 0.000 1.06000e-06 0.000 1.06005e-06 1.800 1.06200e-06 1.800
+ 1.06205e-06 0.000 1.06400e-06 0.000 1.06405e-06 1.800 1.06600e-06 1.800 1.06605e-06 0.000 1.06800e-06 0.000
+ 1.06805e-06 1.800 1.07000e-06 1.800 1.07005e-06 0.000 1.07200e-06 0.000 1.07205e-06 1.800 1.07400e-06 1.800
+ 1.07405e-06 0.000 1.07600e-06 0.000 1.07605e-06 1.800 1.07800e-06 1.800 1.07805e-06 0.000 1.08000e-06 0.000
+ 1.08005e-06 1.800 1.08200e-06 1.800 1.08205e-06 0.000 1.08400e-06 0.000 1.08405e-06 1.800 1.08600e-06 1.800
+ 1.08605e-06 0.000 1.08800e-06 0.000 1.08805e-06 1.800 1.09000e-06 1.800 1.09005e-06 0.000 1.09200e-06 0.000
+ 1.09205e-06 1.800 1.09400e-06 1.800 1.09405e-06 0.000 1.09600e-06 0.000 1.09605e-06 1.800 1.09800e-06 1.800
+ 1.09805e-06 0.000 1.10000e-06 0.000 1.10005e-06 1.800 1.10200e-06 1.800 1.10205e-06 0.000 1.10400e-06 0.000
+ 1.10405e-06 1.800 1.10600e-06 1.800 1.10605e-06 0.000 1.10800e-06 0.000 1.10805e-06 1.800 1.11000e-06 1.800
+ 1.11005e-06 0.000 1.11200e-06 0.000 1.11205e-06 1.800 1.11400e-06 1.800 1.11405e-06 0.000 1.11600e-06 0.000
+ 1.11605e-06 1.800 1.11800e-06 1.800 1.11805e-06 0.000 1.12000e-06 0.000 1.12005e-06 1.800 1.12200e-06 1.800
+ 1.12205e-06 0.000 1.12400e-06 0.000 1.12405e-06 1.800 1.12600e-06 1.800 1.12605e-06 0.000 1.12800e-06 0.000
+ 1.12805e-06 1.800 1.13000e-06 1.800 1.13005e-06 0.000 1.13200e-06 0.000 1.13205e-06 1.800 1.13400e-06 1.800
+ 1.13405e-06 0.000 1.13600e-06 0.000 1.13605e-06 1.800 1.13800e-06 1.800 1.13805e-06 0.000 1.14000e-06 0.000
+ 1.14005e-06 1.800 1.14200e-06 1.800 1.14205e-06 0.000 1.14400e-06 0.000 1.14405e-06 1.800 1.14600e-06 1.800
+ 1.14605e-06 0.000 1.14800e-06 0.000 1.14805e-06 1.800 1.15000e-06 1.800 1.15005e-06 0.000 1.15200e-06 0.000
+ 1.15205e-06 1.800 1.15400e-06 1.800 1.15405e-06 0.000 1.15600e-06 0.000 1.15605e-06 1.800 1.15800e-06 1.800
+ 1.15805e-06 0.000 1.16000e-06 0.000 1.16005e-06 1.800 1.16200e-06 1.800 1.16205e-06 0.000 1.16400e-06 0.000
+ 1.16405e-06 1.800 1.16600e-06 1.800 1.16605e-06 0.000 1.16800e-06 0.000 1.16805e-06 1.800 1.17000e-06 1.800
+ 1.17005e-06 0.000 1.17200e-06 0.000 1.17205e-06 1.800 1.17400e-06 1.800 1.17405e-06 0.000 1.17600e-06 0.000
+ 1.17605e-06 1.800 1.17800e-06 1.800 1.17805e-06 0.000 1.18000e-06 0.000 1.18005e-06 1.800 1.18200e-06 1.800
+ 1.18205e-06 0.000 1.18400e-06 0.000 1.18405e-06 1.800 1.18600e-06 1.800 1.18605e-06 0.000 1.18800e-06 0.000
+ 1.18805e-06 1.800 1.19000e-06 1.800 1.19005e-06 0.000 1.19200e-06 0.000 1.19205e-06 1.800 1.19400e-06 1.800
+ 1.19405e-06 0.000 1.19600e-06 0.000 1.19605e-06 1.800 1.19800e-06 1.800 1.19805e-06 0.000 1.20000e-06 0.000
+ 1.20005e-06 1.800 1.20200e-06 1.800 1.20205e-06 0.000 1.20400e-06 0.000 1.20405e-06 1.800 1.20600e-06 1.800
+ 1.20605e-06 0.000 1.20800e-06 0.000 1.20805e-06 1.800 1.21000e-06 1.800 1.21005e-06 0.000 1.21200e-06 0.000
+ 1.21205e-06 1.800 1.21400e-06 1.800 1.21405e-06 0.000 1.21600e-06 0.000 1.21605e-06 1.800 1.21800e-06 1.800
+ 1.21805e-06 0.000 1.22000e-06 0.000 1.22005e-06 1.800 1.22200e-06 1.800 1.22205e-06 0.000 1.22400e-06 0.000
+ 1.22405e-06 1.800 1.22600e-06 1.800 1.22605e-06 0.000 1.22800e-06 0.000 1.22805e-06 1.800 1.23000e-06 1.800
+ 1.23005e-06 0.000 1.23200e-06 0.000 1.23205e-06 1.800 1.23400e-06 1.800 1.23405e-06 0.000 1.23600e-06 0.000
+ 1.23605e-06 1.800 1.23800e-06 1.800 1.23805e-06 0.000 1.24000e-06 0.000 1.24005e-06 1.800 1.24200e-06 1.800
+ 1.24205e-06 0.000 1.24400e-06 0.000 1.24405e-06 1.800 1.24600e-06 1.800 1.24605e-06 0.000 1.24800e-06 0.000
+ 1.24805e-06 1.800 1.25000e-06 1.800 1.25005e-06 0.000 1.25200e-06 0.000 1.25205e-06 1.800 1.25400e-06 1.800
+ 1.25405e-06 0.000 1.25600e-06 0.000 1.25605e-06 1.800 1.25800e-06 1.800 1.25805e-06 0.000 1.26000e-06 0.000
+ 1.26005e-06 1.800 1.26200e-06 1.800 1.26205e-06 0.000 1.26400e-06 0.000 1.26405e-06 1.800 1.26600e-06 1.800
+ 1.26605e-06 0.000 1.26800e-06 0.000 1.26805e-06 1.800 1.27000e-06 1.800 1.27005e-06 0.000 1.27200e-06 0.000
+ 1.27205e-06 1.800 1.27400e-06 1.800 1.27405e-06 0.000 1.27600e-06 0.000 1.27605e-06 1.800 1.27800e-06 1.800
+ 1.27805e-06 0.000 1.28000e-06 0.000 1.28005e-06 1.800 1.28200e-06 1.800 1.28205e-06 0.000 1.28400e-06 0.000
+ 1.28405e-06 1.800 1.28600e-06 1.800 1.28605e-06 0.000 1.28800e-06 0.000 1.28805e-06 1.800 1.29000e-06 1.800
+ 1.29005e-06 0.000 1.29200e-06 0.000 1.29205e-06 1.800 1.29400e-06 1.800 1.29405e-06 0.000 1.29600e-06 0.000
+ 1.29605e-06 1.800 1.29800e-06 1.800 1.29805e-06 0.000 1.30000e-06 0.000 1.30005e-06 1.800 1.30200e-06 1.800
+ 1.30205e-06 0.000 1.30400e-06 0.000 1.30405e-06 1.800 1.30600e-06 1.800 1.30605e-06 0.000 1.30800e-06 0.000
+ 1.30805e-06 1.800 1.31000e-06 1.800 1.31005e-06 0.000 1.31200e-06 0.000 1.31205e-06 1.800 1.31400e-06 1.800
+ 1.31405e-06 0.000 1.31600e-06 0.000 1.31605e-06 1.800 1.31800e-06 1.800 1.31805e-06 0.000 1.32000e-06 0.000
+ 1.32005e-06 1.800 1.32200e-06 1.800 1.32205e-06 0.000 1.32400e-06 0.000 1.32405e-06 1.800 1.32600e-06 1.800
+ 1.32605e-06 0.000 1.32800e-06 0.000 1.32805e-06 1.800 1.33000e-06 1.800 1.33005e-06 0.000 1.33200e-06 0.000
+ 1.33205e-06 1.800 1.33400e-06 1.800 1.33405e-06 0.000 1.33600e-06 0.000 1.33605e-06 1.800 1.33800e-06 1.800
+ 1.33805e-06 0.000 1.34000e-06 0.000 1.34005e-06 1.800 1.34200e-06 1.800 1.34205e-06 0.000 1.34400e-06 0.000
+ 1.34405e-06 1.800 1.34600e-06 1.800 1.34605e-06 0.000 1.34800e-06 0.000 1.34805e-06 1.800 1.35000e-06 1.800
+ 1.35005e-06 0.000 1.35200e-06 0.000 1.35205e-06 1.800 1.35400e-06 1.800 1.35405e-06 0.000 1.35600e-06 0.000
+ 1.35605e-06 1.800 1.35800e-06 1.800 1.35805e-06 0.000 1.36000e-06 0.000 1.36005e-06 1.800 1.36200e-06 1.800
+ 1.36205e-06 0.000 1.36400e-06 0.000 1.36405e-06 1.800 1.36600e-06 1.800 1.36605e-06 0.000 1.36800e-06 0.000
+ 1.36805e-06 1.800 1.37000e-06 1.800 1.37005e-06 0.000 1.37200e-06 0.000 1.37205e-06 1.800 1.37400e-06 1.800
+ 1.37405e-06 0.000 1.37600e-06 0.000 1.37605e-06 1.800 1.37800e-06 1.800 1.37805e-06 0.000 1.38000e-06 0.000
+ 1.38005e-06 1.800 1.38200e-06 1.800 1.38205e-06 0.000 1.38400e-06 0.000 1.38405e-06 1.800 1.38600e-06 1.800
+ 1.38605e-06 0.000 1.38800e-06 0.000 1.38805e-06 1.800 1.39000e-06 1.800 1.39005e-06 0.000 1.39200e-06 0.000
+ 1.39205e-06 1.800 1.39400e-06 1.800 1.39405e-06 0.000 1.39600e-06 0.000 1.39605e-06 1.800 1.39800e-06 1.800
+ 1.39805e-06 0.000 1.40000e-06 0.000 1.40005e-06 1.800 1.40200e-06 1.800 1.40205e-06 0.000 1.40400e-06 0.000
+ 1.40405e-06 1.800 1.40600e-06 1.800 1.40605e-06 0.000 1.40800e-06 0.000 1.40805e-06 1.800 1.41000e-06 1.800
+ 1.41005e-06 0.000 1.41200e-06 0.000 1.41205e-06 1.800 1.41400e-06 1.800 1.41405e-06 0.000 1.41600e-06 0.000
+ 1.41605e-06 1.800 1.41800e-06 1.800 1.41805e-06 0.000 1.42000e-06 0.000 1.42005e-06 1.800 1.42200e-06 1.800
+ 1.42205e-06 0.000 1.42400e-06 0.000 1.42405e-06 1.800 1.42600e-06 1.800 1.42605e-06 0.000 1.42800e-06 0.000
+ 1.42805e-06 1.800 1.43000e-06 1.800 1.43005e-06 0.000 1.43200e-06 0.000 1.43205e-06 1.800 1.43400e-06 1.800
+ 1.43405e-06 0.000 1.43600e-06 0.000 1.43605e-06 1.800 1.43800e-06 1.800 1.43805e-06 0.000 1.44000e-06 0.000
+ 1.44005e-06 1.800 1.44200e-06 1.800 1.44205e-06 0.000 1.44400e-06 0.000 1.44405e-06 1.800 1.44600e-06 1.800
+ 1.44605e-06 0.000 1.44800e-06 0.000 1.44805e-06 1.800 1.45000e-06 1.800 1.45005e-06 0.000 1.45200e-06 0.000
+ 1.45205e-06 1.800 1.45400e-06 1.800 1.45405e-06 0.000 1.45600e-06 0.000 1.45605e-06 1.800 1.45800e-06 1.800
+ 1.45805e-06 0.000 1.46000e-06 0.000 1.46005e-06 1.800 1.46200e-06 1.800 1.46205e-06 0.000 1.46400e-06 0.000
+ 1.46405e-06 1.800 1.46600e-06 1.800 1.46605e-06 0.000 1.46800e-06 0.000 1.46805e-06 1.800 1.47000e-06 1.800
+ 1.47005e-06 0.000 1.47200e-06 0.000 1.47205e-06 1.800 1.47400e-06 1.800 1.47405e-06 0.000 1.47600e-06 0.000
+ 1.47605e-06 1.800 1.47800e-06 1.800 1.47805e-06 0.000 1.48000e-06 0.000 1.48005e-06 1.800 1.48200e-06 1.800
+ 1.48205e-06 0.000 1.48400e-06 0.000 1.48405e-06 1.800 1.48600e-06 1.800 1.48605e-06 0.000 1.48800e-06 0.000
+ 1.48805e-06 1.800 1.49000e-06 1.800 1.49005e-06 0.000 1.49200e-06 0.000 1.49205e-06 1.800 1.49400e-06 1.800
+ 1.49405e-06 0.000 1.49600e-06 0.000 1.49605e-06 1.800 1.49800e-06 1.800 1.49805e-06 0.000 1.50000e-06 0.000
+ 1.50005e-06 1.800 1.50200e-06 1.800 1.50205e-06 0.000 1.50400e-06 0.000 1.50405e-06 1.800 1.50600e-06 1.800
+ 1.50605e-06 0.000 1.50800e-06 0.000 1.50805e-06 1.800 1.51000e-06 1.800 1.51005e-06 0.000 1.51200e-06 0.000
+ 1.51205e-06 1.800 1.51400e-06 1.800 1.51405e-06 0.000 1.51600e-06 0.000 1.51605e-06 1.800 1.51800e-06 1.800
+ 1.51805e-06 0.000 1.52000e-06 0.000 1.52005e-06 1.800 1.52200e-06 1.800 1.52205e-06 0.000 1.52400e-06 0.000
+ 1.52405e-06 1.800 1.52600e-06 1.800 1.52605e-06 0.000 1.52800e-06 0.000 1.52805e-06 1.800 1.53000e-06 1.800
+ 1.53005e-06 0.000 1.53200e-06 0.000 1.53205e-06 1.800 1.53400e-06 1.800 1.53405e-06 0.000 1.53600e-06 0.000
+ 1.53605e-06 1.800 1.53800e-06 1.800 1.53805e-06 0.000 1.54000e-06 0.000 1.54005e-06 1.800 1.54200e-06 1.800
+ 1.54205e-06 0.000 1.54400e-06 0.000 1.54405e-06 1.800 1.54600e-06 1.800 1.54605e-06 0.000 1.54800e-06 0.000
+ 1.54805e-06 1.800 1.55000e-06 1.800 1.55005e-06 0.000 1.55200e-06 0.000 1.55205e-06 1.800 1.55400e-06 1.800
+ 1.55405e-06 0.000 1.55600e-06 0.000 1.55605e-06 1.800 1.55800e-06 1.800 1.55805e-06 0.000 1.56000e-06 0.000
+ 1.56005e-06 1.800 1.56200e-06 1.800 1.56205e-06 0.000 1.56400e-06 0.000 1.56405e-06 1.800 1.56600e-06 1.800
+ 1.56605e-06 0.000 1.56800e-06 0.000 1.56805e-06 1.800 1.57000e-06 1.800 1.57005e-06 0.000 1.57200e-06 0.000
+ 1.57205e-06 1.800 1.57400e-06 1.800 1.57405e-06 0.000 1.57600e-06 0.000 1.57605e-06 1.800 1.57800e-06 1.800
+ 1.57805e-06 0.000 1.58000e-06 0.000 1.58005e-06 1.800 1.58200e-06 1.800 1.58205e-06 0.000 1.58400e-06 0.000
+ 1.58405e-06 1.800 1.58600e-06 1.800 1.58605e-06 0.000 1.58800e-06 0.000 1.58805e-06 1.800 1.59000e-06 1.800
+ 1.59005e-06 0.000 1.59200e-06 0.000 1.59205e-06 1.800 1.59400e-06 1.800 1.59405e-06 0.000 1.59600e-06 0.000
+ 1.59605e-06 1.800 1.59800e-06 1.800 1.59805e-06 0.000 1.60000e-06 0.000 1.60005e-06 1.800 1.60200e-06 1.800
+ 1.60205e-06 0.000 1.60400e-06 0.000 1.60405e-06 1.800 1.60600e-06 1.800 1.60605e-06 0.000 1.60800e-06 0.000
+ 1.60805e-06 1.800 1.61000e-06 1.800 1.61005e-06 0.000 1.61200e-06 0.000 1.61205e-06 1.800 1.61400e-06 1.800
+ 1.61405e-06 0.000 1.61600e-06 0.000 1.61605e-06 1.800 1.61800e-06 1.800 1.61805e-06 0.000 1.62000e-06 0.000
+ 1.62005e-06 1.800 1.62200e-06 1.800 1.62205e-06 0.000 1.62400e-06 0.000 1.62405e-06 1.800 1.62600e-06 1.800
+ 1.62605e-06 0.000 1.62800e-06 0.000 1.62805e-06 1.800 1.63000e-06 1.800 1.63005e-06 0.000 1.63200e-06 0.000
+ 1.63205e-06 1.800 1.63400e-06 1.800 1.63405e-06 0.000 1.63600e-06 0.000 1.63605e-06 1.800 1.63800e-06 1.800
+ 1.63805e-06 0.000 1.64000e-06 0.000 1.64005e-06 1.800 1.64200e-06 1.800 1.64205e-06 0.000 1.64400e-06 0.000
+ 1.64405e-06 1.800 1.64600e-06 1.800 1.64605e-06 0.000 1.64800e-06 0.000 1.64805e-06 1.800 1.65000e-06 1.800
+ 1.65005e-06 0.000 1.65200e-06 0.000 1.65205e-06 1.800 1.65400e-06 1.800 1.65405e-06 0.000 1.65600e-06 0.000
+ 1.65605e-06 1.800 1.65800e-06 1.800 1.65805e-06 0.000 1.66000e-06 0.000 1.66005e-06 1.800 1.66200e-06 1.800
+ 1.66205e-06 0.000 1.66400e-06 0.000 1.66405e-06 1.800 1.66600e-06 1.800 1.66605e-06 0.000 1.66800e-06 0.000
+ 1.66805e-06 1.800 1.67000e-06 1.800 1.67005e-06 0.000 1.67200e-06 0.000 1.67205e-06 1.800 1.67400e-06 1.800
+ 1.67405e-06 0.000 1.67600e-06 0.000 1.67605e-06 1.800 1.67800e-06 1.800 1.67805e-06 0.000 1.68000e-06 0.000
+ 1.68005e-06 1.800 1.68200e-06 1.800 1.68205e-06 0.000 1.68400e-06 0.000 1.68405e-06 1.800 1.68600e-06 1.800
+ 1.68605e-06 0.000 1.68800e-06 0.000 1.68805e-06 1.800 1.69000e-06 1.800 1.69005e-06 0.000 1.69200e-06 0.000
+ 1.69205e-06 1.800 1.69400e-06 1.800 1.69405e-06 0.000 1.69600e-06 0.000 1.69605e-06 1.800 1.69800e-06 1.800
+ 1.69805e-06 0.000 1.70000e-06 0.000 1.70005e-06 1.800 1.70200e-06 1.800 1.70205e-06 0.000 1.70400e-06 0.000
+ 1.70405e-06 1.800 1.70600e-06 1.800 1.70605e-06 0.000 1.70800e-06 0.000 1.70805e-06 1.800 1.71000e-06 1.800
+ 1.71005e-06 0.000 1.71200e-06 0.000 1.71205e-06 1.800 1.71400e-06 1.800 1.71405e-06 0.000 1.71600e-06 0.000
+ 1.71605e-06 1.800 1.71800e-06 1.800 1.71805e-06 0.000 1.72000e-06 0.000 1.72005e-06 1.800 1.72200e-06 1.800
+ 1.72205e-06 0.000 1.72400e-06 0.000 1.72405e-06 1.800 1.72600e-06 1.800 1.72605e-06 0.000 1.72800e-06 0.000
+ 1.72805e-06 1.800 1.73000e-06 1.800 1.73005e-06 0.000 1.73200e-06 0.000 1.73205e-06 1.800 1.73400e-06 1.800
+ 1.73405e-06 0.000 1.73600e-06 0.000 1.73605e-06 1.800 1.73800e-06 1.800 1.73805e-06 0.000 1.74000e-06 0.000
+ 1.74005e-06 1.800 1.74200e-06 1.800 1.74205e-06 0.000 1.74400e-06 0.000 1.74405e-06 1.800 1.74600e-06 1.800
+ 1.74605e-06 0.000 1.74800e-06 0.000 1.74805e-06 1.800 1.75000e-06 1.800 1.75005e-06 0.000 1.75200e-06 0.000
+ 1.75205e-06 1.800 1.75400e-06 1.800 1.75405e-06 0.000 1.75600e-06 0.000 1.75605e-06 1.800 1.75800e-06 1.800
+ 1.75805e-06 0.000 1.76000e-06 0.000 1.76005e-06 1.800 1.76200e-06 1.800 1.76205e-06 0.000 1.76400e-06 0.000
+ 1.76405e-06 1.800 1.76600e-06 1.800 1.76605e-06 0.000 1.76800e-06 0.000 1.76805e-06 1.800 1.77000e-06 1.800
+ 1.77005e-06 0.000 1.77200e-06 0.000 1.77205e-06 1.800 1.77400e-06 1.800 1.77405e-06 0.000 1.77600e-06 0.000
+ 1.77605e-06 1.800 1.77800e-06 1.800 1.77805e-06 0.000 1.78000e-06 0.000 1.78005e-06 1.800 1.78200e-06 1.800
+ 1.78205e-06 0.000 1.78400e-06 0.000 1.78405e-06 1.800 1.78600e-06 1.800 1.78605e-06 0.000 1.78800e-06 0.000
+ 1.78805e-06 1.800 1.79000e-06 1.800 1.79005e-06 0.000 1.79200e-06 0.000 1.79205e-06 1.800 1.79400e-06 1.800
+ 1.79405e-06 0.000 1.79600e-06 0.000 1.79605e-06 1.800 1.79800e-06 1.800 1.79805e-06 0.000 1.80000e-06 0.000
+ 1.80005e-06 1.800 1.80200e-06 1.800 1.80205e-06 0.000 1.80400e-06 0.000 1.80405e-06 1.800 1.80600e-06 1.800
+ 1.80605e-06 0.000 1.80800e-06 0.000 1.80805e-06 1.800 1.81000e-06 1.800 1.81005e-06 0.000 1.81200e-06 0.000
+ 1.81205e-06 1.800 1.81400e-06 1.800 1.81405e-06 0.000 1.81600e-06 0.000 1.81605e-06 1.800 1.81800e-06 1.800
+ 1.81805e-06 0.000 1.82000e-06 0.000 1.82005e-06 1.800 1.82200e-06 1.800 1.82205e-06 0.000 1.82400e-06 0.000
+ 1.82405e-06 1.800 1.82600e-06 1.800 1.82605e-06 0.000 1.82800e-06 0.000 1.82805e-06 1.800 1.83000e-06 1.800
+ 1.83005e-06 0.000 1.83200e-06 0.000 1.83205e-06 1.800 1.83400e-06 1.800 1.83405e-06 0.000 1.83600e-06 0.000
+ 1.83605e-06 1.800 1.83800e-06 1.800 1.83805e-06 0.000 1.84000e-06 0.000 1.84005e-06 1.800 1.84200e-06 1.800
+ 1.84205e-06 0.000 1.84400e-06 0.000 1.84405e-06 1.800 1.84600e-06 1.800 1.84605e-06 0.000 1.84800e-06 0.000
+ 1.84805e-06 1.800 1.85000e-06 1.800 1.85005e-06 0.000 1.85200e-06 0.000 1.85205e-06 1.800 1.85400e-06 1.800
+ 1.85405e-06 0.000 1.85600e-06 0.000 1.85605e-06 1.800 1.85800e-06 1.800 1.85805e-06 0.000 1.86000e-06 0.000
+ 1.86005e-06 1.800 1.86200e-06 1.800 1.86205e-06 0.000 1.86400e-06 0.000 1.86405e-06 1.800 1.86600e-06 1.800
+ 1.86605e-06 0.000 1.86800e-06 0.000 1.86805e-06 1.800 1.87000e-06 1.800 1.87005e-06 0.000 1.87200e-06 0.000
+ 1.87205e-06 1.800 1.87400e-06 1.800 1.87405e-06 0.000 1.87600e-06 0.000 1.87605e-06 1.800 1.87800e-06 1.800
+ 1.87805e-06 0.000 1.88000e-06 0.000 1.88005e-06 1.800 1.88200e-06 1.800 1.88205e-06 0.000 1.88400e-06 0.000
+ 1.88405e-06 1.800 1.88600e-06 1.800 1.88605e-06 0.000 1.88800e-06 0.000 1.88805e-06 1.800 1.89000e-06 1.800
+ 1.89005e-06 0.000 1.89200e-06 0.000 1.89205e-06 1.800 1.89400e-06 1.800 1.89405e-06 0.000 1.89600e-06 0.000
+ 1.89605e-06 1.800 1.89800e-06 1.800 1.89805e-06 0.000 1.90000e-06 0.000 1.90005e-06 1.800 1.90200e-06 1.800
+ 1.90205e-06 0.000 1.90400e-06 0.000 1.90405e-06 1.800 1.90600e-06 1.800 1.90605e-06 0.000 1.90800e-06 0.000
+ 1.90805e-06 1.800 1.91000e-06 1.800 1.91005e-06 0.000 1.91200e-06 0.000 1.91205e-06 1.800 1.91400e-06 1.800
+ 1.91405e-06 0.000 1.91600e-06 0.000 1.91605e-06 1.800 1.91800e-06 1.800 1.91805e-06 0.000 1.92000e-06 0.000
+ 1.92005e-06 1.800 1.92200e-06 1.800 1.92205e-06 0.000 1.92400e-06 0.000 1.92405e-06 1.800 1.92600e-06 1.800
+ 1.92605e-06 0.000 1.92800e-06 0.000 1.92805e-06 1.800 1.93000e-06 1.800 1.93005e-06 0.000 1.93200e-06 0.000
+ 1.93205e-06 1.800 1.93400e-06 1.800 1.93405e-06 0.000 1.93600e-06 0.000 1.93605e-06 1.800 1.93800e-06 1.800
+ 1.93805e-06 0.000 1.94000e-06 0.000 1.94005e-06 1.800 1.94200e-06 1.800 1.94205e-06 0.000 1.94400e-06 0.000
+ 1.94405e-06 1.800 1.94600e-06 1.800 1.94605e-06 0.000 1.94800e-06 0.000 1.94805e-06 1.800 1.95000e-06 1.800
+ 1.95005e-06 0.000 1.95200e-06 0.000 1.95205e-06 1.800 1.95400e-06 1.800 1.95405e-06 0.000 1.95600e-06 0.000
+ 1.95605e-06 1.800 1.95800e-06 1.800 1.95805e-06 0.000 1.96000e-06 0.000 1.96005e-06 1.800 1.96200e-06 1.800
+ 1.96205e-06 0.000 1.96400e-06 0.000 1.96405e-06 1.800 1.96600e-06 1.800 1.96605e-06 0.000 1.96800e-06 0.000
+ 1.96805e-06 1.800 1.97000e-06 1.800 1.97005e-06 0.000 1.97200e-06 0.000 1.97205e-06 1.800 1.97400e-06 1.800
+ 1.97405e-06 0.000 1.97600e-06 0.000 1.97605e-06 1.800 1.97800e-06 1.800 1.97805e-06 0.000 1.98000e-06 0.000
+ 1.98005e-06 1.800 1.98200e-06 1.800 1.98205e-06 0.000 1.98400e-06 0.000 1.98405e-06 1.800 1.98600e-06 1.800
+ 1.98605e-06 0.000 1.98800e-06 0.000 1.98805e-06 1.800 1.99000e-06 1.800 1.99005e-06 0.000 1.99200e-06 0.000
+ 1.99205e-06 1.800 1.99400e-06 1.800 1.99405e-06 0.000 1.99600e-06 0.000 1.99605e-06 1.800 1.99800e-06 1.800
+ 1.99805e-06 0.000 2.00000e-06 0.000 2.00005e-06 1.800 2.00200e-06 1.800 2.00205e-06 0.000 2.00400e-06 0.000
+ 2.00405e-06 1.800 2.00600e-06 1.800 2.00605e-06 0.000 2.00800e-06 0.000 2.00805e-06 1.800 2.01000e-06 1.800
+ 2.01005e-06 0.000 2.01200e-06 0.000 2.01205e-06 1.800 2.01400e-06 1.800 2.01405e-06 0.000 2.01600e-06 0.000
+ 2.01605e-06 1.800 2.01800e-06 1.800 2.01805e-06 0.000 2.02000e-06 0.000 2.02005e-06 1.800 2.02200e-06 1.800
+ 2.02205e-06 0.000 2.02400e-06 0.000 2.02405e-06 1.800 2.02600e-06 1.800 2.02605e-06 0.000 2.02800e-06 0.000
+ 2.02805e-06 1.800 2.03000e-06 1.800 2.03005e-06 0.000 2.03200e-06 0.000 2.03205e-06 1.800 2.03400e-06 1.800
+ 2.03405e-06 0.000 2.03600e-06 0.000 2.03605e-06 1.800 2.03800e-06 1.800 2.03805e-06 0.000 2.04000e-06 0.000
+ 2.04005e-06 1.800 2.04200e-06 1.800 2.04205e-06 0.000 2.04400e-06 0.000 2.04405e-06 1.800 2.04600e-06 1.800
+ 2.04605e-06 0.000 2.04900e-06 0.000 2.04905e-06 1.800 2.05100e-06 1.800 2.05105e-06 0.000 2.05200e-06 0.000
+ 2.05205e-06 1.800 2.05300e-06 1.800 2.05305e-06 0.000 2.05400e-06 0.000 2.05405e-06 1.800 2.05500e-06 1.800
+ 2.05505e-06 0.000 2.05600e-06 0.000 2.05605e-06 1.800 2.05700e-06 1.800 2.05705e-06 0.000 2.05800e-06 0.000
+ 2.05805e-06 1.800 2.06100e-06 1.800 2.06105e-06 0.000 2.06200e-06 0.000 2.06205e-06 1.800 2.06400e-06 1.800
+ 2.06405e-06 0.000 2.06700e-06 0.000 2.06705e-06 1.800 2.07200e-06 1.800 2.07205e-06 0.000 2.07500e-06 0.000
+ 2.07505e-06 1.800 2.07800e-06 1.800 2.07805e-06 0.000 2.08000e-06 0.000 2.08005e-06 1.800 2.08100e-06 1.800
+ 2.08105e-06 0.000 2.08200e-06 0.000 2.08205e-06 1.800 2.08400e-06 1.800 2.08405e-06 0.000 2.08500e-06 0.000
+ 2.08505e-06 1.800 2.08600e-06 1.800 2.08605e-06 0.000 2.08800e-06 0.000 2.08805e-06 1.800 2.09000e-06 1.800
+ 2.09005e-06 0.000 2.09100e-06 0.000 2.09105e-06 1.800 2.09300e-06 1.800 2.09305e-06 0.000 2.09400e-06 0.000
+ 2.09405e-06 1.800 2.09500e-06 1.800 2.09505e-06 0.000 2.10100e-06 0.000 2.10105e-06 1.800 2.10200e-06 1.800
+ 2.10205e-06 0.000 2.10500e-06 0.000 2.10505e-06 1.800 2.10700e-06 1.800 2.10705e-06 0.000 2.10800e-06 0.000
+ 2.10805e-06 1.800 2.11500e-06 1.800 2.11505e-06 0.000 2.11800e-06 0.000 2.11805e-06 1.800 2.11900e-06 1.800
+ 2.11905e-06 0.000 2.12100e-06 0.000 2.12105e-06 1.800 2.12500e-06 1.800 2.12505e-06 0.000 2.12600e-06 0.000
+ 2.12605e-06 1.800 2.12700e-06 1.800 2.12705e-06 0.000 2.12800e-06 0.000 2.12805e-06 1.800 2.12900e-06 1.800
+ 2.12905e-06 0.000 2.13200e-06 0.000 2.13205e-06 1.800 2.13300e-06 1.800 2.13305e-06 0.000 2.13400e-06 0.000
+ 2.13405e-06 1.800 2.13500e-06 1.800 2.13505e-06 0.000 2.13700e-06 0.000 2.13705e-06 1.800 2.13900e-06 1.800
+ 2.13905e-06 0.000 2.14200e-06 0.000 2.14205e-06 1.800 2.14400e-06 1.800 2.14405e-06 0.000 2.14800e-06 0.000
+ 2.14805e-06 1.800 2.14900e-06 1.800 2.14905e-06 0.000 2.15100e-06 0.000 2.15105e-06 1.800 2.15200e-06 1.800
+ 2.15205e-06 0.000 2.15500e-06 0.000 2.15505e-06 1.800 2.15700e-06 1.800 2.15705e-06 0.000 2.15900e-06 0.000
+ 2.15905e-06 1.800 2.16000e-06 1.800 2.16005e-06 0.000 2.16400e-06 0.000 2.16405e-06 1.800 2.16500e-06 1.800
+ 2.16505e-06 0.000 2.16900e-06 0.000 2.16905e-06 1.800 2.17000e-06 1.800 2.17005e-06 0.000 2.17100e-06 0.000
+ 2.17105e-06 1.800 2.17300e-06 1.800 2.17305e-06 0.000 2.17400e-06 0.000 2.17405e-06 1.800 2.17600e-06 1.800
+ 2.17605e-06 0.000 2.17900e-06 0.000 2.17905e-06 1.800 2.18100e-06 1.800 2.18105e-06 0.000 2.18500e-06 0.000
+ 2.18505e-06 1.800 2.18800e-06 1.800 2.18805e-06 0.000 2.18900e-06 0.000 2.18905e-06 1.800 2.19000e-06 1.800
+ 2.19005e-06 0.000 2.19100e-06 0.000 2.19105e-06 1.800 2.19300e-06 1.800 2.19305e-06 0.000 2.19400e-06 0.000
+ 2.19405e-06 1.800 2.19700e-06 1.800 2.19705e-06 0.000 2.20000e-06 0.000 2.20005e-06 1.800 2.20200e-06 1.800
+ 2.20205e-06 0.000 2.20300e-06 0.000 2.20305e-06 1.800 2.20600e-06 1.800 2.20605e-06 0.000 2.21000e-06 0.000
+ 2.21005e-06 1.800 2.21200e-06 1.800 2.21205e-06 0.000 2.21400e-06 0.000 2.21405e-06 1.800 2.21500e-06 1.800
+ 2.21505e-06 0.000 2.21600e-06 0.000 2.21605e-06 1.800 2.21700e-06 1.800 2.21705e-06 0.000 2.21900e-06 0.000
+ 2.21905e-06 1.800 2.22000e-06 1.800 2.22005e-06 0.000 2.22100e-06 0.000 2.22105e-06 1.800 2.22200e-06 1.800
+ 2.22205e-06 0.000 2.22400e-06 0.000 2.22405e-06 1.800 2.22600e-06 1.800 2.22605e-06 0.000 2.22700e-06 0.000
+ 2.22705e-06 1.800 2.22800e-06 1.800 2.22805e-06 0.000 2.22900e-06 0.000 2.22905e-06 1.800 2.23000e-06 1.800
+ 2.23005e-06 0.000 2.23100e-06 0.000 2.23105e-06 1.800 2.23200e-06 1.800 2.23205e-06 0.000 2.23400e-06 0.000
+ 2.23405e-06 1.800 2.23500e-06 1.800 2.23505e-06 0.000 2.23600e-06 0.000 2.23605e-06 1.800 2.23900e-06 1.800
+ 2.23905e-06 0.000 2.24000e-06 0.000 2.24005e-06 1.800 2.24100e-06 1.800 2.24105e-06 0.000 2.24500e-06 0.000
+ 2.24505e-06 1.800 2.24800e-06 1.800 2.24805e-06 0.000 2.24900e-06 0.000 2.24905e-06 1.800 2.25000e-06 1.800
+ 2.25005e-06 0.000 2.25100e-06 0.000 2.25105e-06 1.800 2.25400e-06 1.800 2.25405e-06 0.000 2.25600e-06 0.000
+ 2.25605e-06 1.800 2.25800e-06 1.800 2.25805e-06 0.000 2.25900e-06 0.000 2.25905e-06 1.800 2.26000e-06 1.800
+ 2.26005e-06 0.000 2.26200e-06 0.000 2.26205e-06 1.800 2.26400e-06 1.800 2.26405e-06 0.000 2.26500e-06 0.000
+ 2.26505e-06 1.800 2.26800e-06 1.800 2.26805e-06 0.000 2.27000e-06 0.000 2.27005e-06 1.800 2.27100e-06 1.800
+ 2.27105e-06 0.000 2.27500e-06 0.000 2.27505e-06 1.800 2.27700e-06 1.800 2.27705e-06 0.000 2.27900e-06 0.000
+ 2.27905e-06 1.800 2.28300e-06 1.800 2.28305e-06 0.000 2.28400e-06 0.000 2.28405e-06 1.800 2.28800e-06 1.800
+ 2.28805e-06 0.000 2.29000e-06 0.000 2.29005e-06 1.800 2.29200e-06 1.800 2.29205e-06 0.000 2.29500e-06 0.000
+ 2.29505e-06 1.800 2.29600e-06 1.800 2.29605e-06 0.000 2.29700e-06 0.000 2.29705e-06 1.800 2.29800e-06 1.800
+ 2.29805e-06 0.000 2.30000e-06 0.000 2.30005e-06 1.800 2.30200e-06 1.800 2.30205e-06 0.000 2.30300e-06 0.000
+ 2.30305e-06 1.800 2.30400e-06 1.800 2.30405e-06 0.000 2.30600e-06 0.000 2.30605e-06 1.800 2.30700e-06 1.800
+ 2.30705e-06 0.000 2.30800e-06 0.000 2.30805e-06 1.800 2.31000e-06 1.800 2.31005e-06 0.000 2.31500e-06 0.000
+ 2.31505e-06 1.800 2.31700e-06 1.800 2.31705e-06 0.000 2.32300e-06 0.000 2.32305e-06 1.800 2.32400e-06 1.800
+ 2.32405e-06 0.000 2.32700e-06 0.000 2.32705e-06 1.800 2.32800e-06 1.800 2.32805e-06 0.000 2.33200e-06 0.000
+ 2.33205e-06 1.800 2.33300e-06 1.800 2.33305e-06 0.000 2.33400e-06 0.000 2.33405e-06 1.800 2.33500e-06 1.800
+ 2.33505e-06 0.000 2.33600e-06 0.000 2.33605e-06 1.800 2.34000e-06 1.800 2.34005e-06 0.000 2.34100e-06 0.000
+ 2.34105e-06 1.800 2.34200e-06 1.800 2.34205e-06 0.000 2.34300e-06 0.000 2.34305e-06 1.800 2.34700e-06 1.800
+ 2.34705e-06 0.000 2.34800e-06 0.000 2.34805e-06 1.800 2.34900e-06 1.800 2.34905e-06 0.000 2.35200e-06 0.000
+ 2.35205e-06 1.800 2.35600e-06 1.800 2.35605e-06 0.000 2.35900e-06 0.000 2.35905e-06 1.800 2.36000e-06 1.800
+ 2.36005e-06 0.000 2.36200e-06 0.000 2.36205e-06 1.800 2.36400e-06 1.800 2.36405e-06 0.000 2.36500e-06 0.000
+ 2.36505e-06 1.800 2.37000e-06 1.800 2.37005e-06 0.000 2.37400e-06 0.000 2.37405e-06 1.800 2.37500e-06 1.800
+ 2.37505e-06 0.000 2.37600e-06 0.000 2.37605e-06 1.800 2.37700e-06 1.800 2.37705e-06 0.000 2.37800e-06 0.000
+ 2.37805e-06 1.800 2.37900e-06 1.800 2.37905e-06 0.000 2.38200e-06 0.000 2.38205e-06 1.800 2.38300e-06 1.800
+ 2.38305e-06 0.000 2.38400e-06 0.000 2.38405e-06 1.800 2.39100e-06 1.800 2.39105e-06 0.000 2.39300e-06 0.000
+ 2.39305e-06 1.800 2.39600e-06 1.800 2.39605e-06 0.000 2.39700e-06 0.000 2.39705e-06 1.800 2.40100e-06 1.800
+ 2.40105e-06 0.000 2.40200e-06 0.000 2.40205e-06 1.800 2.40400e-06 1.800 2.40405e-06 0.000 2.40500e-06 0.000
+ 2.40505e-06 1.800 2.40600e-06 1.800 2.40605e-06 0.000 2.40700e-06 0.000 2.40705e-06 1.800 2.40800e-06 1.800
+ 2.40805e-06 0.000 2.40900e-06 0.000 2.40905e-06 1.800 2.41500e-06 1.800 2.41505e-06 0.000 2.41600e-06 0.000
+ 2.41605e-06 1.800 2.41700e-06 1.800 2.41705e-06 0.000 2.41900e-06 0.000 2.41905e-06 1.800 2.42100e-06 1.800
+ 2.42105e-06 0.000 2.42200e-06 0.000 2.42205e-06 1.800 2.42500e-06 1.800 2.42505e-06 0.000 2.42600e-06 0.000
+ 2.42605e-06 1.800 2.42700e-06 1.800 2.42705e-06 0.000 2.42800e-06 0.000 2.42805e-06 1.800 2.43100e-06 1.800
+ 2.43105e-06 0.000 2.43300e-06 0.000 2.43305e-06 1.800 2.43400e-06 1.800 2.43405e-06 0.000 2.43500e-06 0.000
+ 2.43505e-06 1.800 2.43600e-06 1.800 2.43605e-06 0.000 2.43900e-06 0.000 2.43905e-06 1.800 2.44100e-06 1.800
+ 2.44105e-06 0.000 2.44300e-06 0.000 2.44305e-06 1.800 2.44500e-06 1.800 2.44505e-06 0.000 2.44800e-06 0.000
+ 2.44805e-06 1.800 2.44900e-06 1.800 2.44905e-06 0.000 2.45000e-06 0.000 2.45005e-06 1.800 2.45100e-06 1.800
+ 2.45105e-06 0.000 2.45400e-06 0.000 2.45405e-06 1.800 2.45500e-06 1.800 2.45505e-06 0.000 2.45700e-06 0.000
+ 2.45705e-06 1.800 2.46300e-06 1.800 2.46305e-06 0.000 2.46400e-06 0.000 2.46405e-06 1.800 2.46600e-06 1.800
+ 2.46605e-06 0.000 2.46700e-06 0.000 2.46705e-06 1.800 2.46800e-06 1.800 2.46805e-06 0.000 2.47400e-06 0.000
+ 2.47405e-06 1.800 2.47900e-06 1.800 2.47905e-06 0.000 2.48100e-06 0.000 2.48105e-06 1.800 2.48200e-06 1.800
+ 2.48205e-06 0.000 2.48400e-06 0.000 2.48405e-06 1.800 2.48500e-06 1.800 2.48505e-06 0.000 2.48600e-06 0.000
+ 2.48605e-06 1.800 2.48900e-06 1.800 2.48905e-06 0.000 2.49400e-06 0.000 2.49405e-06 1.800 2.49800e-06 1.800
+ 2.49805e-06 0.000 2.50200e-06 0.000 2.50205e-06 1.800 2.50700e-06 1.800 2.50705e-06 0.000 2.51100e-06 0.000
+ 2.51105e-06 1.800 2.51400e-06 1.800 2.51405e-06 0.000 2.52000e-06 0.000 2.52005e-06 1.800 2.52300e-06 1.800
+ 2.52305e-06 0.000 2.52400e-06 0.000 2.52405e-06 1.800 2.52600e-06 1.800 2.52605e-06 0.000 2.52800e-06 0.000
+ 2.52805e-06 1.800 2.53000e-06 1.800 2.53005e-06 0.000 2.53100e-06 0.000 2.53105e-06 1.800 2.53300e-06 1.800
+ 2.53305e-06 0.000 2.53400e-06 0.000 2.53405e-06 1.800 2.53600e-06 1.800 2.53605e-06 0.000 2.54000e-06 0.000
+ 2.54005e-06 1.800 2.54100e-06 1.800 2.54105e-06 0.000 2.54200e-06 0.000 2.54205e-06 1.800 2.54300e-06 1.800
+ 2.54305e-06 0.000 2.54700e-06 0.000 2.54705e-06 1.800 2.54800e-06 1.800 2.54805e-06 0.000 2.54900e-06 0.000
+ 2.54905e-06 1.800 2.55300e-06 1.800 2.55305e-06 0.000 2.55400e-06 0.000 2.55405e-06 1.800 2.55500e-06 1.800
+ 2.55505e-06 0.000 2.55600e-06 0.000 2.55605e-06 1.800 2.55700e-06 1.800 2.55705e-06 0.000 2.56600e-06 0.000
+ 2.56605e-06 1.800 2.56700e-06 1.800 2.56705e-06 0.000 2.56800e-06 0.000 2.56805e-06 1.800 2.56900e-06 1.800
+ 2.56905e-06 0.000 2.57000e-06 0.000 2.57005e-06 1.800 2.57100e-06 1.800 2.57105e-06 0.000 2.57200e-06 0.000
+ 2.57205e-06 1.800 2.57300e-06 1.800 2.57305e-06 0.000 2.57400e-06 0.000 2.57405e-06 1.800 2.57500e-06 1.800
+ 2.57505e-06 0.000 2.57600e-06 0.000 2.57605e-06 1.800 2.57700e-06 1.800 2.57705e-06 0.000 2.58300e-06 0.000
+ 2.58305e-06 1.800 2.58400e-06 1.800 2.58405e-06 0.000 2.58500e-06 0.000 2.58505e-06 1.800 2.58600e-06 1.800
+ 2.58605e-06 0.000 2.58900e-06 0.000 2.58905e-06 1.800 2.59300e-06 1.800 2.59305e-06 0.000 2.59500e-06 0.000
+ 2.59505e-06 1.800 2.59700e-06 1.800 2.59705e-06 0.000 2.59900e-06 0.000 2.59905e-06 1.800 2.60000e-06 1.800
+ 2.60005e-06 0.000 2.60100e-06 0.000 2.60105e-06 1.800 2.60200e-06 1.800 2.60205e-06 0.000 2.60300e-06 0.000
+ 2.60305e-06 1.800 2.60400e-06 1.800 2.60405e-06 0.000 2.60500e-06 0.000 2.60505e-06 1.800 2.60800e-06 1.800
+ 2.60805e-06 0.000 2.61100e-06 0.000 2.61105e-06 1.800 2.61200e-06 1.800 2.61205e-06 0.000 2.61300e-06 0.000
+ 2.61305e-06 1.800 2.61400e-06 1.800 2.61405e-06 0.000 2.61700e-06 0.000 2.61705e-06 1.800 2.61800e-06 1.800
+ 2.61805e-06 0.000 2.62200e-06 0.000 2.62205e-06 1.800 2.62400e-06 1.800 2.62405e-06 0.000 2.62500e-06 0.000
+ 2.62505e-06 1.800 2.62600e-06 1.800 2.62605e-06 0.000 2.63000e-06 0.000 2.63005e-06 1.800 2.63300e-06 1.800
+ 2.63305e-06 0.000 2.63500e-06 0.000 2.63505e-06 1.800 2.63800e-06 1.800 2.63805e-06 0.000 2.63900e-06 0.000
+ 2.63905e-06 1.800 2.64000e-06 1.800 2.64005e-06 0.000 2.64100e-06 0.000 2.64105e-06 1.800 2.64300e-06 1.800
+ 2.64305e-06 0.000 2.64500e-06 0.000 2.64505e-06 1.800 2.64600e-06 1.800 2.64605e-06 0.000 2.64700e-06 0.000
+ 2.64705e-06 1.800 2.64900e-06 1.800 2.64905e-06 0.000 2.65500e-06 0.000 2.65505e-06 1.800 2.65700e-06 1.800
+ 2.65705e-06 0.000 2.65800e-06 0.000 2.65805e-06 1.800 2.65900e-06 1.800 2.65905e-06 0.000 2.66000e-06 0.000
+ 2.66005e-06 1.800 2.66100e-06 1.800 2.66105e-06 0.000 2.66400e-06 0.000 2.66405e-06 1.800 2.66500e-06 1.800
+ 2.66505e-06 0.000 2.66600e-06 0.000 2.66605e-06 1.800 2.66700e-06 1.800 2.66705e-06 0.000 2.67100e-06 0.000
+ 2.67105e-06 1.800 2.67300e-06 1.800 2.67305e-06 0.000 2.67400e-06 0.000 2.67405e-06 1.800 2.67600e-06 1.800
+ 2.67605e-06 0.000 2.68400e-06 0.000 2.68405e-06 1.800 2.68500e-06 1.800 2.68505e-06 0.000 2.68700e-06 0.000
+ 2.68705e-06 1.800 2.68800e-06 1.800 2.68805e-06 0.000 2.68900e-06 0.000 2.68905e-06 1.800 2.69100e-06 1.800
+ 2.69105e-06 0.000 2.69300e-06 0.000 2.69305e-06 1.800 2.69400e-06 1.800 2.69405e-06 0.000 2.69500e-06 0.000
+ 2.69505e-06 1.800 2.69600e-06 1.800 2.69605e-06 0.000 2.69800e-06 0.000 2.69805e-06 1.800 2.69900e-06 1.800
+ 2.69905e-06 0.000 2.70000e-06 0.000 2.70005e-06 1.800 2.70200e-06 1.800 2.70205e-06 0.000 2.70600e-06 0.000
+ 2.70605e-06 1.800 2.70700e-06 1.800 2.70705e-06 0.000 2.70900e-06 0.000 2.70905e-06 1.800 2.71000e-06 1.800
+ 2.71005e-06 0.000 2.71100e-06 0.000 2.71105e-06 1.800 2.71300e-06 1.800 2.71305e-06 0.000 2.71800e-06 0.000
+ 2.71805e-06 1.800 2.71900e-06 1.800 2.71905e-06 0.000 2.72100e-06 0.000 2.72105e-06 1.800 2.72200e-06 1.800
+ 2.72205e-06 0.000 2.72400e-06 0.000 2.72405e-06 1.800 2.72700e-06 1.800 2.72705e-06 0.000 2.72800e-06 0.000
+ 2.72805e-06 1.800 2.73000e-06 1.800 2.73005e-06 0.000 2.73100e-06 0.000 2.73105e-06 1.800 2.73200e-06 1.800
+ 2.73205e-06 0.000 2.73400e-06 0.000 2.73405e-06 1.800 2.73500e-06 1.800 2.73505e-06 0.000 2.73600e-06 0.000
+ 2.73605e-06 1.800 2.73700e-06 1.800 2.73705e-06 0.000 2.73900e-06 0.000 2.73905e-06 1.800 2.74000e-06 1.800
+ 2.74005e-06 0.000 2.74100e-06 0.000 2.74105e-06 1.800 2.74400e-06 1.800 2.74405e-06 0.000 2.74900e-06 0.000
+ 2.74905e-06 1.800 2.75100e-06 1.800 2.75105e-06 0.000 2.75600e-06 0.000 2.75605e-06 1.800 2.75700e-06 1.800
+ 2.75705e-06 0.000 2.76000e-06 0.000 2.76005e-06 1.800 2.76400e-06 1.800 2.76405e-06 0.000 2.76900e-06 0.000
+ 2.76905e-06 1.800 2.77000e-06 1.800 2.77005e-06 0.000 2.77300e-06 0.000 2.77305e-06 1.800 2.77400e-06 1.800
+ 2.77405e-06 0.000 2.77500e-06 0.000 2.77505e-06 1.800 2.77600e-06 1.800 2.77605e-06 0.000 2.77700e-06 0.000
+ 2.77705e-06 1.800 2.78300e-06 1.800 2.78305e-06 0.000 2.78400e-06 0.000 2.78405e-06 1.800 2.78600e-06 1.800
+ 2.78605e-06 0.000 2.78700e-06 0.000 2.78705e-06 1.800 2.78800e-06 1.800 2.78805e-06 0.000 2.79000e-06 0.000
+ 2.79005e-06 1.800 2.79100e-06 1.800 2.79105e-06 0.000 2.79200e-06 0.000 2.79205e-06 1.800 2.79300e-06 1.800
+ 2.79305e-06 0.000 2.79400e-06 0.000 2.79405e-06 1.800 2.79600e-06 1.800 2.79605e-06 0.000 2.79800e-06 0.000
+ 2.79805e-06 1.800 2.79900e-06 1.800 2.79905e-06 0.000 2.80000e-06 0.000 2.80005e-06 1.800 2.80100e-06 1.800
+ 2.80105e-06 0.000 2.80200e-06 0.000 2.80205e-06 1.800 2.80300e-06 1.800 2.80305e-06 0.000 2.80400e-06 0.000
+ 2.80405e-06 1.800 2.80800e-06 1.800 2.80805e-06 0.000 2.80900e-06 0.000 2.80905e-06 1.800 2.81000e-06 1.800
+ 2.81005e-06 0.000 2.81100e-06 0.000 2.81105e-06 1.800 2.81300e-06 1.800 2.81305e-06 0.000 2.81500e-06 0.000
+ 2.81505e-06 1.800 2.81800e-06 1.800 2.81805e-06 0.000 2.82000e-06 0.000 2.82005e-06 1.800 2.82200e-06 1.800
+ 2.82205e-06 0.000 2.82300e-06 0.000 2.82305e-06 1.800 2.82600e-06 1.800 2.82605e-06 0.000 2.82700e-06 0.000
+ 2.82705e-06 1.800 2.82800e-06 1.800 2.82805e-06 0.000 2.83100e-06 0.000 2.83105e-06 1.800 2.83300e-06 1.800
+ 2.83305e-06 0.000 2.83700e-06 0.000 2.83705e-06 1.800 2.83800e-06 1.800 2.83805e-06 0.000 2.83900e-06 0.000
+ 2.83905e-06 1.800 2.84000e-06 1.800 2.84005e-06 0.000 2.84300e-06 0.000 2.84305e-06 1.800 2.84800e-06 1.800
+ 2.84805e-06 0.000 2.84900e-06 0.000 2.84905e-06 1.800 2.85000e-06 1.800 2.85005e-06 0.000 2.85300e-06 0.000
+ 2.85305e-06 1.800 2.85600e-06 1.800 2.85605e-06 0.000 2.85900e-06 0.000 2.85905e-06 1.800 2.86000e-06 1.800
+ 2.86005e-06 0.000 2.86100e-06 0.000 2.86105e-06 1.800 2.86200e-06 1.800 2.86205e-06 0.000 2.86300e-06 0.000
+ 2.86305e-06 1.800 2.86600e-06 1.800 2.86605e-06 0.000 2.86800e-06 0.000 2.86805e-06 1.800 2.87100e-06 1.800
+ 2.87105e-06 0.000 2.87600e-06 0.000 2.87605e-06 1.800 2.87700e-06 1.800 2.87705e-06 0.000 2.88100e-06 0.000
+ 2.88105e-06 1.800 2.88400e-06 1.800 2.88405e-06 0.000 2.88500e-06 0.000 2.88505e-06 1.800 2.88700e-06 1.800
+ 2.88705e-06 0.000 2.88800e-06 0.000 2.88805e-06 1.800 2.89100e-06 1.800 2.89105e-06 0.000 2.89500e-06 0.000
+ 2.89505e-06 1.800 2.89600e-06 1.800 2.89605e-06 0.000 2.89700e-06 0.000 2.89705e-06 1.800 2.89900e-06 1.800
+ 2.89905e-06 0.000 2.90000e-06 0.000 2.90005e-06 1.800 2.90200e-06 1.800 2.90205e-06 0.000 2.90400e-06 0.000
+ 2.90405e-06 1.800 2.90500e-06 1.800 2.90505e-06 0.000 2.90600e-06 0.000 2.90605e-06 1.800 2.90900e-06 1.800
+ 2.90905e-06 0.000 2.91000e-06 0.000 2.91005e-06 1.800 2.91100e-06 1.800 2.91105e-06 0.000 2.91200e-06 0.000
+ 2.91205e-06 1.800 2.91300e-06 1.800 2.91305e-06 0.000 2.91400e-06 0.000 2.91405e-06 1.800 2.91500e-06 1.800
+ 2.91505e-06 0.000 2.91800e-06 0.000 2.91805e-06 1.800 2.92100e-06 1.800 2.92105e-06 0.000 2.92300e-06 0.000
+ 2.92305e-06 1.800 2.92400e-06 1.800 2.92405e-06 0.000 2.92600e-06 0.000 2.92605e-06 1.800 2.93200e-06 1.800
+ 2.93205e-06 0.000 2.93300e-06 0.000 2.93305e-06 1.800 2.93600e-06 1.800 2.93605e-06 0.000 2.93900e-06 0.000
+ 2.93905e-06 1.800 2.94000e-06 1.800 2.94005e-06 0.000 2.94600e-06 0.000 2.94605e-06 1.800 2.94700e-06 1.800
+ 2.94705e-06 0.000 2.94800e-06 0.000 2.94805e-06 1.800 2.95200e-06 1.800 2.95205e-06 0.000 2.95900e-06 0.000
+ 2.95905e-06 1.800 2.96000e-06 1.800 2.96005e-06 0.000 2.96100e-06 0.000 2.96105e-06 1.800 2.96200e-06 1.800
+ 2.96205e-06 0.000 2.96300e-06 0.000 2.96305e-06 1.800 2.96400e-06 1.800 2.96405e-06 0.000 2.96500e-06 0.000
+ 2.96505e-06 1.800 2.96600e-06 1.800 2.96605e-06 0.000 2.97400e-06 0.000 2.97405e-06 1.800 2.97500e-06 1.800
+ 2.97505e-06 0.000 2.98100e-06 0.000 2.98105e-06 1.800 2.98200e-06 1.800 2.98205e-06 0.000 2.98300e-06 0.000
+ 2.98305e-06 1.800 2.98500e-06 1.800 2.98505e-06 0.000 2.99000e-06 0.000 2.99005e-06 1.800 2.99100e-06 1.800
+ 2.99105e-06 0.000 2.99200e-06 0.000 2.99205e-06 1.800 2.99300e-06 1.800 2.99305e-06 0.000 2.99400e-06 0.000
+ 2.99405e-06 1.800 2.99700e-06 1.800 2.99705e-06 0.000 3.00000e-06 0.000 3.00005e-06 1.800 3.00200e-06 1.800
+ 3.00205e-06 0.000 3.00500e-06 0.000 3.00505e-06 1.800 3.00700e-06 1.800 3.00705e-06 0.000 3.00800e-06 0.000
+ 3.00805e-06 1.800 3.00900e-06 1.800 3.00905e-06 0.000 3.01100e-06 0.000 3.01105e-06 1.800 3.01200e-06 1.800
+ 3.01205e-06 0.000 3.01600e-06 0.000 3.01605e-06 1.800 3.01700e-06 1.800 3.01705e-06 0.000 3.01800e-06 0.000
+ 3.01805e-06 1.800 3.02100e-06 1.800 3.02105e-06 0.000 3.02400e-06 0.000 3.02405e-06 1.800 3.03100e-06 1.800
+ 3.03105e-06 0.000 3.03400e-06 0.000 3.03405e-06 1.800 3.03900e-06 1.800 3.03905e-06 0.000 3.04100e-06 0.000
+ 3.04105e-06 1.800 3.04500e-06 1.800 3.04505e-06 0.000 3.04600e-06 0.000 3.04605e-06 1.800 3.04700e-06 1.800
+ 3.04705e-06 0.000 3.04800e-06 0.000 3.04805e-06 1.800 3.05100e-06 1.800 3.05105e-06 0.000 3.05500e-06 0.000
+ 3.05505e-06 1.800 3.05800e-06 1.800 3.05805e-06 0.000 3.06000e-06 0.000 3.06005e-06 1.800 3.06200e-06 1.800
+ 3.06205e-06 0.000 3.06500e-06 0.000 3.06505e-06 1.800 3.06800e-06 1.800 3.06805e-06 0.000 3.07000e-06 0.000
+ 3.07005e-06 1.800 3.07200e-06 1.800 3.07205e-06 0.000 3.07300e-06 0.000 3.07305e-06 1.800 3.07700e-06 1.800
+ 3.07705e-06 0.000 3.08300e-06 0.000 3.08305e-06 1.800 3.08700e-06 1.800 3.08705e-06 0.000 3.08800e-06 0.000
+ 3.08805e-06 1.800 3.09000e-06 1.800 3.09005e-06 0.000 3.09300e-06 0.000 3.09305e-06 1.800 3.10000e-06 1.800
+ 3.10005e-06 0.000 3.10100e-06 0.000 3.10105e-06 1.800 3.10500e-06 1.800 3.10505e-06 0.000 3.10600e-06 0.000
+ 3.10605e-06 1.800 3.10900e-06 1.800 3.10905e-06 0.000 3.11000e-06 0.000 3.11005e-06 1.800 3.11300e-06 1.800
+ 3.11305e-06 0.000 3.11400e-06 0.000 3.11405e-06 1.800 3.11600e-06 1.800 3.11605e-06 0.000 3.11800e-06 0.000
+ 3.11805e-06 1.800 3.11900e-06 1.800 3.11905e-06 0.000 3.12000e-06 0.000 3.12005e-06 1.800 3.12300e-06 1.800
+ 3.12305e-06 0.000 3.12800e-06 0.000 3.12805e-06 1.800 3.13200e-06 1.800 3.13205e-06 0.000 3.13600e-06 0.000
+ 3.13605e-06 1.800 3.13800e-06 1.800 3.13805e-06 0.000 3.13900e-06 0.000 3.13905e-06 1.800 3.14500e-06 1.800
+ 3.14505e-06 0.000 3.14600e-06 0.000 3.14605e-06 1.800 3.14700e-06 1.800 3.14705e-06 0.000 3.14900e-06 0.000
+ 3.14905e-06 1.800 3.15000e-06 1.800 3.15005e-06 0.000 3.15200e-06 0.000 3.15205e-06 1.800 3.15300e-06 1.800
+ 3.15305e-06 0.000 3.15400e-06 0.000 3.15405e-06 1.800 3.15600e-06 1.800 3.15605e-06 0.000 3.15700e-06 0.000
+ 3.15705e-06 1.800 3.15800e-06 1.800 3.15805e-06 0.000 3.16000e-06 0.000 3.16005e-06 1.800 3.16200e-06 1.800
+ 3.16205e-06 0.000 3.16300e-06 0.000 3.16305e-06 1.800 3.16400e-06 1.800 3.16405e-06 0.000 3.16700e-06 0.000
+ 3.16705e-06 1.800 3.16900e-06 1.800 3.16905e-06 0.000 3.17500e-06 0.000 3.17505e-06 1.800 3.17600e-06 1.800
+ 3.17605e-06 0.000 3.17900e-06 0.000 3.17905e-06 1.800 3.18200e-06 1.800 3.18205e-06 0.000 3.18700e-06 0.000
+ 3.18705e-06 1.800 3.18800e-06 1.800 3.18805e-06 0.000 3.18900e-06 0.000 3.18905e-06 1.800 3.19300e-06 1.800
+ 3.19305e-06 0.000 3.19400e-06 0.000 3.19405e-06 1.800 3.19600e-06 1.800 3.19605e-06 0.000 3.19800e-06 0.000
+ 3.19805e-06 1.800 3.20100e-06 1.800 3.20105e-06 0.000 3.20200e-06 0.000 3.20205e-06 1.800 3.20300e-06 1.800
+ 3.20305e-06 0.000 3.20600e-06 0.000 3.20605e-06 1.800 3.20700e-06 1.800 3.20705e-06 0.000 3.20800e-06 0.000
+ 3.20805e-06 1.800 3.20900e-06 1.800 3.20905e-06 0.000 3.21000e-06 0.000 3.21005e-06 1.800 3.21100e-06 1.800
+ 3.21105e-06 0.000 3.21300e-06 0.000 3.21305e-06 1.800 3.21700e-06 1.800 3.21705e-06 0.000 3.21800e-06 0.000
+ 3.21805e-06 1.800 3.21900e-06 1.800 3.21905e-06 0.000 3.22400e-06 0.000 3.22405e-06 1.800 3.22600e-06 1.800
+ 3.22605e-06 0.000 3.22800e-06 0.000 3.22805e-06 1.800 3.23100e-06 1.800 3.23105e-06 0.000 3.23300e-06 0.000
+ 3.23305e-06 1.800 3.23500e-06 1.800 3.23505e-06 0.000 3.23800e-06 0.000 3.23805e-06 1.800 3.24000e-06 1.800
+ 3.24005e-06 0.000 3.24100e-06 0.000 3.24105e-06 1.800 3.24200e-06 1.800 3.24205e-06 0.000 3.24400e-06 0.000
+ 3.24405e-06 1.800 3.24700e-06 1.800 3.24705e-06 0.000 3.24800e-06 0.000 3.24805e-06 1.800 3.25100e-06 1.800
+ 3.25105e-06 0.000 3.25200e-06 0.000 3.25205e-06 1.800 3.25300e-06 1.800 3.25305e-06 0.000 3.25600e-06 0.000
+ 3.25605e-06 1.800 3.25800e-06 1.800 3.25805e-06 0.000 3.25900e-06 0.000 3.25905e-06 1.800 3.26000e-06 1.800
+ 3.26005e-06 0.000 3.26100e-06 0.000 3.26105e-06 1.800 3.26200e-06 1.800 3.26205e-06 0.000 3.26400e-06 0.000
+ 3.26405e-06 1.800 3.26600e-06 1.800 3.26605e-06 0.000 3.26700e-06 0.000 3.26705e-06 1.800 3.26800e-06 1.800
+ 3.26805e-06 0.000 3.26900e-06 0.000 3.26905e-06 1.800 3.27000e-06 1.800 3.27005e-06 0.000 3.27100e-06 0.000
+ 3.27105e-06 1.800 3.27200e-06 1.800 3.27205e-06 0.000 3.27300e-06 0.000 3.27305e-06 1.800 3.27600e-06 1.800
+ 3.27605e-06 0.000 3.27800e-06 0.000 3.27805e-06 1.800 3.27900e-06 1.800 3.27905e-06 0.000 3.28000e-06 0.000
+ 3.28005e-06 1.800 3.28300e-06 1.800 3.28305e-06 0.000 3.28400e-06 0.000 3.28405e-06 1.800 3.28500e-06 1.800
+ 3.28505e-06 0.000 3.28600e-06 0.000 3.28605e-06 1.800 3.28800e-06 1.800 3.28805e-06 0.000 3.29000e-06 0.000
+ 3.29005e-06 1.800 3.29100e-06 1.800 3.29105e-06 0.000 3.29300e-06 0.000 3.29305e-06 1.800 3.29400e-06 1.800
+ 3.29405e-06 0.000 3.29600e-06 0.000 3.29605e-06 1.800 3.30000e-06 1.800 3.30005e-06 0.000 3.30400e-06 0.000
+ 3.30405e-06 1.800 3.31200e-06 1.800 3.31205e-06 0.000 3.31300e-06 0.000 3.31305e-06 1.800 3.31400e-06 1.800
+ 3.31405e-06 0.000 3.31700e-06 0.000 3.31705e-06 1.800 3.32200e-06 1.800 3.32205e-06 0.000 3.32300e-06 0.000
+ 3.32305e-06 1.800 3.32400e-06 1.800 3.32405e-06 0.000 3.32700e-06 0.000 3.32705e-06 1.800 3.32800e-06 1.800
+ 3.32805e-06 0.000 3.33000e-06 0.000 3.33005e-06 1.800 3.33100e-06 1.800 3.33105e-06 0.000 3.33200e-06 0.000
+ 3.33205e-06 1.800 3.33300e-06 1.800 3.33305e-06 0.000 3.33500e-06 0.000 3.33505e-06 1.800 3.33800e-06 1.800
+ 3.33805e-06 0.000 3.33900e-06 0.000 3.33905e-06 1.800 3.34000e-06 1.800 3.34005e-06 0.000 3.34100e-06 0.000
+ 3.34105e-06 1.800 3.34300e-06 1.800 3.34305e-06 0.000 3.34400e-06 0.000 3.34405e-06 1.800 3.34500e-06 1.800
+ 3.34505e-06 0.000 3.34600e-06 0.000 3.34605e-06 1.800 3.34700e-06 1.800 3.34705e-06 0.000 3.35000e-06 0.000
+ 3.35005e-06 1.800 3.35600e-06 1.800 3.35605e-06 0.000 3.35800e-06 0.000 3.35805e-06 1.800 3.36100e-06 1.800
+ 3.36105e-06 0.000 3.36200e-06 0.000 3.36205e-06 1.800 3.36400e-06 1.800 3.36405e-06 0.000 3.36500e-06 0.000
+ 3.36505e-06 1.800 3.36700e-06 1.800 3.36705e-06 0.000 3.36800e-06 0.000 3.36805e-06 1.800 3.37100e-06 1.800
+ 3.37105e-06 0.000 3.37300e-06 0.000 3.37305e-06 1.800 3.37500e-06 1.800 3.37505e-06 0.000 3.37800e-06 0.000
+ 3.37805e-06 1.800 3.37900e-06 1.800 3.37905e-06 0.000 3.38000e-06 0.000 3.38005e-06 1.800 3.38100e-06 1.800
+ 3.38105e-06 0.000 3.38200e-06 0.000 3.38205e-06 1.800 3.38300e-06 1.800 3.38305e-06 0.000 3.38400e-06 0.000
+ 3.38405e-06 1.800 3.38500e-06 1.800 3.38505e-06 0.000 3.38800e-06 0.000 3.38805e-06 1.800 3.38900e-06 1.800
+ 3.38905e-06 0.000 3.39300e-06 0.000 3.39305e-06 1.800 3.39600e-06 1.800 3.39605e-06 0.000 3.39800e-06 0.000
+ 3.39805e-06 1.800 3.39900e-06 1.800 3.39905e-06 0.000 3.40100e-06 0.000 3.40105e-06 1.800 3.40500e-06 1.800
+ 3.40505e-06 0.000 3.40900e-06 0.000 3.40905e-06 1.800 3.41000e-06 1.800 3.41005e-06 0.000 3.41100e-06 0.000
+ 3.41105e-06 1.800 3.41700e-06 1.800 3.41705e-06 0.000 3.41800e-06 0.000 3.41805e-06 1.800 3.41900e-06 1.800
+ 3.41905e-06 0.000 3.42100e-06 0.000 3.42105e-06 1.800 3.42200e-06 1.800 3.42205e-06 0.000 3.42300e-06 0.000
+ 3.42305e-06 1.800 3.42400e-06 1.800 3.42405e-06 0.000 3.42500e-06 0.000 3.42505e-06 1.800 3.42700e-06 1.800
+ 3.42705e-06 0.000 3.42800e-06 0.000 3.42805e-06 1.800 3.42900e-06 1.800 3.42905e-06 0.000 3.43000e-06 0.000
+ 3.43005e-06 1.800 3.43100e-06 1.800 3.43105e-06 0.000 3.43400e-06 0.000 3.43405e-06 1.800 3.43600e-06 1.800
+ 3.43605e-06 0.000 3.44100e-06 0.000 3.44105e-06 1.800 3.44700e-06 1.800 3.44705e-06 0.000 3.44800e-06 0.000
+ 3.44805e-06 1.800 3.45000e-06 1.800 3.45005e-06 0.000 3.45200e-06 0.000 3.45205e-06 1.800 3.45300e-06 1.800
+ 3.45305e-06 0.000 3.46000e-06 0.000 3.46005e-06 1.800 3.46200e-06 1.800 3.46205e-06 0.000 3.46500e-06 0.000
+ 3.46505e-06 1.800 3.46700e-06 1.800 3.46705e-06 0.000 3.47000e-06 0.000 3.47005e-06 1.800 3.47100e-06 1.800
+ 3.47105e-06 0.000 3.47200e-06 0.000 3.47205e-06 1.800 3.47300e-06 1.800 3.47305e-06 0.000 3.47600e-06 0.000
+ 3.47605e-06 1.800 3.47700e-06 1.800 3.47705e-06 0.000 3.47800e-06 0.000 3.47805e-06 1.800 3.47900e-06 1.800
+ 3.47905e-06 0.000 3.48000e-06 0.000 3.48005e-06 1.800 3.48300e-06 1.800 3.48305e-06 0.000 3.48500e-06 0.000
+ 3.48505e-06 1.800 3.48700e-06 1.800 3.48705e-06 0.000 3.48800e-06 0.000 3.48805e-06 1.800 3.48900e-06 1.800
+ 3.48905e-06 0.000 3.49000e-06 0.000 3.49005e-06 1.800 3.49200e-06 1.800 3.49205e-06 0.000 3.49300e-06 0.000
+ 3.49305e-06 1.800 3.49600e-06 1.800 3.49605e-06 0.000 3.50000e-06 0.000 3.50005e-06 1.800 3.50100e-06 1.800
+ 3.50105e-06 0.000 3.50200e-06 0.000 3.50205e-06 1.800 3.50900e-06 1.800 3.50905e-06 0.000 3.51000e-06 0.000
+ 3.51005e-06 1.800 3.51200e-06 1.800 3.51205e-06 0.000 3.51500e-06 0.000 3.51505e-06 1.800 3.51900e-06 1.800
+ 3.51905e-06 0.000 3.52000e-06 0.000 3.52005e-06 1.800 3.52100e-06 1.800 3.52105e-06 0.000 3.52200e-06 0.000
+ 3.52205e-06 1.800 3.52300e-06 1.800 3.52305e-06 0.000 3.52800e-06 0.000 3.52805e-06 1.800 3.53000e-06 1.800
+ 3.53005e-06 0.000 3.53100e-06 0.000 3.53105e-06 1.800 3.53200e-06 1.800 3.53205e-06 0.000 3.53700e-06 0.000
+ 3.53705e-06 1.800 3.54100e-06 1.800 3.54105e-06 0.000 3.54200e-06 0.000 3.54205e-06 1.800 3.54600e-06 1.800
+ 3.54605e-06 0.000 3.54800e-06 0.000 3.54805e-06 1.800 3.54900e-06 1.800 3.54905e-06 0.000 3.55000e-06 0.000
+ 3.55005e-06 1.800 3.55500e-06 1.800 3.55505e-06 0.000 3.55700e-06 0.000 3.55705e-06 1.800 3.55800e-06 1.800
+ 3.55805e-06 0.000 3.55900e-06 0.000 3.55905e-06 1.800 3.56200e-06 1.800 3.56205e-06 0.000 3.56400e-06 0.000
+ 3.56405e-06 1.800 3.56600e-06 1.800 3.56605e-06 0.000 3.56700e-06 0.000 3.56705e-06 1.800 3.56800e-06 1.800
+ 3.56805e-06 0.000 3.56900e-06 0.000 3.56905e-06 1.800 3.57100e-06 1.800 3.57105e-06 0.000 3.57200e-06 0.000
+ 3.57205e-06 1.800 3.57400e-06 1.800 3.57405e-06 0.000 3.57500e-06 0.000 3.57505e-06 1.800 3.57600e-06 1.800
+ 3.57605e-06 0.000 3.57800e-06 0.000 3.57805e-06 1.800 3.57900e-06 1.800 3.57905e-06 0.000 3.58000e-06 0.000
+ 3.58005e-06 1.800 3.58300e-06 1.800 3.58305e-06 0.000 3.58500e-06 0.000 3.58505e-06 1.800 3.58600e-06 1.800
+ 3.58605e-06 0.000 3.58700e-06 0.000 3.58705e-06 1.800 3.58900e-06 1.800 3.58905e-06 0.000 3.59000e-06 0.000
+ 3.59005e-06 1.800 3.59500e-06 1.800 3.59505e-06 0.000 3.59600e-06 0.000 3.59605e-06 1.800 3.59700e-06 1.800
+ 3.59705e-06 0.000 3.59800e-06 0.000 3.59805e-06 1.800 3.60300e-06 1.800 3.60305e-06 0.000 3.60400e-06 0.000
+ 3.60405e-06 1.800 3.60500e-06 1.800 3.60505e-06 0.000 3.60700e-06 0.000 3.60705e-06 1.800 3.60800e-06 1.800
+ 3.60805e-06 0.000 3.60900e-06 0.000 3.60905e-06 1.800 3.61000e-06 1.800 3.61005e-06 0.000 3.61200e-06 0.000
+ 3.61205e-06 1.800 3.61600e-06 1.800 3.61605e-06 0.000 3.61800e-06 0.000 3.61805e-06 1.800 3.61900e-06 1.800
+ 3.61905e-06 0.000 3.62100e-06 0.000 3.62105e-06 1.800 3.62200e-06 1.800 3.62205e-06 0.000 3.62500e-06 0.000
+ 3.62505e-06 1.800 3.62600e-06 1.800 3.62605e-06 0.000 3.63000e-06 0.000 3.63005e-06 1.800 3.63100e-06 1.800
+ 3.63105e-06 0.000 3.63300e-06 0.000 3.63305e-06 1.800 3.63400e-06 1.800 3.63405e-06 0.000 3.63500e-06 0.000
+ 3.63505e-06 1.800 3.63700e-06 1.800 3.63705e-06 0.000 3.64100e-06 0.000 3.64105e-06 1.800 3.64300e-06 1.800
+ 3.64305e-06 0.000 3.64500e-06 0.000 3.64505e-06 1.800 3.64700e-06 1.800 3.64705e-06 0.000 3.64800e-06 0.000
+ 3.64805e-06 1.800 3.65000e-06 1.800 3.65005e-06 0.000 3.65200e-06 0.000 3.65205e-06 1.800 3.65300e-06 1.800
+ 3.65305e-06 0.000 3.65900e-06 0.000 3.65905e-06 1.800 3.66400e-06 1.800 3.66405e-06 0.000 3.66700e-06 0.000
+ 3.66705e-06 1.800 3.66900e-06 1.800 3.66905e-06 0.000 3.67100e-06 0.000 3.67105e-06 1.800 3.67500e-06 1.800
+ 3.67505e-06 0.000 3.67600e-06 0.000 3.67605e-06 1.800 3.67800e-06 1.800 3.67805e-06 0.000 3.67900e-06 0.000
+ 3.67905e-06 1.800 3.68600e-06 1.800 3.68605e-06 0.000 3.68700e-06 0.000 3.68705e-06 1.800 3.69400e-06 1.800
+ 3.69405e-06 0.000 3.69500e-06 0.000 3.69505e-06 1.800 3.69700e-06 1.800 3.69705e-06 0.000 3.69800e-06 0.000
+ 3.69805e-06 1.800 3.69900e-06 1.800 3.69905e-06 0.000 3.70000e-06 0.000 3.70005e-06 1.800 3.70200e-06 1.800
+ 3.70205e-06 0.000 3.70300e-06 0.000 3.70305e-06 1.800 3.70600e-06 1.800 3.70605e-06 0.000 3.70700e-06 0.000
+ 3.70705e-06 1.800 3.70900e-06 1.800 3.70905e-06 0.000 3.71200e-06 0.000 3.71205e-06 1.800 3.71600e-06 1.800
+ 3.71605e-06 0.000 3.71700e-06 0.000 3.71705e-06 1.800 3.71800e-06 1.800 3.71805e-06 0.000 3.72000e-06 0.000
+ 3.72005e-06 1.800 3.72100e-06 1.800 3.72105e-06 0.000 3.72200e-06 0.000 3.72205e-06 1.800 3.72400e-06 1.800
+ 3.72405e-06 0.000 3.72600e-06 0.000 3.72605e-06 1.800 3.72900e-06 1.800 3.72905e-06 0.000 3.73000e-06 0.000
+ 3.73005e-06 1.800 3.73100e-06 1.800 3.73105e-06 0.000 3.73400e-06 0.000 3.73405e-06 1.800 3.73500e-06 1.800
+ 3.73505e-06 0.000 3.73800e-06 0.000 3.73805e-06 1.800 3.74100e-06 1.800 3.74105e-06 0.000 3.74200e-06 0.000
+ 3.74205e-06 1.800 3.74400e-06 1.800 3.74405e-06 0.000 3.74500e-06 0.000 3.74505e-06 1.800 3.74600e-06 1.800
+ 3.74605e-06 0.000 3.75000e-06 0.000 3.75005e-06 1.800 3.75100e-06 1.800 3.75105e-06 0.000 3.75300e-06 0.000
+ 3.75305e-06 1.800 3.75500e-06 1.800 3.75505e-06 0.000 3.75900e-06 0.000 3.75905e-06 1.800 3.76000e-06 1.800
+ 3.76005e-06 0.000 3.76100e-06 0.000 3.76105e-06 1.800 3.76500e-06 1.800 3.76505e-06 0.000 3.76600e-06 0.000
+ 3.76605e-06 1.800 3.77100e-06 1.800 3.77105e-06 0.000 3.77300e-06 0.000 3.77305e-06 1.800 3.77500e-06 1.800
+ 3.77505e-06 0.000 3.77600e-06 0.000 3.77605e-06 1.800 3.77700e-06 1.800 3.77705e-06 0.000 3.77800e-06 0.000
+ 3.77805e-06 1.800 3.77900e-06 1.800 3.77905e-06 0.000 3.78100e-06 0.000 3.78105e-06 1.800 3.78200e-06 1.800
+ 3.78205e-06 0.000 3.78300e-06 0.000 3.78305e-06 1.800 3.78400e-06 1.800 3.78405e-06 0.000 3.78500e-06 0.000
+ 3.78505e-06 1.800 3.78700e-06 1.800 3.78705e-06 0.000 3.78900e-06 0.000 3.78905e-06 1.800 3.79400e-06 1.800
+ 3.79405e-06 0.000 3.79500e-06 0.000 3.79505e-06 1.800 3.79600e-06 1.800 3.79605e-06 0.000 3.79700e-06 0.000
+ 3.79705e-06 1.800 3.79800e-06 1.800 3.79805e-06 0.000 3.80000e-06 0.000 3.80005e-06 1.800 3.80100e-06 1.800
+ 3.80105e-06 0.000 3.80200e-06 0.000 3.80205e-06 1.800 3.80500e-06 1.800 3.80505e-06 0.000 3.80700e-06 0.000
+ 3.80705e-06 1.800 3.81000e-06 1.800 3.81005e-06 0.000 3.81100e-06 0.000 3.81105e-06 1.800 3.81400e-06 1.800
+ 3.81405e-06 0.000 3.81500e-06 0.000 3.81505e-06 1.800 3.82000e-06 1.800 3.82005e-06 0.000 3.82300e-06 0.000
+ 3.82305e-06 1.800 3.82500e-06 1.800 3.82505e-06 0.000 3.83000e-06 0.000 3.83005e-06 1.800 3.83200e-06 1.800
+ 3.83205e-06 0.000 3.83300e-06 0.000 3.83305e-06 1.800 3.83400e-06 1.800 3.83405e-06 0.000 3.83800e-06 0.000
+ 3.83805e-06 1.800 3.83900e-06 1.800 3.83905e-06 0.000 3.84100e-06 0.000 3.84105e-06 1.800 3.84300e-06 1.800
+ 3.84305e-06 0.000 3.84400e-06 0.000 3.84405e-06 1.800 3.84500e-06 1.800 3.84505e-06 0.000 3.84900e-06 0.000
+ 3.84905e-06 1.800 3.85000e-06 1.800 3.85005e-06 0.000 3.85300e-06 0.000 3.85305e-06 1.800 3.85400e-06 1.800
+ 3.85405e-06 0.000 3.85800e-06 0.000 3.85805e-06 1.800 3.86000e-06 1.800 3.86005e-06 0.000 3.86200e-06 0.000
+ 3.86205e-06 1.800 3.86300e-06 1.800 3.86305e-06 0.000 3.86400e-06 0.000 3.86405e-06 1.800 3.86500e-06 1.800
+ 3.86505e-06 0.000 3.86800e-06 0.000 3.86805e-06 1.800 3.87000e-06 1.800 3.87005e-06 0.000 3.87100e-06 0.000
+ 3.87105e-06 1.800 3.87300e-06 1.800 3.87305e-06 0.000 3.87700e-06 0.000 3.87705e-06 1.800 3.87800e-06 1.800
+ 3.87805e-06 0.000 3.88000e-06 0.000 3.88005e-06 1.800 3.88100e-06 1.800 3.88105e-06 0.000 3.88300e-06 0.000
+ 3.88305e-06 1.800 3.88500e-06 1.800 3.88505e-06 0.000 3.88900e-06 0.000 3.88905e-06 1.800 3.89000e-06 1.800
+ 3.89005e-06 0.000 3.89300e-06 0.000 3.89305e-06 1.800 3.89500e-06 1.800 3.89505e-06 0.000 3.89600e-06 0.000
+ 3.89605e-06 1.800 3.89800e-06 1.800 3.89805e-06 0.000 3.89900e-06 0.000 3.89905e-06 1.800 3.90100e-06 1.800
+ 3.90105e-06 0.000 3.90400e-06 0.000 3.90405e-06 1.800 3.90600e-06 1.800 3.90605e-06 0.000 3.90700e-06 0.000
+ 3.90705e-06 1.800 3.91100e-06 1.800 3.91105e-06 0.000 3.91200e-06 0.000 3.91205e-06 1.800 3.91600e-06 1.800
+ 3.91605e-06 0.000 3.91700e-06 0.000 3.91705e-06 1.800 3.91800e-06 1.800 3.91805e-06 0.000 3.91900e-06 0.000
+ 3.91905e-06 1.800 3.92100e-06 1.800 3.92105e-06 0.000 3.92200e-06 0.000 3.92205e-06 1.800 3.92300e-06 1.800
+ 3.92305e-06 0.000 3.92400e-06 0.000 3.92405e-06 1.800 3.92500e-06 1.800 3.92505e-06 0.000 3.92800e-06 0.000
+ 3.92805e-06 1.800 3.92900e-06 1.800 3.92905e-06 0.000 3.93100e-06 0.000 3.93105e-06 1.800 3.93500e-06 1.800
+ 3.93505e-06 0.000 3.93800e-06 0.000 3.93805e-06 1.800 3.94100e-06 1.800 3.94105e-06 0.000 3.94200e-06 0.000
+ 3.94205e-06 1.800 3.94800e-06 1.800 3.94805e-06 0.000 3.94900e-06 0.000 3.94905e-06 1.800 3.95000e-06 1.800
+ 3.95005e-06 0.000 3.95200e-06 0.000 3.95205e-06 1.800 3.95400e-06 1.800 3.95405e-06 0.000 3.95500e-06 0.000
+ 3.95505e-06 1.800 3.95900e-06 1.800 3.95905e-06 0.000 3.96200e-06 0.000 3.96205e-06 1.800 3.96300e-06 1.800
+ 3.96305e-06 0.000 3.96600e-06 0.000 3.96605e-06 1.800 3.96800e-06 1.800 3.96805e-06 0.000 3.97000e-06 0.000
+ 3.97005e-06 1.800 3.97100e-06 1.800 3.97105e-06 0.000 3.97300e-06 0.000 3.97305e-06 1.800 3.97500e-06 1.800
+ 3.97505e-06 0.000 3.98000e-06 0.000 3.98005e-06 1.800 3.98200e-06 1.800 3.98205e-06 0.000 3.98300e-06 0.000
+ 3.98305e-06 1.800 3.98400e-06 1.800 3.98405e-06 0.000 3.98500e-06 0.000 3.98505e-06 1.800 3.98600e-06 1.800
+ 3.98605e-06 0.000 3.99000e-06 0.000 3.99005e-06 1.800 3.99100e-06 1.800 3.99105e-06 0.000 3.99300e-06 0.000
+ 3.99305e-06 1.800 3.99400e-06 1.800 3.99405e-06 0.000 3.99700e-06 0.000 3.99705e-06 1.800 4.00200e-06 1.800
+ 4.00205e-06 0.000 4.00400e-06 0.000 4.00405e-06 1.800 4.00900e-06 1.800 4.00905e-06 0.000 4.01000e-06 0.000
+ 4.01005e-06 1.800 4.01200e-06 1.800 4.01205e-06 0.000 4.01400e-06 0.000 4.01405e-06 1.800 4.01500e-06 1.800
+ 4.01505e-06 0.000 4.01600e-06 0.000 4.01605e-06 1.800 4.01900e-06 1.800 4.01905e-06 0.000 4.02000e-06 0.000
+ 4.02005e-06 1.800 4.02100e-06 1.800 4.02105e-06 0.000 4.02200e-06 0.000 4.02205e-06 1.800 4.02300e-06 1.800
+ 4.02305e-06 0.000 4.02400e-06 0.000 4.02405e-06 1.800 4.02800e-06 1.800 4.02805e-06 0.000 4.02900e-06 0.000
+ 4.02905e-06 1.800 4.03000e-06 1.800 4.03005e-06 0.000 4.03100e-06 0.000 4.03105e-06 1.800 4.03200e-06 1.800
+ 4.03205e-06 0.000 4.03300e-06 0.000 4.03305e-06 1.800 4.03400e-06 1.800 4.03405e-06 0.000 4.03500e-06 0.000
+ 4.03505e-06 1.800 4.03700e-06 1.800 4.03705e-06 0.000 4.03900e-06 0.000 4.03905e-06 1.800 4.04000e-06 1.800
+ 4.04005e-06 0.000 4.04200e-06 0.000 4.04205e-06 1.800 4.04300e-06 1.800 4.04305e-06 0.000 4.04500e-06 0.000
+ 4.04505e-06 1.800 4.04700e-06 1.800 4.04705e-06 0.000 4.04800e-06 0.000 4.04805e-06 1.800 4.05100e-06 1.800
+ 4.05105e-06 0.000 4.05300e-06 0.000 4.05305e-06 1.800 4.05400e-06 1.800 4.05405e-06 0.000 4.05500e-06 0.000
+ 4.05505e-06 1.800 4.05700e-06 1.800 4.05705e-06 0.000 4.06000e-06 0.000 4.06005e-06 1.800 4.06100e-06 1.800
+ 4.06105e-06 0.000 4.06300e-06 0.000 4.06305e-06 1.800 4.06400e-06 1.800 4.06405e-06 0.000 4.06500e-06 0.000
+ 4.06505e-06 1.800 4.07000e-06 1.800 4.07005e-06 0.000 4.07100e-06 0.000 4.07105e-06 1.800 4.07300e-06 1.800
+ 4.07305e-06 0.000 4.07600e-06 0.000 4.07605e-06 1.800 4.07700e-06 1.800 4.07705e-06 0.000 4.07900e-06 0.000
+ 4.07905e-06 1.800 4.08100e-06 1.800 4.08105e-06 0.000 4.08200e-06 0.000 4.08205e-06 1.800 4.08300e-06 1.800
+ 4.08305e-06 0.000 4.08500e-06 0.000 4.08505e-06 1.800 4.08600e-06 1.800 4.08605e-06 0.000 4.08800e-06 0.000
+ 4.08805e-06 1.800 4.08900e-06 1.800 4.08905e-06 0.000 4.09000e-06 0.000 4.09005e-06 1.800 4.09200e-06 1.800
+ 4.09205e-06 0.000 4.09400e-06 0.000 4.09405e-06 1.800 4.09500e-06 1.800 4.09505e-06 0.000 4.09600e-06 0.000
+ )
Xd_a3 src_a3 a3 vdd gnd tb_inv
Vb3 src_b3 gnd PWL(
+ 0.00000e+00 1.800 1.00000e-09 1.800 1.05000e-09 0.000 2.00000e-09 0.000 2.05000e-09 1.800 3.00000e-09 1.800
+ 3.05000e-09 0.000 4.00000e-09 0.000 4.05000e-09 1.800 5.00000e-09 1.800 5.05000e-09 0.000 6.00000e-09 0.000
+ 6.05000e-09 1.800 7.00000e-09 1.800 7.05000e-09 0.000 8.00000e-09 0.000 8.05000e-09 1.800 9.00000e-09 1.800
+ 9.05000e-09 0.000 1.00000e-08 0.000 1.00500e-08 1.800 1.10000e-08 1.800 1.10500e-08 0.000 1.20000e-08 0.000
+ 1.20500e-08 1.800 1.30000e-08 1.800 1.30500e-08 0.000 1.40000e-08 0.000 1.40500e-08 1.800 1.50000e-08 1.800
+ 1.50500e-08 0.000 1.60000e-08 0.000 1.60500e-08 1.800 1.70000e-08 1.800 1.70500e-08 0.000 1.80000e-08 0.000
+ 1.80500e-08 1.800 1.90000e-08 1.800 1.90500e-08 0.000 2.00000e-08 0.000 2.00500e-08 1.800 2.10000e-08 1.800
+ 2.10500e-08 0.000 2.20000e-08 0.000 2.20500e-08 1.800 2.30000e-08 1.800 2.30500e-08 0.000 2.40000e-08 0.000
+ 2.40500e-08 1.800 2.50000e-08 1.800 2.50500e-08 0.000 2.60000e-08 0.000 2.60500e-08 1.800 2.70000e-08 1.800
+ 2.70500e-08 0.000 2.80000e-08 0.000 2.80500e-08 1.800 2.90000e-08 1.800 2.90500e-08 0.000 3.00000e-08 0.000
+ 3.00500e-08 1.800 3.10000e-08 1.800 3.10500e-08 0.000 3.20000e-08 0.000 3.20500e-08 1.800 3.30000e-08 1.800
+ 3.30500e-08 0.000 3.40000e-08 0.000 3.40500e-08 1.800 3.50000e-08 1.800 3.50500e-08 0.000 3.60000e-08 0.000
+ 3.60500e-08 1.800 3.70000e-08 1.800 3.70500e-08 0.000 3.80000e-08 0.000 3.80500e-08 1.800 3.90000e-08 1.800
+ 3.90500e-08 0.000 4.00000e-08 0.000 4.00500e-08 1.800 4.10000e-08 1.800 4.10500e-08 0.000 4.20000e-08 0.000
+ 4.20500e-08 1.800 4.30000e-08 1.800 4.30500e-08 0.000 4.40000e-08 0.000 4.40500e-08 1.800 4.50000e-08 1.800
+ 4.50500e-08 0.000 4.60000e-08 0.000 4.60500e-08 1.800 4.70000e-08 1.800 4.70500e-08 0.000 4.80000e-08 0.000
+ 4.80500e-08 1.800 4.90000e-08 1.800 4.90500e-08 0.000 5.00000e-08 0.000 5.00500e-08 1.800 5.10000e-08 1.800
+ 5.10500e-08 0.000 5.20000e-08 0.000 5.20500e-08 1.800 5.30000e-08 1.800 5.30500e-08 0.000 5.40000e-08 0.000
+ 5.40500e-08 1.800 5.50000e-08 1.800 5.50500e-08 0.000 5.60000e-08 0.000 5.60500e-08 1.800 5.70000e-08 1.800
+ 5.70500e-08 0.000 5.80000e-08 0.000 5.80500e-08 1.800 5.90000e-08 1.800 5.90500e-08 0.000 6.00000e-08 0.000
+ 6.00500e-08 1.800 6.10000e-08 1.800 6.10500e-08 0.000 6.20000e-08 0.000 6.20500e-08 1.800 6.30000e-08 1.800
+ 6.30500e-08 0.000 6.40000e-08 0.000 6.40500e-08 1.800 6.50000e-08 1.800 6.50500e-08 0.000 6.60000e-08 0.000
+ 6.60500e-08 1.800 6.70000e-08 1.800 6.70500e-08 0.000 6.80000e-08 0.000 6.80500e-08 1.800 6.90000e-08 1.800
+ 6.90500e-08 0.000 7.00000e-08 0.000 7.00500e-08 1.800 7.10000e-08 1.800 7.10500e-08 0.000 7.20000e-08 0.000
+ 7.20500e-08 1.800 7.30000e-08 1.800 7.30500e-08 0.000 7.40000e-08 0.000 7.40500e-08 1.800 7.50000e-08 1.800
+ 7.50500e-08 0.000 7.60000e-08 0.000 7.60500e-08 1.800 7.70000e-08 1.800 7.70500e-08 0.000 7.80000e-08 0.000
+ 7.80500e-08 1.800 7.90000e-08 1.800 7.90500e-08 0.000 8.00000e-08 0.000 8.00500e-08 1.800 8.10000e-08 1.800
+ 8.10500e-08 0.000 8.20000e-08 0.000 8.20500e-08 1.800 8.30000e-08 1.800 8.30500e-08 0.000 8.40000e-08 0.000
+ 8.40500e-08 1.800 8.50000e-08 1.800 8.50500e-08 0.000 8.60000e-08 0.000 8.60500e-08 1.800 8.70000e-08 1.800
+ 8.70500e-08 0.000 8.80000e-08 0.000 8.80500e-08 1.800 8.90000e-08 1.800 8.90500e-08 0.000 9.00000e-08 0.000
+ 9.00500e-08 1.800 9.10000e-08 1.800 9.10500e-08 0.000 9.20000e-08 0.000 9.20500e-08 1.800 9.30000e-08 1.800
+ 9.30500e-08 0.000 9.40000e-08 0.000 9.40500e-08 1.800 9.50000e-08 1.800 9.50500e-08 0.000 9.60000e-08 0.000
+ 9.60500e-08 1.800 9.70000e-08 1.800 9.70500e-08 0.000 9.80000e-08 0.000 9.80500e-08 1.800 9.90000e-08 1.800
+ 9.90500e-08 0.000 1.00000e-07 0.000 1.00050e-07 1.800 1.01000e-07 1.800 1.01050e-07 0.000 1.02000e-07 0.000
+ 1.02050e-07 1.800 1.03000e-07 1.800 1.03050e-07 0.000 1.04000e-07 0.000 1.04050e-07 1.800 1.05000e-07 1.800
+ 1.05050e-07 0.000 1.06000e-07 0.000 1.06050e-07 1.800 1.07000e-07 1.800 1.07050e-07 0.000 1.08000e-07 0.000
+ 1.08050e-07 1.800 1.09000e-07 1.800 1.09050e-07 0.000 1.10000e-07 0.000 1.10050e-07 1.800 1.11000e-07 1.800
+ 1.11050e-07 0.000 1.12000e-07 0.000 1.12050e-07 1.800 1.13000e-07 1.800 1.13050e-07 0.000 1.14000e-07 0.000
+ 1.14050e-07 1.800 1.15000e-07 1.800 1.15050e-07 0.000 1.16000e-07 0.000 1.16050e-07 1.800 1.17000e-07 1.800
+ 1.17050e-07 0.000 1.18000e-07 0.000 1.18050e-07 1.800 1.19000e-07 1.800 1.19050e-07 0.000 1.20000e-07 0.000
+ 1.20050e-07 1.800 1.21000e-07 1.800 1.21050e-07 0.000 1.22000e-07 0.000 1.22050e-07 1.800 1.23000e-07 1.800
+ 1.23050e-07 0.000 1.24000e-07 0.000 1.24050e-07 1.800 1.25000e-07 1.800 1.25050e-07 0.000 1.26000e-07 0.000
+ 1.26050e-07 1.800 1.27000e-07 1.800 1.27050e-07 0.000 1.28000e-07 0.000 1.28050e-07 1.800 1.29000e-07 1.800
+ 1.29050e-07 0.000 1.30000e-07 0.000 1.30050e-07 1.800 1.31000e-07 1.800 1.31050e-07 0.000 1.32000e-07 0.000
+ 1.32050e-07 1.800 1.33000e-07 1.800 1.33050e-07 0.000 1.34000e-07 0.000 1.34050e-07 1.800 1.35000e-07 1.800
+ 1.35050e-07 0.000 1.36000e-07 0.000 1.36050e-07 1.800 1.37000e-07 1.800 1.37050e-07 0.000 1.38000e-07 0.000
+ 1.38050e-07 1.800 1.39000e-07 1.800 1.39050e-07 0.000 1.40000e-07 0.000 1.40050e-07 1.800 1.41000e-07 1.800
+ 1.41050e-07 0.000 1.42000e-07 0.000 1.42050e-07 1.800 1.43000e-07 1.800 1.43050e-07 0.000 1.44000e-07 0.000
+ 1.44050e-07 1.800 1.45000e-07 1.800 1.45050e-07 0.000 1.46000e-07 0.000 1.46050e-07 1.800 1.47000e-07 1.800
+ 1.47050e-07 0.000 1.48000e-07 0.000 1.48050e-07 1.800 1.49000e-07 1.800 1.49050e-07 0.000 1.50000e-07 0.000
+ 1.50050e-07 1.800 1.51000e-07 1.800 1.51050e-07 0.000 1.52000e-07 0.000 1.52050e-07 1.800 1.53000e-07 1.800
+ 1.53050e-07 0.000 1.54000e-07 0.000 1.54050e-07 1.800 1.55000e-07 1.800 1.55050e-07 0.000 1.56000e-07 0.000
+ 1.56050e-07 1.800 1.57000e-07 1.800 1.57050e-07 0.000 1.58000e-07 0.000 1.58050e-07 1.800 1.59000e-07 1.800
+ 1.59050e-07 0.000 1.60000e-07 0.000 1.60050e-07 1.800 1.61000e-07 1.800 1.61050e-07 0.000 1.62000e-07 0.000
+ 1.62050e-07 1.800 1.63000e-07 1.800 1.63050e-07 0.000 1.64000e-07 0.000 1.64050e-07 1.800 1.65000e-07 1.800
+ 1.65050e-07 0.000 1.66000e-07 0.000 1.66050e-07 1.800 1.67000e-07 1.800 1.67050e-07 0.000 1.68000e-07 0.000
+ 1.68050e-07 1.800 1.69000e-07 1.800 1.69050e-07 0.000 1.70000e-07 0.000 1.70050e-07 1.800 1.71000e-07 1.800
+ 1.71050e-07 0.000 1.72000e-07 0.000 1.72050e-07 1.800 1.73000e-07 1.800 1.73050e-07 0.000 1.74000e-07 0.000
+ 1.74050e-07 1.800 1.75000e-07 1.800 1.75050e-07 0.000 1.76000e-07 0.000 1.76050e-07 1.800 1.77000e-07 1.800
+ 1.77050e-07 0.000 1.78000e-07 0.000 1.78050e-07 1.800 1.79000e-07 1.800 1.79050e-07 0.000 1.80000e-07 0.000
+ 1.80050e-07 1.800 1.81000e-07 1.800 1.81050e-07 0.000 1.82000e-07 0.000 1.82050e-07 1.800 1.83000e-07 1.800
+ 1.83050e-07 0.000 1.84000e-07 0.000 1.84050e-07 1.800 1.85000e-07 1.800 1.85050e-07 0.000 1.86000e-07 0.000
+ 1.86050e-07 1.800 1.87000e-07 1.800 1.87050e-07 0.000 1.88000e-07 0.000 1.88050e-07 1.800 1.89000e-07 1.800
+ 1.89050e-07 0.000 1.90000e-07 0.000 1.90050e-07 1.800 1.91000e-07 1.800 1.91050e-07 0.000 1.92000e-07 0.000
+ 1.92050e-07 1.800 1.93000e-07 1.800 1.93050e-07 0.000 1.94000e-07 0.000 1.94050e-07 1.800 1.95000e-07 1.800
+ 1.95050e-07 0.000 1.96000e-07 0.000 1.96050e-07 1.800 1.97000e-07 1.800 1.97050e-07 0.000 1.98000e-07 0.000
+ 1.98050e-07 1.800 1.99000e-07 1.800 1.99050e-07 0.000 2.00000e-07 0.000 2.00050e-07 1.800 2.01000e-07 1.800
+ 2.01050e-07 0.000 2.02000e-07 0.000 2.02050e-07 1.800 2.03000e-07 1.800 2.03050e-07 0.000 2.04000e-07 0.000
+ 2.04050e-07 1.800 2.05000e-07 1.800 2.05050e-07 0.000 2.06000e-07 0.000 2.06050e-07 1.800 2.07000e-07 1.800
+ 2.07050e-07 0.000 2.08000e-07 0.000 2.08050e-07 1.800 2.09000e-07 1.800 2.09050e-07 0.000 2.10000e-07 0.000
+ 2.10050e-07 1.800 2.11000e-07 1.800 2.11050e-07 0.000 2.12000e-07 0.000 2.12050e-07 1.800 2.13000e-07 1.800
+ 2.13050e-07 0.000 2.14000e-07 0.000 2.14050e-07 1.800 2.15000e-07 1.800 2.15050e-07 0.000 2.16000e-07 0.000
+ 2.16050e-07 1.800 2.17000e-07 1.800 2.17050e-07 0.000 2.18000e-07 0.000 2.18050e-07 1.800 2.19000e-07 1.800
+ 2.19050e-07 0.000 2.20000e-07 0.000 2.20050e-07 1.800 2.21000e-07 1.800 2.21050e-07 0.000 2.22000e-07 0.000
+ 2.22050e-07 1.800 2.23000e-07 1.800 2.23050e-07 0.000 2.24000e-07 0.000 2.24050e-07 1.800 2.25000e-07 1.800
+ 2.25050e-07 0.000 2.26000e-07 0.000 2.26050e-07 1.800 2.27000e-07 1.800 2.27050e-07 0.000 2.28000e-07 0.000
+ 2.28050e-07 1.800 2.29000e-07 1.800 2.29050e-07 0.000 2.30000e-07 0.000 2.30050e-07 1.800 2.31000e-07 1.800
+ 2.31050e-07 0.000 2.32000e-07 0.000 2.32050e-07 1.800 2.33000e-07 1.800 2.33050e-07 0.000 2.34000e-07 0.000
+ 2.34050e-07 1.800 2.35000e-07 1.800 2.35050e-07 0.000 2.36000e-07 0.000 2.36050e-07 1.800 2.37000e-07 1.800
+ 2.37050e-07 0.000 2.38000e-07 0.000 2.38050e-07 1.800 2.39000e-07 1.800 2.39050e-07 0.000 2.40000e-07 0.000
+ 2.40050e-07 1.800 2.41000e-07 1.800 2.41050e-07 0.000 2.42000e-07 0.000 2.42050e-07 1.800 2.43000e-07 1.800
+ 2.43050e-07 0.000 2.44000e-07 0.000 2.44050e-07 1.800 2.45000e-07 1.800 2.45050e-07 0.000 2.46000e-07 0.000
+ 2.46050e-07 1.800 2.47000e-07 1.800 2.47050e-07 0.000 2.48000e-07 0.000 2.48050e-07 1.800 2.49000e-07 1.800
+ 2.49050e-07 0.000 2.50000e-07 0.000 2.50050e-07 1.800 2.51000e-07 1.800 2.51050e-07 0.000 2.52000e-07 0.000
+ 2.52050e-07 1.800 2.53000e-07 1.800 2.53050e-07 0.000 2.54000e-07 0.000 2.54050e-07 1.800 2.55000e-07 1.800
+ 2.55050e-07 0.000 2.56000e-07 0.000 2.56050e-07 1.800 2.57000e-07 1.800 2.57050e-07 0.000 2.58000e-07 0.000
+ 2.58050e-07 1.800 2.59000e-07 1.800 2.59050e-07 0.000 2.60000e-07 0.000 2.60050e-07 1.800 2.61000e-07 1.800
+ 2.61050e-07 0.000 2.62000e-07 0.000 2.62050e-07 1.800 2.63000e-07 1.800 2.63050e-07 0.000 2.64000e-07 0.000
+ 2.64050e-07 1.800 2.65000e-07 1.800 2.65050e-07 0.000 2.66000e-07 0.000 2.66050e-07 1.800 2.67000e-07 1.800
+ 2.67050e-07 0.000 2.68000e-07 0.000 2.68050e-07 1.800 2.69000e-07 1.800 2.69050e-07 0.000 2.70000e-07 0.000
+ 2.70050e-07 1.800 2.71000e-07 1.800 2.71050e-07 0.000 2.72000e-07 0.000 2.72050e-07 1.800 2.73000e-07 1.800
+ 2.73050e-07 0.000 2.74000e-07 0.000 2.74050e-07 1.800 2.75000e-07 1.800 2.75050e-07 0.000 2.76000e-07 0.000
+ 2.76050e-07 1.800 2.77000e-07 1.800 2.77050e-07 0.000 2.78000e-07 0.000 2.78050e-07 1.800 2.79000e-07 1.800
+ 2.79050e-07 0.000 2.80000e-07 0.000 2.80050e-07 1.800 2.81000e-07 1.800 2.81050e-07 0.000 2.82000e-07 0.000
+ 2.82050e-07 1.800 2.83000e-07 1.800 2.83050e-07 0.000 2.84000e-07 0.000 2.84050e-07 1.800 2.85000e-07 1.800
+ 2.85050e-07 0.000 2.86000e-07 0.000 2.86050e-07 1.800 2.87000e-07 1.800 2.87050e-07 0.000 2.88000e-07 0.000
+ 2.88050e-07 1.800 2.89000e-07 1.800 2.89050e-07 0.000 2.90000e-07 0.000 2.90050e-07 1.800 2.91000e-07 1.800
+ 2.91050e-07 0.000 2.92000e-07 0.000 2.92050e-07 1.800 2.93000e-07 1.800 2.93050e-07 0.000 2.94000e-07 0.000
+ 2.94050e-07 1.800 2.95000e-07 1.800 2.95050e-07 0.000 2.96000e-07 0.000 2.96050e-07 1.800 2.97000e-07 1.800
+ 2.97050e-07 0.000 2.98000e-07 0.000 2.98050e-07 1.800 2.99000e-07 1.800 2.99050e-07 0.000 3.00000e-07 0.000
+ 3.00050e-07 1.800 3.01000e-07 1.800 3.01050e-07 0.000 3.02000e-07 0.000 3.02050e-07 1.800 3.03000e-07 1.800
+ 3.03050e-07 0.000 3.04000e-07 0.000 3.04050e-07 1.800 3.05000e-07 1.800 3.05050e-07 0.000 3.06000e-07 0.000
+ 3.06050e-07 1.800 3.07000e-07 1.800 3.07050e-07 0.000 3.08000e-07 0.000 3.08050e-07 1.800 3.09000e-07 1.800
+ 3.09050e-07 0.000 3.10000e-07 0.000 3.10050e-07 1.800 3.11000e-07 1.800 3.11050e-07 0.000 3.12000e-07 0.000
+ 3.12050e-07 1.800 3.13000e-07 1.800 3.13050e-07 0.000 3.14000e-07 0.000 3.14050e-07 1.800 3.15000e-07 1.800
+ 3.15050e-07 0.000 3.16000e-07 0.000 3.16050e-07 1.800 3.17000e-07 1.800 3.17050e-07 0.000 3.18000e-07 0.000
+ 3.18050e-07 1.800 3.19000e-07 1.800 3.19050e-07 0.000 3.20000e-07 0.000 3.20050e-07 1.800 3.21000e-07 1.800
+ 3.21050e-07 0.000 3.22000e-07 0.000 3.22050e-07 1.800 3.23000e-07 1.800 3.23050e-07 0.000 3.24000e-07 0.000
+ 3.24050e-07 1.800 3.25000e-07 1.800 3.25050e-07 0.000 3.26000e-07 0.000 3.26050e-07 1.800 3.27000e-07 1.800
+ 3.27050e-07 0.000 3.28000e-07 0.000 3.28050e-07 1.800 3.29000e-07 1.800 3.29050e-07 0.000 3.30000e-07 0.000
+ 3.30050e-07 1.800 3.31000e-07 1.800 3.31050e-07 0.000 3.32000e-07 0.000 3.32050e-07 1.800 3.33000e-07 1.800
+ 3.33050e-07 0.000 3.34000e-07 0.000 3.34050e-07 1.800 3.35000e-07 1.800 3.35050e-07 0.000 3.36000e-07 0.000
+ 3.36050e-07 1.800 3.37000e-07 1.800 3.37050e-07 0.000 3.38000e-07 0.000 3.38050e-07 1.800 3.39000e-07 1.800
+ 3.39050e-07 0.000 3.40000e-07 0.000 3.40050e-07 1.800 3.41000e-07 1.800 3.41050e-07 0.000 3.42000e-07 0.000
+ 3.42050e-07 1.800 3.43000e-07 1.800 3.43050e-07 0.000 3.44000e-07 0.000 3.44050e-07 1.800 3.45000e-07 1.800
+ 3.45050e-07 0.000 3.46000e-07 0.000 3.46050e-07 1.800 3.47000e-07 1.800 3.47050e-07 0.000 3.48000e-07 0.000
+ 3.48050e-07 1.800 3.49000e-07 1.800 3.49050e-07 0.000 3.50000e-07 0.000 3.50050e-07 1.800 3.51000e-07 1.800
+ 3.51050e-07 0.000 3.52000e-07 0.000 3.52050e-07 1.800 3.53000e-07 1.800 3.53050e-07 0.000 3.54000e-07 0.000
+ 3.54050e-07 1.800 3.55000e-07 1.800 3.55050e-07 0.000 3.56000e-07 0.000 3.56050e-07 1.800 3.57000e-07 1.800
+ 3.57050e-07 0.000 3.58000e-07 0.000 3.58050e-07 1.800 3.59000e-07 1.800 3.59050e-07 0.000 3.60000e-07 0.000
+ 3.60050e-07 1.800 3.61000e-07 1.800 3.61050e-07 0.000 3.62000e-07 0.000 3.62050e-07 1.800 3.63000e-07 1.800
+ 3.63050e-07 0.000 3.64000e-07 0.000 3.64050e-07 1.800 3.65000e-07 1.800 3.65050e-07 0.000 3.66000e-07 0.000
+ 3.66050e-07 1.800 3.67000e-07 1.800 3.67050e-07 0.000 3.68000e-07 0.000 3.68050e-07 1.800 3.69000e-07 1.800
+ 3.69050e-07 0.000 3.70000e-07 0.000 3.70050e-07 1.800 3.71000e-07 1.800 3.71050e-07 0.000 3.72000e-07 0.000
+ 3.72050e-07 1.800 3.73000e-07 1.800 3.73050e-07 0.000 3.74000e-07 0.000 3.74050e-07 1.800 3.75000e-07 1.800
+ 3.75050e-07 0.000 3.76000e-07 0.000 3.76050e-07 1.800 3.77000e-07 1.800 3.77050e-07 0.000 3.78000e-07 0.000
+ 3.78050e-07 1.800 3.79000e-07 1.800 3.79050e-07 0.000 3.80000e-07 0.000 3.80050e-07 1.800 3.81000e-07 1.800
+ 3.81050e-07 0.000 3.82000e-07 0.000 3.82050e-07 1.800 3.83000e-07 1.800 3.83050e-07 0.000 3.84000e-07 0.000
+ 3.84050e-07 1.800 3.85000e-07 1.800 3.85050e-07 0.000 3.86000e-07 0.000 3.86050e-07 1.800 3.87000e-07 1.800
+ 3.87050e-07 0.000 3.88000e-07 0.000 3.88050e-07 1.800 3.89000e-07 1.800 3.89050e-07 0.000 3.90000e-07 0.000
+ 3.90050e-07 1.800 3.91000e-07 1.800 3.91050e-07 0.000 3.92000e-07 0.000 3.92050e-07 1.800 3.93000e-07 1.800
+ 3.93050e-07 0.000 3.94000e-07 0.000 3.94050e-07 1.800 3.95000e-07 1.800 3.95050e-07 0.000 3.96000e-07 0.000
+ 3.96050e-07 1.800 3.97000e-07 1.800 3.97050e-07 0.000 3.98000e-07 0.000 3.98050e-07 1.800 3.99000e-07 1.800
+ 3.99050e-07 0.000 4.00000e-07 0.000 4.00050e-07 1.800 4.01000e-07 1.800 4.01050e-07 0.000 4.02000e-07 0.000
+ 4.02050e-07 1.800 4.03000e-07 1.800 4.03050e-07 0.000 4.04000e-07 0.000 4.04050e-07 1.800 4.05000e-07 1.800
+ 4.05050e-07 0.000 4.06000e-07 0.000 4.06050e-07 1.800 4.07000e-07 1.800 4.07050e-07 0.000 4.08000e-07 0.000
+ 4.08050e-07 1.800 4.09000e-07 1.800 4.09050e-07 0.000 4.10000e-07 0.000 4.10050e-07 1.800 4.11000e-07 1.800
+ 4.11050e-07 0.000 4.12000e-07 0.000 4.12050e-07 1.800 4.13000e-07 1.800 4.13050e-07 0.000 4.14000e-07 0.000
+ 4.14050e-07 1.800 4.15000e-07 1.800 4.15050e-07 0.000 4.16000e-07 0.000 4.16050e-07 1.800 4.17000e-07 1.800
+ 4.17050e-07 0.000 4.18000e-07 0.000 4.18050e-07 1.800 4.19000e-07 1.800 4.19050e-07 0.000 4.20000e-07 0.000
+ 4.20050e-07 1.800 4.21000e-07 1.800 4.21050e-07 0.000 4.22000e-07 0.000 4.22050e-07 1.800 4.23000e-07 1.800
+ 4.23050e-07 0.000 4.24000e-07 0.000 4.24050e-07 1.800 4.25000e-07 1.800 4.25050e-07 0.000 4.26000e-07 0.000
+ 4.26050e-07 1.800 4.27000e-07 1.800 4.27050e-07 0.000 4.28000e-07 0.000 4.28050e-07 1.800 4.29000e-07 1.800
+ 4.29050e-07 0.000 4.30000e-07 0.000 4.30050e-07 1.800 4.31000e-07 1.800 4.31050e-07 0.000 4.32000e-07 0.000
+ 4.32050e-07 1.800 4.33000e-07 1.800 4.33050e-07 0.000 4.34000e-07 0.000 4.34050e-07 1.800 4.35000e-07 1.800
+ 4.35050e-07 0.000 4.36000e-07 0.000 4.36050e-07 1.800 4.37000e-07 1.800 4.37050e-07 0.000 4.38000e-07 0.000
+ 4.38050e-07 1.800 4.39000e-07 1.800 4.39050e-07 0.000 4.40000e-07 0.000 4.40050e-07 1.800 4.41000e-07 1.800
+ 4.41050e-07 0.000 4.42000e-07 0.000 4.42050e-07 1.800 4.43000e-07 1.800 4.43050e-07 0.000 4.44000e-07 0.000
+ 4.44050e-07 1.800 4.45000e-07 1.800 4.45050e-07 0.000 4.46000e-07 0.000 4.46050e-07 1.800 4.47000e-07 1.800
+ 4.47050e-07 0.000 4.48000e-07 0.000 4.48050e-07 1.800 4.49000e-07 1.800 4.49050e-07 0.000 4.50000e-07 0.000
+ 4.50050e-07 1.800 4.51000e-07 1.800 4.51050e-07 0.000 4.52000e-07 0.000 4.52050e-07 1.800 4.53000e-07 1.800
+ 4.53050e-07 0.000 4.54000e-07 0.000 4.54050e-07 1.800 4.55000e-07 1.800 4.55050e-07 0.000 4.56000e-07 0.000
+ 4.56050e-07 1.800 4.57000e-07 1.800 4.57050e-07 0.000 4.58000e-07 0.000 4.58050e-07 1.800 4.59000e-07 1.800
+ 4.59050e-07 0.000 4.60000e-07 0.000 4.60050e-07 1.800 4.61000e-07 1.800 4.61050e-07 0.000 4.62000e-07 0.000
+ 4.62050e-07 1.800 4.63000e-07 1.800 4.63050e-07 0.000 4.64000e-07 0.000 4.64050e-07 1.800 4.65000e-07 1.800
+ 4.65050e-07 0.000 4.66000e-07 0.000 4.66050e-07 1.800 4.67000e-07 1.800 4.67050e-07 0.000 4.68000e-07 0.000
+ 4.68050e-07 1.800 4.69000e-07 1.800 4.69050e-07 0.000 4.70000e-07 0.000 4.70050e-07 1.800 4.71000e-07 1.800
+ 4.71050e-07 0.000 4.72000e-07 0.000 4.72050e-07 1.800 4.73000e-07 1.800 4.73050e-07 0.000 4.74000e-07 0.000
+ 4.74050e-07 1.800 4.75000e-07 1.800 4.75050e-07 0.000 4.76000e-07 0.000 4.76050e-07 1.800 4.77000e-07 1.800
+ 4.77050e-07 0.000 4.78000e-07 0.000 4.78050e-07 1.800 4.79000e-07 1.800 4.79050e-07 0.000 4.80000e-07 0.000
+ 4.80050e-07 1.800 4.81000e-07 1.800 4.81050e-07 0.000 4.82000e-07 0.000 4.82050e-07 1.800 4.83000e-07 1.800
+ 4.83050e-07 0.000 4.84000e-07 0.000 4.84050e-07 1.800 4.85000e-07 1.800 4.85050e-07 0.000 4.86000e-07 0.000
+ 4.86050e-07 1.800 4.87000e-07 1.800 4.87050e-07 0.000 4.88000e-07 0.000 4.88050e-07 1.800 4.89000e-07 1.800
+ 4.89050e-07 0.000 4.90000e-07 0.000 4.90050e-07 1.800 4.91000e-07 1.800 4.91050e-07 0.000 4.92000e-07 0.000
+ 4.92050e-07 1.800 4.93000e-07 1.800 4.93050e-07 0.000 4.94000e-07 0.000 4.94050e-07 1.800 4.95000e-07 1.800
+ 4.95050e-07 0.000 4.96000e-07 0.000 4.96050e-07 1.800 4.97000e-07 1.800 4.97050e-07 0.000 4.98000e-07 0.000
+ 4.98050e-07 1.800 4.99000e-07 1.800 4.99050e-07 0.000 5.00000e-07 0.000 5.00050e-07 1.800 5.01000e-07 1.800
+ 5.01050e-07 0.000 5.02000e-07 0.000 5.02050e-07 1.800 5.03000e-07 1.800 5.03050e-07 0.000 5.04000e-07 0.000
+ 5.04050e-07 1.800 5.05000e-07 1.800 5.05050e-07 0.000 5.06000e-07 0.000 5.06050e-07 1.800 5.07000e-07 1.800
+ 5.07050e-07 0.000 5.08000e-07 0.000 5.08050e-07 1.800 5.09000e-07 1.800 5.09050e-07 0.000 5.10000e-07 0.000
+ 5.10050e-07 1.800 5.11000e-07 1.800 5.11050e-07 0.000 5.12000e-07 0.000 5.12050e-07 1.800 5.13000e-07 1.800
+ 5.13050e-07 0.000 5.14000e-07 0.000 5.14050e-07 1.800 5.15000e-07 1.800 5.15050e-07 0.000 5.16000e-07 0.000
+ 5.16050e-07 1.800 5.17000e-07 1.800 5.17050e-07 0.000 5.18000e-07 0.000 5.18050e-07 1.800 5.19000e-07 1.800
+ 5.19050e-07 0.000 5.20000e-07 0.000 5.20050e-07 1.800 5.21000e-07 1.800 5.21050e-07 0.000 5.22000e-07 0.000
+ 5.22050e-07 1.800 5.23000e-07 1.800 5.23050e-07 0.000 5.24000e-07 0.000 5.24050e-07 1.800 5.25000e-07 1.800
+ 5.25050e-07 0.000 5.26000e-07 0.000 5.26050e-07 1.800 5.27000e-07 1.800 5.27050e-07 0.000 5.28000e-07 0.000
+ 5.28050e-07 1.800 5.29000e-07 1.800 5.29050e-07 0.000 5.30000e-07 0.000 5.30050e-07 1.800 5.31000e-07 1.800
+ 5.31050e-07 0.000 5.32000e-07 0.000 5.32050e-07 1.800 5.33000e-07 1.800 5.33050e-07 0.000 5.34000e-07 0.000
+ 5.34050e-07 1.800 5.35000e-07 1.800 5.35050e-07 0.000 5.36000e-07 0.000 5.36050e-07 1.800 5.37000e-07 1.800
+ 5.37050e-07 0.000 5.38000e-07 0.000 5.38050e-07 1.800 5.39000e-07 1.800 5.39050e-07 0.000 5.40000e-07 0.000
+ 5.40050e-07 1.800 5.41000e-07 1.800 5.41050e-07 0.000 5.42000e-07 0.000 5.42050e-07 1.800 5.43000e-07 1.800
+ 5.43050e-07 0.000 5.44000e-07 0.000 5.44050e-07 1.800 5.45000e-07 1.800 5.45050e-07 0.000 5.46000e-07 0.000
+ 5.46050e-07 1.800 5.47000e-07 1.800 5.47050e-07 0.000 5.48000e-07 0.000 5.48050e-07 1.800 5.49000e-07 1.800
+ 5.49050e-07 0.000 5.50000e-07 0.000 5.50050e-07 1.800 5.51000e-07 1.800 5.51050e-07 0.000 5.52000e-07 0.000
+ 5.52050e-07 1.800 5.53000e-07 1.800 5.53050e-07 0.000 5.54000e-07 0.000 5.54050e-07 1.800 5.55000e-07 1.800
+ 5.55050e-07 0.000 5.56000e-07 0.000 5.56050e-07 1.800 5.57000e-07 1.800 5.57050e-07 0.000 5.58000e-07 0.000
+ 5.58050e-07 1.800 5.59000e-07 1.800 5.59050e-07 0.000 5.60000e-07 0.000 5.60050e-07 1.800 5.61000e-07 1.800
+ 5.61050e-07 0.000 5.62000e-07 0.000 5.62050e-07 1.800 5.63000e-07 1.800 5.63050e-07 0.000 5.64000e-07 0.000
+ 5.64050e-07 1.800 5.65000e-07 1.800 5.65050e-07 0.000 5.66000e-07 0.000 5.66050e-07 1.800 5.67000e-07 1.800
+ 5.67050e-07 0.000 5.68000e-07 0.000 5.68050e-07 1.800 5.69000e-07 1.800 5.69050e-07 0.000 5.70000e-07 0.000
+ 5.70050e-07 1.800 5.71000e-07 1.800 5.71050e-07 0.000 5.72000e-07 0.000 5.72050e-07 1.800 5.73000e-07 1.800
+ 5.73050e-07 0.000 5.74000e-07 0.000 5.74050e-07 1.800 5.75000e-07 1.800 5.75050e-07 0.000 5.76000e-07 0.000
+ 5.76050e-07 1.800 5.77000e-07 1.800 5.77050e-07 0.000 5.78000e-07 0.000 5.78050e-07 1.800 5.79000e-07 1.800
+ 5.79050e-07 0.000 5.80000e-07 0.000 5.80050e-07 1.800 5.81000e-07 1.800 5.81050e-07 0.000 5.82000e-07 0.000
+ 5.82050e-07 1.800 5.83000e-07 1.800 5.83050e-07 0.000 5.84000e-07 0.000 5.84050e-07 1.800 5.85000e-07 1.800
+ 5.85050e-07 0.000 5.86000e-07 0.000 5.86050e-07 1.800 5.87000e-07 1.800 5.87050e-07 0.000 5.88000e-07 0.000
+ 5.88050e-07 1.800 5.89000e-07 1.800 5.89050e-07 0.000 5.90000e-07 0.000 5.90050e-07 1.800 5.91000e-07 1.800
+ 5.91050e-07 0.000 5.92000e-07 0.000 5.92050e-07 1.800 5.93000e-07 1.800 5.93050e-07 0.000 5.94000e-07 0.000
+ 5.94050e-07 1.800 5.95000e-07 1.800 5.95050e-07 0.000 5.96000e-07 0.000 5.96050e-07 1.800 5.97000e-07 1.800
+ 5.97050e-07 0.000 5.98000e-07 0.000 5.98050e-07 1.800 5.99000e-07 1.800 5.99050e-07 0.000 6.00000e-07 0.000
+ 6.00050e-07 1.800 6.01000e-07 1.800 6.01050e-07 0.000 6.02000e-07 0.000 6.02050e-07 1.800 6.03000e-07 1.800
+ 6.03050e-07 0.000 6.04000e-07 0.000 6.04050e-07 1.800 6.05000e-07 1.800 6.05050e-07 0.000 6.06000e-07 0.000
+ 6.06050e-07 1.800 6.07000e-07 1.800 6.07050e-07 0.000 6.08000e-07 0.000 6.08050e-07 1.800 6.09000e-07 1.800
+ 6.09050e-07 0.000 6.10000e-07 0.000 6.10050e-07 1.800 6.11000e-07 1.800 6.11050e-07 0.000 6.12000e-07 0.000
+ 6.12050e-07 1.800 6.13000e-07 1.800 6.13050e-07 0.000 6.14000e-07 0.000 6.14050e-07 1.800 6.15000e-07 1.800
+ 6.15050e-07 0.000 6.16000e-07 0.000 6.16050e-07 1.800 6.17000e-07 1.800 6.17050e-07 0.000 6.18000e-07 0.000
+ 6.18050e-07 1.800 6.19000e-07 1.800 6.19050e-07 0.000 6.20000e-07 0.000 6.20050e-07 1.800 6.21000e-07 1.800
+ 6.21050e-07 0.000 6.22000e-07 0.000 6.22050e-07 1.800 6.23000e-07 1.800 6.23050e-07 0.000 6.24000e-07 0.000
+ 6.24050e-07 1.800 6.25000e-07 1.800 6.25050e-07 0.000 6.26000e-07 0.000 6.26050e-07 1.800 6.27000e-07 1.800
+ 6.27050e-07 0.000 6.28000e-07 0.000 6.28050e-07 1.800 6.29000e-07 1.800 6.29050e-07 0.000 6.30000e-07 0.000
+ 6.30050e-07 1.800 6.31000e-07 1.800 6.31050e-07 0.000 6.32000e-07 0.000 6.32050e-07 1.800 6.33000e-07 1.800
+ 6.33050e-07 0.000 6.34000e-07 0.000 6.34050e-07 1.800 6.35000e-07 1.800 6.35050e-07 0.000 6.36000e-07 0.000
+ 6.36050e-07 1.800 6.37000e-07 1.800 6.37050e-07 0.000 6.38000e-07 0.000 6.38050e-07 1.800 6.39000e-07 1.800
+ 6.39050e-07 0.000 6.40000e-07 0.000 6.40050e-07 1.800 6.41000e-07 1.800 6.41050e-07 0.000 6.42000e-07 0.000
+ 6.42050e-07 1.800 6.43000e-07 1.800 6.43050e-07 0.000 6.44000e-07 0.000 6.44050e-07 1.800 6.45000e-07 1.800
+ 6.45050e-07 0.000 6.46000e-07 0.000 6.46050e-07 1.800 6.47000e-07 1.800 6.47050e-07 0.000 6.48000e-07 0.000
+ 6.48050e-07 1.800 6.49000e-07 1.800 6.49050e-07 0.000 6.50000e-07 0.000 6.50050e-07 1.800 6.51000e-07 1.800
+ 6.51050e-07 0.000 6.52000e-07 0.000 6.52050e-07 1.800 6.53000e-07 1.800 6.53050e-07 0.000 6.54000e-07 0.000
+ 6.54050e-07 1.800 6.55000e-07 1.800 6.55050e-07 0.000 6.56000e-07 0.000 6.56050e-07 1.800 6.57000e-07 1.800
+ 6.57050e-07 0.000 6.58000e-07 0.000 6.58050e-07 1.800 6.59000e-07 1.800 6.59050e-07 0.000 6.60000e-07 0.000
+ 6.60050e-07 1.800 6.61000e-07 1.800 6.61050e-07 0.000 6.62000e-07 0.000 6.62050e-07 1.800 6.63000e-07 1.800
+ 6.63050e-07 0.000 6.64000e-07 0.000 6.64050e-07 1.800 6.65000e-07 1.800 6.65050e-07 0.000 6.66000e-07 0.000
+ 6.66050e-07 1.800 6.67000e-07 1.800 6.67050e-07 0.000 6.68000e-07 0.000 6.68050e-07 1.800 6.69000e-07 1.800
+ 6.69050e-07 0.000 6.70000e-07 0.000 6.70050e-07 1.800 6.71000e-07 1.800 6.71050e-07 0.000 6.72000e-07 0.000
+ 6.72050e-07 1.800 6.73000e-07 1.800 6.73050e-07 0.000 6.74000e-07 0.000 6.74050e-07 1.800 6.75000e-07 1.800
+ 6.75050e-07 0.000 6.76000e-07 0.000 6.76050e-07 1.800 6.77000e-07 1.800 6.77050e-07 0.000 6.78000e-07 0.000
+ 6.78050e-07 1.800 6.79000e-07 1.800 6.79050e-07 0.000 6.80000e-07 0.000 6.80050e-07 1.800 6.81000e-07 1.800
+ 6.81050e-07 0.000 6.82000e-07 0.000 6.82050e-07 1.800 6.83000e-07 1.800 6.83050e-07 0.000 6.84000e-07 0.000
+ 6.84050e-07 1.800 6.85000e-07 1.800 6.85050e-07 0.000 6.86000e-07 0.000 6.86050e-07 1.800 6.87000e-07 1.800
+ 6.87050e-07 0.000 6.88000e-07 0.000 6.88050e-07 1.800 6.89000e-07 1.800 6.89050e-07 0.000 6.90000e-07 0.000
+ 6.90050e-07 1.800 6.91000e-07 1.800 6.91050e-07 0.000 6.92000e-07 0.000 6.92050e-07 1.800 6.93000e-07 1.800
+ 6.93050e-07 0.000 6.94000e-07 0.000 6.94050e-07 1.800 6.95000e-07 1.800 6.95050e-07 0.000 6.96000e-07 0.000
+ 6.96050e-07 1.800 6.97000e-07 1.800 6.97050e-07 0.000 6.98000e-07 0.000 6.98050e-07 1.800 6.99000e-07 1.800
+ 6.99050e-07 0.000 7.00000e-07 0.000 7.00050e-07 1.800 7.01000e-07 1.800 7.01050e-07 0.000 7.02000e-07 0.000
+ 7.02050e-07 1.800 7.03000e-07 1.800 7.03050e-07 0.000 7.04000e-07 0.000 7.04050e-07 1.800 7.05000e-07 1.800
+ 7.05050e-07 0.000 7.06000e-07 0.000 7.06050e-07 1.800 7.07000e-07 1.800 7.07050e-07 0.000 7.08000e-07 0.000
+ 7.08050e-07 1.800 7.09000e-07 1.800 7.09050e-07 0.000 7.10000e-07 0.000 7.10050e-07 1.800 7.11000e-07 1.800
+ 7.11050e-07 0.000 7.12000e-07 0.000 7.12050e-07 1.800 7.13000e-07 1.800 7.13050e-07 0.000 7.14000e-07 0.000
+ 7.14050e-07 1.800 7.15000e-07 1.800 7.15050e-07 0.000 7.16000e-07 0.000 7.16050e-07 1.800 7.17000e-07 1.800
+ 7.17050e-07 0.000 7.18000e-07 0.000 7.18050e-07 1.800 7.19000e-07 1.800 7.19050e-07 0.000 7.20000e-07 0.000
+ 7.20050e-07 1.800 7.21000e-07 1.800 7.21050e-07 0.000 7.22000e-07 0.000 7.22050e-07 1.800 7.23000e-07 1.800
+ 7.23050e-07 0.000 7.24000e-07 0.000 7.24050e-07 1.800 7.25000e-07 1.800 7.25050e-07 0.000 7.26000e-07 0.000
+ 7.26050e-07 1.800 7.27000e-07 1.800 7.27050e-07 0.000 7.28000e-07 0.000 7.28050e-07 1.800 7.29000e-07 1.800
+ 7.29050e-07 0.000 7.30000e-07 0.000 7.30050e-07 1.800 7.31000e-07 1.800 7.31050e-07 0.000 7.32000e-07 0.000
+ 7.32050e-07 1.800 7.33000e-07 1.800 7.33050e-07 0.000 7.34000e-07 0.000 7.34050e-07 1.800 7.35000e-07 1.800
+ 7.35050e-07 0.000 7.36000e-07 0.000 7.36050e-07 1.800 7.37000e-07 1.800 7.37050e-07 0.000 7.38000e-07 0.000
+ 7.38050e-07 1.800 7.39000e-07 1.800 7.39050e-07 0.000 7.40000e-07 0.000 7.40050e-07 1.800 7.41000e-07 1.800
+ 7.41050e-07 0.000 7.42000e-07 0.000 7.42050e-07 1.800 7.43000e-07 1.800 7.43050e-07 0.000 7.44000e-07 0.000
+ 7.44050e-07 1.800 7.45000e-07 1.800 7.45050e-07 0.000 7.46000e-07 0.000 7.46050e-07 1.800 7.47000e-07 1.800
+ 7.47050e-07 0.000 7.48000e-07 0.000 7.48050e-07 1.800 7.49000e-07 1.800 7.49050e-07 0.000 7.50000e-07 0.000
+ 7.50050e-07 1.800 7.51000e-07 1.800 7.51050e-07 0.000 7.52000e-07 0.000 7.52050e-07 1.800 7.53000e-07 1.800
+ 7.53050e-07 0.000 7.54000e-07 0.000 7.54050e-07 1.800 7.55000e-07 1.800 7.55050e-07 0.000 7.56000e-07 0.000
+ 7.56050e-07 1.800 7.57000e-07 1.800 7.57050e-07 0.000 7.58000e-07 0.000 7.58050e-07 1.800 7.59000e-07 1.800
+ 7.59050e-07 0.000 7.60000e-07 0.000 7.60050e-07 1.800 7.61000e-07 1.800 7.61050e-07 0.000 7.62000e-07 0.000
+ 7.62050e-07 1.800 7.63000e-07 1.800 7.63050e-07 0.000 7.64000e-07 0.000 7.64050e-07 1.800 7.65000e-07 1.800
+ 7.65050e-07 0.000 7.66000e-07 0.000 7.66050e-07 1.800 7.67000e-07 1.800 7.67050e-07 0.000 7.68000e-07 0.000
+ 7.68050e-07 1.800 7.69000e-07 1.800 7.69050e-07 0.000 7.70000e-07 0.000 7.70050e-07 1.800 7.71000e-07 1.800
+ 7.71050e-07 0.000 7.72000e-07 0.000 7.72050e-07 1.800 7.73000e-07 1.800 7.73050e-07 0.000 7.74000e-07 0.000
+ 7.74050e-07 1.800 7.75000e-07 1.800 7.75050e-07 0.000 7.76000e-07 0.000 7.76050e-07 1.800 7.77000e-07 1.800
+ 7.77050e-07 0.000 7.78000e-07 0.000 7.78050e-07 1.800 7.79000e-07 1.800 7.79050e-07 0.000 7.80000e-07 0.000
+ 7.80050e-07 1.800 7.81000e-07 1.800 7.81050e-07 0.000 7.82000e-07 0.000 7.82050e-07 1.800 7.83000e-07 1.800
+ 7.83050e-07 0.000 7.84000e-07 0.000 7.84050e-07 1.800 7.85000e-07 1.800 7.85050e-07 0.000 7.86000e-07 0.000
+ 7.86050e-07 1.800 7.87000e-07 1.800 7.87050e-07 0.000 7.88000e-07 0.000 7.88050e-07 1.800 7.89000e-07 1.800
+ 7.89050e-07 0.000 7.90000e-07 0.000 7.90050e-07 1.800 7.91000e-07 1.800 7.91050e-07 0.000 7.92000e-07 0.000
+ 7.92050e-07 1.800 7.93000e-07 1.800 7.93050e-07 0.000 7.94000e-07 0.000 7.94050e-07 1.800 7.95000e-07 1.800
+ 7.95050e-07 0.000 7.96000e-07 0.000 7.96050e-07 1.800 7.97000e-07 1.800 7.97050e-07 0.000 7.98000e-07 0.000
+ 7.98050e-07 1.800 7.99000e-07 1.800 7.99050e-07 0.000 8.00000e-07 0.000 8.00050e-07 1.800 8.01000e-07 1.800
+ 8.01050e-07 0.000 8.02000e-07 0.000 8.02050e-07 1.800 8.03000e-07 1.800 8.03050e-07 0.000 8.04000e-07 0.000
+ 8.04050e-07 1.800 8.05000e-07 1.800 8.05050e-07 0.000 8.06000e-07 0.000 8.06050e-07 1.800 8.07000e-07 1.800
+ 8.07050e-07 0.000 8.08000e-07 0.000 8.08050e-07 1.800 8.09000e-07 1.800 8.09050e-07 0.000 8.10000e-07 0.000
+ 8.10050e-07 1.800 8.11000e-07 1.800 8.11050e-07 0.000 8.12000e-07 0.000 8.12050e-07 1.800 8.13000e-07 1.800
+ 8.13050e-07 0.000 8.14000e-07 0.000 8.14050e-07 1.800 8.15000e-07 1.800 8.15050e-07 0.000 8.16000e-07 0.000
+ 8.16050e-07 1.800 8.17000e-07 1.800 8.17050e-07 0.000 8.18000e-07 0.000 8.18050e-07 1.800 8.19000e-07 1.800
+ 8.19050e-07 0.000 8.20000e-07 0.000 8.20050e-07 1.800 8.21000e-07 1.800 8.21050e-07 0.000 8.22000e-07 0.000
+ 8.22050e-07 1.800 8.23000e-07 1.800 8.23050e-07 0.000 8.24000e-07 0.000 8.24050e-07 1.800 8.25000e-07 1.800
+ 8.25050e-07 0.000 8.26000e-07 0.000 8.26050e-07 1.800 8.27000e-07 1.800 8.27050e-07 0.000 8.28000e-07 0.000
+ 8.28050e-07 1.800 8.29000e-07 1.800 8.29050e-07 0.000 8.30000e-07 0.000 8.30050e-07 1.800 8.31000e-07 1.800
+ 8.31050e-07 0.000 8.32000e-07 0.000 8.32050e-07 1.800 8.33000e-07 1.800 8.33050e-07 0.000 8.34000e-07 0.000
+ 8.34050e-07 1.800 8.35000e-07 1.800 8.35050e-07 0.000 8.36000e-07 0.000 8.36050e-07 1.800 8.37000e-07 1.800
+ 8.37050e-07 0.000 8.38000e-07 0.000 8.38050e-07 1.800 8.39000e-07 1.800 8.39050e-07 0.000 8.40000e-07 0.000
+ 8.40050e-07 1.800 8.41000e-07 1.800 8.41050e-07 0.000 8.42000e-07 0.000 8.42050e-07 1.800 8.43000e-07 1.800
+ 8.43050e-07 0.000 8.44000e-07 0.000 8.44050e-07 1.800 8.45000e-07 1.800 8.45050e-07 0.000 8.46000e-07 0.000
+ 8.46050e-07 1.800 8.47000e-07 1.800 8.47050e-07 0.000 8.48000e-07 0.000 8.48050e-07 1.800 8.49000e-07 1.800
+ 8.49050e-07 0.000 8.50000e-07 0.000 8.50050e-07 1.800 8.51000e-07 1.800 8.51050e-07 0.000 8.52000e-07 0.000
+ 8.52050e-07 1.800 8.53000e-07 1.800 8.53050e-07 0.000 8.54000e-07 0.000 8.54050e-07 1.800 8.55000e-07 1.800
+ 8.55050e-07 0.000 8.56000e-07 0.000 8.56050e-07 1.800 8.57000e-07 1.800 8.57050e-07 0.000 8.58000e-07 0.000
+ 8.58050e-07 1.800 8.59000e-07 1.800 8.59050e-07 0.000 8.60000e-07 0.000 8.60050e-07 1.800 8.61000e-07 1.800
+ 8.61050e-07 0.000 8.62000e-07 0.000 8.62050e-07 1.800 8.63000e-07 1.800 8.63050e-07 0.000 8.64000e-07 0.000
+ 8.64050e-07 1.800 8.65000e-07 1.800 8.65050e-07 0.000 8.66000e-07 0.000 8.66050e-07 1.800 8.67000e-07 1.800
+ 8.67050e-07 0.000 8.68000e-07 0.000 8.68050e-07 1.800 8.69000e-07 1.800 8.69050e-07 0.000 8.70000e-07 0.000
+ 8.70050e-07 1.800 8.71000e-07 1.800 8.71050e-07 0.000 8.72000e-07 0.000 8.72050e-07 1.800 8.73000e-07 1.800
+ 8.73050e-07 0.000 8.74000e-07 0.000 8.74050e-07 1.800 8.75000e-07 1.800 8.75050e-07 0.000 8.76000e-07 0.000
+ 8.76050e-07 1.800 8.77000e-07 1.800 8.77050e-07 0.000 8.78000e-07 0.000 8.78050e-07 1.800 8.79000e-07 1.800
+ 8.79050e-07 0.000 8.80000e-07 0.000 8.80050e-07 1.800 8.81000e-07 1.800 8.81050e-07 0.000 8.82000e-07 0.000
+ 8.82050e-07 1.800 8.83000e-07 1.800 8.83050e-07 0.000 8.84000e-07 0.000 8.84050e-07 1.800 8.85000e-07 1.800
+ 8.85050e-07 0.000 8.86000e-07 0.000 8.86050e-07 1.800 8.87000e-07 1.800 8.87050e-07 0.000 8.88000e-07 0.000
+ 8.88050e-07 1.800 8.89000e-07 1.800 8.89050e-07 0.000 8.90000e-07 0.000 8.90050e-07 1.800 8.91000e-07 1.800
+ 8.91050e-07 0.000 8.92000e-07 0.000 8.92050e-07 1.800 8.93000e-07 1.800 8.93050e-07 0.000 8.94000e-07 0.000
+ 8.94050e-07 1.800 8.95000e-07 1.800 8.95050e-07 0.000 8.96000e-07 0.000 8.96050e-07 1.800 8.97000e-07 1.800
+ 8.97050e-07 0.000 8.98000e-07 0.000 8.98050e-07 1.800 8.99000e-07 1.800 8.99050e-07 0.000 9.00000e-07 0.000
+ 9.00050e-07 1.800 9.01000e-07 1.800 9.01050e-07 0.000 9.02000e-07 0.000 9.02050e-07 1.800 9.03000e-07 1.800
+ 9.03050e-07 0.000 9.04000e-07 0.000 9.04050e-07 1.800 9.05000e-07 1.800 9.05050e-07 0.000 9.06000e-07 0.000
+ 9.06050e-07 1.800 9.07000e-07 1.800 9.07050e-07 0.000 9.08000e-07 0.000 9.08050e-07 1.800 9.09000e-07 1.800
+ 9.09050e-07 0.000 9.10000e-07 0.000 9.10050e-07 1.800 9.11000e-07 1.800 9.11050e-07 0.000 9.12000e-07 0.000
+ 9.12050e-07 1.800 9.13000e-07 1.800 9.13050e-07 0.000 9.14000e-07 0.000 9.14050e-07 1.800 9.15000e-07 1.800
+ 9.15050e-07 0.000 9.16000e-07 0.000 9.16050e-07 1.800 9.17000e-07 1.800 9.17050e-07 0.000 9.18000e-07 0.000
+ 9.18050e-07 1.800 9.19000e-07 1.800 9.19050e-07 0.000 9.20000e-07 0.000 9.20050e-07 1.800 9.21000e-07 1.800
+ 9.21050e-07 0.000 9.22000e-07 0.000 9.22050e-07 1.800 9.23000e-07 1.800 9.23050e-07 0.000 9.24000e-07 0.000
+ 9.24050e-07 1.800 9.25000e-07 1.800 9.25050e-07 0.000 9.26000e-07 0.000 9.26050e-07 1.800 9.27000e-07 1.800
+ 9.27050e-07 0.000 9.28000e-07 0.000 9.28050e-07 1.800 9.29000e-07 1.800 9.29050e-07 0.000 9.30000e-07 0.000
+ 9.30050e-07 1.800 9.31000e-07 1.800 9.31050e-07 0.000 9.32000e-07 0.000 9.32050e-07 1.800 9.33000e-07 1.800
+ 9.33050e-07 0.000 9.34000e-07 0.000 9.34050e-07 1.800 9.35000e-07 1.800 9.35050e-07 0.000 9.36000e-07 0.000
+ 9.36050e-07 1.800 9.37000e-07 1.800 9.37050e-07 0.000 9.38000e-07 0.000 9.38050e-07 1.800 9.39000e-07 1.800
+ 9.39050e-07 0.000 9.40000e-07 0.000 9.40050e-07 1.800 9.41000e-07 1.800 9.41050e-07 0.000 9.42000e-07 0.000
+ 9.42050e-07 1.800 9.43000e-07 1.800 9.43050e-07 0.000 9.44000e-07 0.000 9.44050e-07 1.800 9.45000e-07 1.800
+ 9.45050e-07 0.000 9.46000e-07 0.000 9.46050e-07 1.800 9.47000e-07 1.800 9.47050e-07 0.000 9.48000e-07 0.000
+ 9.48050e-07 1.800 9.49000e-07 1.800 9.49050e-07 0.000 9.50000e-07 0.000 9.50050e-07 1.800 9.51000e-07 1.800
+ 9.51050e-07 0.000 9.52000e-07 0.000 9.52050e-07 1.800 9.53000e-07 1.800 9.53050e-07 0.000 9.54000e-07 0.000
+ 9.54050e-07 1.800 9.55000e-07 1.800 9.55050e-07 0.000 9.56000e-07 0.000 9.56050e-07 1.800 9.57000e-07 1.800
+ 9.57050e-07 0.000 9.58000e-07 0.000 9.58050e-07 1.800 9.59000e-07 1.800 9.59050e-07 0.000 9.60000e-07 0.000
+ 9.60050e-07 1.800 9.61000e-07 1.800 9.61050e-07 0.000 9.62000e-07 0.000 9.62050e-07 1.800 9.63000e-07 1.800
+ 9.63050e-07 0.000 9.64000e-07 0.000 9.64050e-07 1.800 9.65000e-07 1.800 9.65050e-07 0.000 9.66000e-07 0.000
+ 9.66050e-07 1.800 9.67000e-07 1.800 9.67050e-07 0.000 9.68000e-07 0.000 9.68050e-07 1.800 9.69000e-07 1.800
+ 9.69050e-07 0.000 9.70000e-07 0.000 9.70050e-07 1.800 9.71000e-07 1.800 9.71050e-07 0.000 9.72000e-07 0.000
+ 9.72050e-07 1.800 9.73000e-07 1.800 9.73050e-07 0.000 9.74000e-07 0.000 9.74050e-07 1.800 9.75000e-07 1.800
+ 9.75050e-07 0.000 9.76000e-07 0.000 9.76050e-07 1.800 9.77000e-07 1.800 9.77050e-07 0.000 9.78000e-07 0.000
+ 9.78050e-07 1.800 9.79000e-07 1.800 9.79050e-07 0.000 9.80000e-07 0.000 9.80050e-07 1.800 9.81000e-07 1.800
+ 9.81050e-07 0.000 9.82000e-07 0.000 9.82050e-07 1.800 9.83000e-07 1.800 9.83050e-07 0.000 9.84000e-07 0.000
+ 9.84050e-07 1.800 9.85000e-07 1.800 9.85050e-07 0.000 9.86000e-07 0.000 9.86050e-07 1.800 9.87000e-07 1.800
+ 9.87050e-07 0.000 9.88000e-07 0.000 9.88050e-07 1.800 9.89000e-07 1.800 9.89050e-07 0.000 9.90000e-07 0.000
+ 9.90050e-07 1.800 9.91000e-07 1.800 9.91050e-07 0.000 9.92000e-07 0.000 9.92050e-07 1.800 9.93000e-07 1.800
+ 9.93050e-07 0.000 9.94000e-07 0.000 9.94050e-07 1.800 9.95000e-07 1.800 9.95050e-07 0.000 9.96000e-07 0.000
+ 9.96050e-07 1.800 9.97000e-07 1.800 9.97050e-07 0.000 9.98000e-07 0.000 9.98050e-07 1.800 9.99000e-07 1.800
+ 9.99050e-07 0.000 1.00000e-06 0.000 1.00005e-06 1.800 1.00100e-06 1.800 1.00105e-06 0.000 1.00200e-06 0.000
+ 1.00205e-06 1.800 1.00300e-06 1.800 1.00305e-06 0.000 1.00400e-06 0.000 1.00405e-06 1.800 1.00500e-06 1.800
+ 1.00505e-06 0.000 1.00600e-06 0.000 1.00605e-06 1.800 1.00700e-06 1.800 1.00705e-06 0.000 1.00800e-06 0.000
+ 1.00805e-06 1.800 1.00900e-06 1.800 1.00905e-06 0.000 1.01000e-06 0.000 1.01005e-06 1.800 1.01100e-06 1.800
+ 1.01105e-06 0.000 1.01200e-06 0.000 1.01205e-06 1.800 1.01300e-06 1.800 1.01305e-06 0.000 1.01400e-06 0.000
+ 1.01405e-06 1.800 1.01500e-06 1.800 1.01505e-06 0.000 1.01600e-06 0.000 1.01605e-06 1.800 1.01700e-06 1.800
+ 1.01705e-06 0.000 1.01800e-06 0.000 1.01805e-06 1.800 1.01900e-06 1.800 1.01905e-06 0.000 1.02000e-06 0.000
+ 1.02005e-06 1.800 1.02100e-06 1.800 1.02105e-06 0.000 1.02200e-06 0.000 1.02205e-06 1.800 1.02300e-06 1.800
+ 1.02305e-06 0.000 1.02400e-06 0.000 1.02405e-06 1.800 1.02500e-06 1.800 1.02505e-06 0.000 1.02600e-06 0.000
+ 1.02605e-06 1.800 1.02700e-06 1.800 1.02705e-06 0.000 1.02800e-06 0.000 1.02805e-06 1.800 1.02900e-06 1.800
+ 1.02905e-06 0.000 1.03000e-06 0.000 1.03005e-06 1.800 1.03100e-06 1.800 1.03105e-06 0.000 1.03200e-06 0.000
+ 1.03205e-06 1.800 1.03300e-06 1.800 1.03305e-06 0.000 1.03400e-06 0.000 1.03405e-06 1.800 1.03500e-06 1.800
+ 1.03505e-06 0.000 1.03600e-06 0.000 1.03605e-06 1.800 1.03700e-06 1.800 1.03705e-06 0.000 1.03800e-06 0.000
+ 1.03805e-06 1.800 1.03900e-06 1.800 1.03905e-06 0.000 1.04000e-06 0.000 1.04005e-06 1.800 1.04100e-06 1.800
+ 1.04105e-06 0.000 1.04200e-06 0.000 1.04205e-06 1.800 1.04300e-06 1.800 1.04305e-06 0.000 1.04400e-06 0.000
+ 1.04405e-06 1.800 1.04500e-06 1.800 1.04505e-06 0.000 1.04600e-06 0.000 1.04605e-06 1.800 1.04700e-06 1.800
+ 1.04705e-06 0.000 1.04800e-06 0.000 1.04805e-06 1.800 1.04900e-06 1.800 1.04905e-06 0.000 1.05000e-06 0.000
+ 1.05005e-06 1.800 1.05100e-06 1.800 1.05105e-06 0.000 1.05200e-06 0.000 1.05205e-06 1.800 1.05300e-06 1.800
+ 1.05305e-06 0.000 1.05400e-06 0.000 1.05405e-06 1.800 1.05500e-06 1.800 1.05505e-06 0.000 1.05600e-06 0.000
+ 1.05605e-06 1.800 1.05700e-06 1.800 1.05705e-06 0.000 1.05800e-06 0.000 1.05805e-06 1.800 1.05900e-06 1.800
+ 1.05905e-06 0.000 1.06000e-06 0.000 1.06005e-06 1.800 1.06100e-06 1.800 1.06105e-06 0.000 1.06200e-06 0.000
+ 1.06205e-06 1.800 1.06300e-06 1.800 1.06305e-06 0.000 1.06400e-06 0.000 1.06405e-06 1.800 1.06500e-06 1.800
+ 1.06505e-06 0.000 1.06600e-06 0.000 1.06605e-06 1.800 1.06700e-06 1.800 1.06705e-06 0.000 1.06800e-06 0.000
+ 1.06805e-06 1.800 1.06900e-06 1.800 1.06905e-06 0.000 1.07000e-06 0.000 1.07005e-06 1.800 1.07100e-06 1.800
+ 1.07105e-06 0.000 1.07200e-06 0.000 1.07205e-06 1.800 1.07300e-06 1.800 1.07305e-06 0.000 1.07400e-06 0.000
+ 1.07405e-06 1.800 1.07500e-06 1.800 1.07505e-06 0.000 1.07600e-06 0.000 1.07605e-06 1.800 1.07700e-06 1.800
+ 1.07705e-06 0.000 1.07800e-06 0.000 1.07805e-06 1.800 1.07900e-06 1.800 1.07905e-06 0.000 1.08000e-06 0.000
+ 1.08005e-06 1.800 1.08100e-06 1.800 1.08105e-06 0.000 1.08200e-06 0.000 1.08205e-06 1.800 1.08300e-06 1.800
+ 1.08305e-06 0.000 1.08400e-06 0.000 1.08405e-06 1.800 1.08500e-06 1.800 1.08505e-06 0.000 1.08600e-06 0.000
+ 1.08605e-06 1.800 1.08700e-06 1.800 1.08705e-06 0.000 1.08800e-06 0.000 1.08805e-06 1.800 1.08900e-06 1.800
+ 1.08905e-06 0.000 1.09000e-06 0.000 1.09005e-06 1.800 1.09100e-06 1.800 1.09105e-06 0.000 1.09200e-06 0.000
+ 1.09205e-06 1.800 1.09300e-06 1.800 1.09305e-06 0.000 1.09400e-06 0.000 1.09405e-06 1.800 1.09500e-06 1.800
+ 1.09505e-06 0.000 1.09600e-06 0.000 1.09605e-06 1.800 1.09700e-06 1.800 1.09705e-06 0.000 1.09800e-06 0.000
+ 1.09805e-06 1.800 1.09900e-06 1.800 1.09905e-06 0.000 1.10000e-06 0.000 1.10005e-06 1.800 1.10100e-06 1.800
+ 1.10105e-06 0.000 1.10200e-06 0.000 1.10205e-06 1.800 1.10300e-06 1.800 1.10305e-06 0.000 1.10400e-06 0.000
+ 1.10405e-06 1.800 1.10500e-06 1.800 1.10505e-06 0.000 1.10600e-06 0.000 1.10605e-06 1.800 1.10700e-06 1.800
+ 1.10705e-06 0.000 1.10800e-06 0.000 1.10805e-06 1.800 1.10900e-06 1.800 1.10905e-06 0.000 1.11000e-06 0.000
+ 1.11005e-06 1.800 1.11100e-06 1.800 1.11105e-06 0.000 1.11200e-06 0.000 1.11205e-06 1.800 1.11300e-06 1.800
+ 1.11305e-06 0.000 1.11400e-06 0.000 1.11405e-06 1.800 1.11500e-06 1.800 1.11505e-06 0.000 1.11600e-06 0.000
+ 1.11605e-06 1.800 1.11700e-06 1.800 1.11705e-06 0.000 1.11800e-06 0.000 1.11805e-06 1.800 1.11900e-06 1.800
+ 1.11905e-06 0.000 1.12000e-06 0.000 1.12005e-06 1.800 1.12100e-06 1.800 1.12105e-06 0.000 1.12200e-06 0.000
+ 1.12205e-06 1.800 1.12300e-06 1.800 1.12305e-06 0.000 1.12400e-06 0.000 1.12405e-06 1.800 1.12500e-06 1.800
+ 1.12505e-06 0.000 1.12600e-06 0.000 1.12605e-06 1.800 1.12700e-06 1.800 1.12705e-06 0.000 1.12800e-06 0.000
+ 1.12805e-06 1.800 1.12900e-06 1.800 1.12905e-06 0.000 1.13000e-06 0.000 1.13005e-06 1.800 1.13100e-06 1.800
+ 1.13105e-06 0.000 1.13200e-06 0.000 1.13205e-06 1.800 1.13300e-06 1.800 1.13305e-06 0.000 1.13400e-06 0.000
+ 1.13405e-06 1.800 1.13500e-06 1.800 1.13505e-06 0.000 1.13600e-06 0.000 1.13605e-06 1.800 1.13700e-06 1.800
+ 1.13705e-06 0.000 1.13800e-06 0.000 1.13805e-06 1.800 1.13900e-06 1.800 1.13905e-06 0.000 1.14000e-06 0.000
+ 1.14005e-06 1.800 1.14100e-06 1.800 1.14105e-06 0.000 1.14200e-06 0.000 1.14205e-06 1.800 1.14300e-06 1.800
+ 1.14305e-06 0.000 1.14400e-06 0.000 1.14405e-06 1.800 1.14500e-06 1.800 1.14505e-06 0.000 1.14600e-06 0.000
+ 1.14605e-06 1.800 1.14700e-06 1.800 1.14705e-06 0.000 1.14800e-06 0.000 1.14805e-06 1.800 1.14900e-06 1.800
+ 1.14905e-06 0.000 1.15000e-06 0.000 1.15005e-06 1.800 1.15100e-06 1.800 1.15105e-06 0.000 1.15200e-06 0.000
+ 1.15205e-06 1.800 1.15300e-06 1.800 1.15305e-06 0.000 1.15400e-06 0.000 1.15405e-06 1.800 1.15500e-06 1.800
+ 1.15505e-06 0.000 1.15600e-06 0.000 1.15605e-06 1.800 1.15700e-06 1.800 1.15705e-06 0.000 1.15800e-06 0.000
+ 1.15805e-06 1.800 1.15900e-06 1.800 1.15905e-06 0.000 1.16000e-06 0.000 1.16005e-06 1.800 1.16100e-06 1.800
+ 1.16105e-06 0.000 1.16200e-06 0.000 1.16205e-06 1.800 1.16300e-06 1.800 1.16305e-06 0.000 1.16400e-06 0.000
+ 1.16405e-06 1.800 1.16500e-06 1.800 1.16505e-06 0.000 1.16600e-06 0.000 1.16605e-06 1.800 1.16700e-06 1.800
+ 1.16705e-06 0.000 1.16800e-06 0.000 1.16805e-06 1.800 1.16900e-06 1.800 1.16905e-06 0.000 1.17000e-06 0.000
+ 1.17005e-06 1.800 1.17100e-06 1.800 1.17105e-06 0.000 1.17200e-06 0.000 1.17205e-06 1.800 1.17300e-06 1.800
+ 1.17305e-06 0.000 1.17400e-06 0.000 1.17405e-06 1.800 1.17500e-06 1.800 1.17505e-06 0.000 1.17600e-06 0.000
+ 1.17605e-06 1.800 1.17700e-06 1.800 1.17705e-06 0.000 1.17800e-06 0.000 1.17805e-06 1.800 1.17900e-06 1.800
+ 1.17905e-06 0.000 1.18000e-06 0.000 1.18005e-06 1.800 1.18100e-06 1.800 1.18105e-06 0.000 1.18200e-06 0.000
+ 1.18205e-06 1.800 1.18300e-06 1.800 1.18305e-06 0.000 1.18400e-06 0.000 1.18405e-06 1.800 1.18500e-06 1.800
+ 1.18505e-06 0.000 1.18600e-06 0.000 1.18605e-06 1.800 1.18700e-06 1.800 1.18705e-06 0.000 1.18800e-06 0.000
+ 1.18805e-06 1.800 1.18900e-06 1.800 1.18905e-06 0.000 1.19000e-06 0.000 1.19005e-06 1.800 1.19100e-06 1.800
+ 1.19105e-06 0.000 1.19200e-06 0.000 1.19205e-06 1.800 1.19300e-06 1.800 1.19305e-06 0.000 1.19400e-06 0.000
+ 1.19405e-06 1.800 1.19500e-06 1.800 1.19505e-06 0.000 1.19600e-06 0.000 1.19605e-06 1.800 1.19700e-06 1.800
+ 1.19705e-06 0.000 1.19800e-06 0.000 1.19805e-06 1.800 1.19900e-06 1.800 1.19905e-06 0.000 1.20000e-06 0.000
+ 1.20005e-06 1.800 1.20100e-06 1.800 1.20105e-06 0.000 1.20200e-06 0.000 1.20205e-06 1.800 1.20300e-06 1.800
+ 1.20305e-06 0.000 1.20400e-06 0.000 1.20405e-06 1.800 1.20500e-06 1.800 1.20505e-06 0.000 1.20600e-06 0.000
+ 1.20605e-06 1.800 1.20700e-06 1.800 1.20705e-06 0.000 1.20800e-06 0.000 1.20805e-06 1.800 1.20900e-06 1.800
+ 1.20905e-06 0.000 1.21000e-06 0.000 1.21005e-06 1.800 1.21100e-06 1.800 1.21105e-06 0.000 1.21200e-06 0.000
+ 1.21205e-06 1.800 1.21300e-06 1.800 1.21305e-06 0.000 1.21400e-06 0.000 1.21405e-06 1.800 1.21500e-06 1.800
+ 1.21505e-06 0.000 1.21600e-06 0.000 1.21605e-06 1.800 1.21700e-06 1.800 1.21705e-06 0.000 1.21800e-06 0.000
+ 1.21805e-06 1.800 1.21900e-06 1.800 1.21905e-06 0.000 1.22000e-06 0.000 1.22005e-06 1.800 1.22100e-06 1.800
+ 1.22105e-06 0.000 1.22200e-06 0.000 1.22205e-06 1.800 1.22300e-06 1.800 1.22305e-06 0.000 1.22400e-06 0.000
+ 1.22405e-06 1.800 1.22500e-06 1.800 1.22505e-06 0.000 1.22600e-06 0.000 1.22605e-06 1.800 1.22700e-06 1.800
+ 1.22705e-06 0.000 1.22800e-06 0.000 1.22805e-06 1.800 1.22900e-06 1.800 1.22905e-06 0.000 1.23000e-06 0.000
+ 1.23005e-06 1.800 1.23100e-06 1.800 1.23105e-06 0.000 1.23200e-06 0.000 1.23205e-06 1.800 1.23300e-06 1.800
+ 1.23305e-06 0.000 1.23400e-06 0.000 1.23405e-06 1.800 1.23500e-06 1.800 1.23505e-06 0.000 1.23600e-06 0.000
+ 1.23605e-06 1.800 1.23700e-06 1.800 1.23705e-06 0.000 1.23800e-06 0.000 1.23805e-06 1.800 1.23900e-06 1.800
+ 1.23905e-06 0.000 1.24000e-06 0.000 1.24005e-06 1.800 1.24100e-06 1.800 1.24105e-06 0.000 1.24200e-06 0.000
+ 1.24205e-06 1.800 1.24300e-06 1.800 1.24305e-06 0.000 1.24400e-06 0.000 1.24405e-06 1.800 1.24500e-06 1.800
+ 1.24505e-06 0.000 1.24600e-06 0.000 1.24605e-06 1.800 1.24700e-06 1.800 1.24705e-06 0.000 1.24800e-06 0.000
+ 1.24805e-06 1.800 1.24900e-06 1.800 1.24905e-06 0.000 1.25000e-06 0.000 1.25005e-06 1.800 1.25100e-06 1.800
+ 1.25105e-06 0.000 1.25200e-06 0.000 1.25205e-06 1.800 1.25300e-06 1.800 1.25305e-06 0.000 1.25400e-06 0.000
+ 1.25405e-06 1.800 1.25500e-06 1.800 1.25505e-06 0.000 1.25600e-06 0.000 1.25605e-06 1.800 1.25700e-06 1.800
+ 1.25705e-06 0.000 1.25800e-06 0.000 1.25805e-06 1.800 1.25900e-06 1.800 1.25905e-06 0.000 1.26000e-06 0.000
+ 1.26005e-06 1.800 1.26100e-06 1.800 1.26105e-06 0.000 1.26200e-06 0.000 1.26205e-06 1.800 1.26300e-06 1.800
+ 1.26305e-06 0.000 1.26400e-06 0.000 1.26405e-06 1.800 1.26500e-06 1.800 1.26505e-06 0.000 1.26600e-06 0.000
+ 1.26605e-06 1.800 1.26700e-06 1.800 1.26705e-06 0.000 1.26800e-06 0.000 1.26805e-06 1.800 1.26900e-06 1.800
+ 1.26905e-06 0.000 1.27000e-06 0.000 1.27005e-06 1.800 1.27100e-06 1.800 1.27105e-06 0.000 1.27200e-06 0.000
+ 1.27205e-06 1.800 1.27300e-06 1.800 1.27305e-06 0.000 1.27400e-06 0.000 1.27405e-06 1.800 1.27500e-06 1.800
+ 1.27505e-06 0.000 1.27600e-06 0.000 1.27605e-06 1.800 1.27700e-06 1.800 1.27705e-06 0.000 1.27800e-06 0.000
+ 1.27805e-06 1.800 1.27900e-06 1.800 1.27905e-06 0.000 1.28000e-06 0.000 1.28005e-06 1.800 1.28100e-06 1.800
+ 1.28105e-06 0.000 1.28200e-06 0.000 1.28205e-06 1.800 1.28300e-06 1.800 1.28305e-06 0.000 1.28400e-06 0.000
+ 1.28405e-06 1.800 1.28500e-06 1.800 1.28505e-06 0.000 1.28600e-06 0.000 1.28605e-06 1.800 1.28700e-06 1.800
+ 1.28705e-06 0.000 1.28800e-06 0.000 1.28805e-06 1.800 1.28900e-06 1.800 1.28905e-06 0.000 1.29000e-06 0.000
+ 1.29005e-06 1.800 1.29100e-06 1.800 1.29105e-06 0.000 1.29200e-06 0.000 1.29205e-06 1.800 1.29300e-06 1.800
+ 1.29305e-06 0.000 1.29400e-06 0.000 1.29405e-06 1.800 1.29500e-06 1.800 1.29505e-06 0.000 1.29600e-06 0.000
+ 1.29605e-06 1.800 1.29700e-06 1.800 1.29705e-06 0.000 1.29800e-06 0.000 1.29805e-06 1.800 1.29900e-06 1.800
+ 1.29905e-06 0.000 1.30000e-06 0.000 1.30005e-06 1.800 1.30100e-06 1.800 1.30105e-06 0.000 1.30200e-06 0.000
+ 1.30205e-06 1.800 1.30300e-06 1.800 1.30305e-06 0.000 1.30400e-06 0.000 1.30405e-06 1.800 1.30500e-06 1.800
+ 1.30505e-06 0.000 1.30600e-06 0.000 1.30605e-06 1.800 1.30700e-06 1.800 1.30705e-06 0.000 1.30800e-06 0.000
+ 1.30805e-06 1.800 1.30900e-06 1.800 1.30905e-06 0.000 1.31000e-06 0.000 1.31005e-06 1.800 1.31100e-06 1.800
+ 1.31105e-06 0.000 1.31200e-06 0.000 1.31205e-06 1.800 1.31300e-06 1.800 1.31305e-06 0.000 1.31400e-06 0.000
+ 1.31405e-06 1.800 1.31500e-06 1.800 1.31505e-06 0.000 1.31600e-06 0.000 1.31605e-06 1.800 1.31700e-06 1.800
+ 1.31705e-06 0.000 1.31800e-06 0.000 1.31805e-06 1.800 1.31900e-06 1.800 1.31905e-06 0.000 1.32000e-06 0.000
+ 1.32005e-06 1.800 1.32100e-06 1.800 1.32105e-06 0.000 1.32200e-06 0.000 1.32205e-06 1.800 1.32300e-06 1.800
+ 1.32305e-06 0.000 1.32400e-06 0.000 1.32405e-06 1.800 1.32500e-06 1.800 1.32505e-06 0.000 1.32600e-06 0.000
+ 1.32605e-06 1.800 1.32700e-06 1.800 1.32705e-06 0.000 1.32800e-06 0.000 1.32805e-06 1.800 1.32900e-06 1.800
+ 1.32905e-06 0.000 1.33000e-06 0.000 1.33005e-06 1.800 1.33100e-06 1.800 1.33105e-06 0.000 1.33200e-06 0.000
+ 1.33205e-06 1.800 1.33300e-06 1.800 1.33305e-06 0.000 1.33400e-06 0.000 1.33405e-06 1.800 1.33500e-06 1.800
+ 1.33505e-06 0.000 1.33600e-06 0.000 1.33605e-06 1.800 1.33700e-06 1.800 1.33705e-06 0.000 1.33800e-06 0.000
+ 1.33805e-06 1.800 1.33900e-06 1.800 1.33905e-06 0.000 1.34000e-06 0.000 1.34005e-06 1.800 1.34100e-06 1.800
+ 1.34105e-06 0.000 1.34200e-06 0.000 1.34205e-06 1.800 1.34300e-06 1.800 1.34305e-06 0.000 1.34400e-06 0.000
+ 1.34405e-06 1.800 1.34500e-06 1.800 1.34505e-06 0.000 1.34600e-06 0.000 1.34605e-06 1.800 1.34700e-06 1.800
+ 1.34705e-06 0.000 1.34800e-06 0.000 1.34805e-06 1.800 1.34900e-06 1.800 1.34905e-06 0.000 1.35000e-06 0.000
+ 1.35005e-06 1.800 1.35100e-06 1.800 1.35105e-06 0.000 1.35200e-06 0.000 1.35205e-06 1.800 1.35300e-06 1.800
+ 1.35305e-06 0.000 1.35400e-06 0.000 1.35405e-06 1.800 1.35500e-06 1.800 1.35505e-06 0.000 1.35600e-06 0.000
+ 1.35605e-06 1.800 1.35700e-06 1.800 1.35705e-06 0.000 1.35800e-06 0.000 1.35805e-06 1.800 1.35900e-06 1.800
+ 1.35905e-06 0.000 1.36000e-06 0.000 1.36005e-06 1.800 1.36100e-06 1.800 1.36105e-06 0.000 1.36200e-06 0.000
+ 1.36205e-06 1.800 1.36300e-06 1.800 1.36305e-06 0.000 1.36400e-06 0.000 1.36405e-06 1.800 1.36500e-06 1.800
+ 1.36505e-06 0.000 1.36600e-06 0.000 1.36605e-06 1.800 1.36700e-06 1.800 1.36705e-06 0.000 1.36800e-06 0.000
+ 1.36805e-06 1.800 1.36900e-06 1.800 1.36905e-06 0.000 1.37000e-06 0.000 1.37005e-06 1.800 1.37100e-06 1.800
+ 1.37105e-06 0.000 1.37200e-06 0.000 1.37205e-06 1.800 1.37300e-06 1.800 1.37305e-06 0.000 1.37400e-06 0.000
+ 1.37405e-06 1.800 1.37500e-06 1.800 1.37505e-06 0.000 1.37600e-06 0.000 1.37605e-06 1.800 1.37700e-06 1.800
+ 1.37705e-06 0.000 1.37800e-06 0.000 1.37805e-06 1.800 1.37900e-06 1.800 1.37905e-06 0.000 1.38000e-06 0.000
+ 1.38005e-06 1.800 1.38100e-06 1.800 1.38105e-06 0.000 1.38200e-06 0.000 1.38205e-06 1.800 1.38300e-06 1.800
+ 1.38305e-06 0.000 1.38400e-06 0.000 1.38405e-06 1.800 1.38500e-06 1.800 1.38505e-06 0.000 1.38600e-06 0.000
+ 1.38605e-06 1.800 1.38700e-06 1.800 1.38705e-06 0.000 1.38800e-06 0.000 1.38805e-06 1.800 1.38900e-06 1.800
+ 1.38905e-06 0.000 1.39000e-06 0.000 1.39005e-06 1.800 1.39100e-06 1.800 1.39105e-06 0.000 1.39200e-06 0.000
+ 1.39205e-06 1.800 1.39300e-06 1.800 1.39305e-06 0.000 1.39400e-06 0.000 1.39405e-06 1.800 1.39500e-06 1.800
+ 1.39505e-06 0.000 1.39600e-06 0.000 1.39605e-06 1.800 1.39700e-06 1.800 1.39705e-06 0.000 1.39800e-06 0.000
+ 1.39805e-06 1.800 1.39900e-06 1.800 1.39905e-06 0.000 1.40000e-06 0.000 1.40005e-06 1.800 1.40100e-06 1.800
+ 1.40105e-06 0.000 1.40200e-06 0.000 1.40205e-06 1.800 1.40300e-06 1.800 1.40305e-06 0.000 1.40400e-06 0.000
+ 1.40405e-06 1.800 1.40500e-06 1.800 1.40505e-06 0.000 1.40600e-06 0.000 1.40605e-06 1.800 1.40700e-06 1.800
+ 1.40705e-06 0.000 1.40800e-06 0.000 1.40805e-06 1.800 1.40900e-06 1.800 1.40905e-06 0.000 1.41000e-06 0.000
+ 1.41005e-06 1.800 1.41100e-06 1.800 1.41105e-06 0.000 1.41200e-06 0.000 1.41205e-06 1.800 1.41300e-06 1.800
+ 1.41305e-06 0.000 1.41400e-06 0.000 1.41405e-06 1.800 1.41500e-06 1.800 1.41505e-06 0.000 1.41600e-06 0.000
+ 1.41605e-06 1.800 1.41700e-06 1.800 1.41705e-06 0.000 1.41800e-06 0.000 1.41805e-06 1.800 1.41900e-06 1.800
+ 1.41905e-06 0.000 1.42000e-06 0.000 1.42005e-06 1.800 1.42100e-06 1.800 1.42105e-06 0.000 1.42200e-06 0.000
+ 1.42205e-06 1.800 1.42300e-06 1.800 1.42305e-06 0.000 1.42400e-06 0.000 1.42405e-06 1.800 1.42500e-06 1.800
+ 1.42505e-06 0.000 1.42600e-06 0.000 1.42605e-06 1.800 1.42700e-06 1.800 1.42705e-06 0.000 1.42800e-06 0.000
+ 1.42805e-06 1.800 1.42900e-06 1.800 1.42905e-06 0.000 1.43000e-06 0.000 1.43005e-06 1.800 1.43100e-06 1.800
+ 1.43105e-06 0.000 1.43200e-06 0.000 1.43205e-06 1.800 1.43300e-06 1.800 1.43305e-06 0.000 1.43400e-06 0.000
+ 1.43405e-06 1.800 1.43500e-06 1.800 1.43505e-06 0.000 1.43600e-06 0.000 1.43605e-06 1.800 1.43700e-06 1.800
+ 1.43705e-06 0.000 1.43800e-06 0.000 1.43805e-06 1.800 1.43900e-06 1.800 1.43905e-06 0.000 1.44000e-06 0.000
+ 1.44005e-06 1.800 1.44100e-06 1.800 1.44105e-06 0.000 1.44200e-06 0.000 1.44205e-06 1.800 1.44300e-06 1.800
+ 1.44305e-06 0.000 1.44400e-06 0.000 1.44405e-06 1.800 1.44500e-06 1.800 1.44505e-06 0.000 1.44600e-06 0.000
+ 1.44605e-06 1.800 1.44700e-06 1.800 1.44705e-06 0.000 1.44800e-06 0.000 1.44805e-06 1.800 1.44900e-06 1.800
+ 1.44905e-06 0.000 1.45000e-06 0.000 1.45005e-06 1.800 1.45100e-06 1.800 1.45105e-06 0.000 1.45200e-06 0.000
+ 1.45205e-06 1.800 1.45300e-06 1.800 1.45305e-06 0.000 1.45400e-06 0.000 1.45405e-06 1.800 1.45500e-06 1.800
+ 1.45505e-06 0.000 1.45600e-06 0.000 1.45605e-06 1.800 1.45700e-06 1.800 1.45705e-06 0.000 1.45800e-06 0.000
+ 1.45805e-06 1.800 1.45900e-06 1.800 1.45905e-06 0.000 1.46000e-06 0.000 1.46005e-06 1.800 1.46100e-06 1.800
+ 1.46105e-06 0.000 1.46200e-06 0.000 1.46205e-06 1.800 1.46300e-06 1.800 1.46305e-06 0.000 1.46400e-06 0.000
+ 1.46405e-06 1.800 1.46500e-06 1.800 1.46505e-06 0.000 1.46600e-06 0.000 1.46605e-06 1.800 1.46700e-06 1.800
+ 1.46705e-06 0.000 1.46800e-06 0.000 1.46805e-06 1.800 1.46900e-06 1.800 1.46905e-06 0.000 1.47000e-06 0.000
+ 1.47005e-06 1.800 1.47100e-06 1.800 1.47105e-06 0.000 1.47200e-06 0.000 1.47205e-06 1.800 1.47300e-06 1.800
+ 1.47305e-06 0.000 1.47400e-06 0.000 1.47405e-06 1.800 1.47500e-06 1.800 1.47505e-06 0.000 1.47600e-06 0.000
+ 1.47605e-06 1.800 1.47700e-06 1.800 1.47705e-06 0.000 1.47800e-06 0.000 1.47805e-06 1.800 1.47900e-06 1.800
+ 1.47905e-06 0.000 1.48000e-06 0.000 1.48005e-06 1.800 1.48100e-06 1.800 1.48105e-06 0.000 1.48200e-06 0.000
+ 1.48205e-06 1.800 1.48300e-06 1.800 1.48305e-06 0.000 1.48400e-06 0.000 1.48405e-06 1.800 1.48500e-06 1.800
+ 1.48505e-06 0.000 1.48600e-06 0.000 1.48605e-06 1.800 1.48700e-06 1.800 1.48705e-06 0.000 1.48800e-06 0.000
+ 1.48805e-06 1.800 1.48900e-06 1.800 1.48905e-06 0.000 1.49000e-06 0.000 1.49005e-06 1.800 1.49100e-06 1.800
+ 1.49105e-06 0.000 1.49200e-06 0.000 1.49205e-06 1.800 1.49300e-06 1.800 1.49305e-06 0.000 1.49400e-06 0.000
+ 1.49405e-06 1.800 1.49500e-06 1.800 1.49505e-06 0.000 1.49600e-06 0.000 1.49605e-06 1.800 1.49700e-06 1.800
+ 1.49705e-06 0.000 1.49800e-06 0.000 1.49805e-06 1.800 1.49900e-06 1.800 1.49905e-06 0.000 1.50000e-06 0.000
+ 1.50005e-06 1.800 1.50100e-06 1.800 1.50105e-06 0.000 1.50200e-06 0.000 1.50205e-06 1.800 1.50300e-06 1.800
+ 1.50305e-06 0.000 1.50400e-06 0.000 1.50405e-06 1.800 1.50500e-06 1.800 1.50505e-06 0.000 1.50600e-06 0.000
+ 1.50605e-06 1.800 1.50700e-06 1.800 1.50705e-06 0.000 1.50800e-06 0.000 1.50805e-06 1.800 1.50900e-06 1.800
+ 1.50905e-06 0.000 1.51000e-06 0.000 1.51005e-06 1.800 1.51100e-06 1.800 1.51105e-06 0.000 1.51200e-06 0.000
+ 1.51205e-06 1.800 1.51300e-06 1.800 1.51305e-06 0.000 1.51400e-06 0.000 1.51405e-06 1.800 1.51500e-06 1.800
+ 1.51505e-06 0.000 1.51600e-06 0.000 1.51605e-06 1.800 1.51700e-06 1.800 1.51705e-06 0.000 1.51800e-06 0.000
+ 1.51805e-06 1.800 1.51900e-06 1.800 1.51905e-06 0.000 1.52000e-06 0.000 1.52005e-06 1.800 1.52100e-06 1.800
+ 1.52105e-06 0.000 1.52200e-06 0.000 1.52205e-06 1.800 1.52300e-06 1.800 1.52305e-06 0.000 1.52400e-06 0.000
+ 1.52405e-06 1.800 1.52500e-06 1.800 1.52505e-06 0.000 1.52600e-06 0.000 1.52605e-06 1.800 1.52700e-06 1.800
+ 1.52705e-06 0.000 1.52800e-06 0.000 1.52805e-06 1.800 1.52900e-06 1.800 1.52905e-06 0.000 1.53000e-06 0.000
+ 1.53005e-06 1.800 1.53100e-06 1.800 1.53105e-06 0.000 1.53200e-06 0.000 1.53205e-06 1.800 1.53300e-06 1.800
+ 1.53305e-06 0.000 1.53400e-06 0.000 1.53405e-06 1.800 1.53500e-06 1.800 1.53505e-06 0.000 1.53600e-06 0.000
+ 1.53605e-06 1.800 1.53700e-06 1.800 1.53705e-06 0.000 1.53800e-06 0.000 1.53805e-06 1.800 1.53900e-06 1.800
+ 1.53905e-06 0.000 1.54000e-06 0.000 1.54005e-06 1.800 1.54100e-06 1.800 1.54105e-06 0.000 1.54200e-06 0.000
+ 1.54205e-06 1.800 1.54300e-06 1.800 1.54305e-06 0.000 1.54400e-06 0.000 1.54405e-06 1.800 1.54500e-06 1.800
+ 1.54505e-06 0.000 1.54600e-06 0.000 1.54605e-06 1.800 1.54700e-06 1.800 1.54705e-06 0.000 1.54800e-06 0.000
+ 1.54805e-06 1.800 1.54900e-06 1.800 1.54905e-06 0.000 1.55000e-06 0.000 1.55005e-06 1.800 1.55100e-06 1.800
+ 1.55105e-06 0.000 1.55200e-06 0.000 1.55205e-06 1.800 1.55300e-06 1.800 1.55305e-06 0.000 1.55400e-06 0.000
+ 1.55405e-06 1.800 1.55500e-06 1.800 1.55505e-06 0.000 1.55600e-06 0.000 1.55605e-06 1.800 1.55700e-06 1.800
+ 1.55705e-06 0.000 1.55800e-06 0.000 1.55805e-06 1.800 1.55900e-06 1.800 1.55905e-06 0.000 1.56000e-06 0.000
+ 1.56005e-06 1.800 1.56100e-06 1.800 1.56105e-06 0.000 1.56200e-06 0.000 1.56205e-06 1.800 1.56300e-06 1.800
+ 1.56305e-06 0.000 1.56400e-06 0.000 1.56405e-06 1.800 1.56500e-06 1.800 1.56505e-06 0.000 1.56600e-06 0.000
+ 1.56605e-06 1.800 1.56700e-06 1.800 1.56705e-06 0.000 1.56800e-06 0.000 1.56805e-06 1.800 1.56900e-06 1.800
+ 1.56905e-06 0.000 1.57000e-06 0.000 1.57005e-06 1.800 1.57100e-06 1.800 1.57105e-06 0.000 1.57200e-06 0.000
+ 1.57205e-06 1.800 1.57300e-06 1.800 1.57305e-06 0.000 1.57400e-06 0.000 1.57405e-06 1.800 1.57500e-06 1.800
+ 1.57505e-06 0.000 1.57600e-06 0.000 1.57605e-06 1.800 1.57700e-06 1.800 1.57705e-06 0.000 1.57800e-06 0.000
+ 1.57805e-06 1.800 1.57900e-06 1.800 1.57905e-06 0.000 1.58000e-06 0.000 1.58005e-06 1.800 1.58100e-06 1.800
+ 1.58105e-06 0.000 1.58200e-06 0.000 1.58205e-06 1.800 1.58300e-06 1.800 1.58305e-06 0.000 1.58400e-06 0.000
+ 1.58405e-06 1.800 1.58500e-06 1.800 1.58505e-06 0.000 1.58600e-06 0.000 1.58605e-06 1.800 1.58700e-06 1.800
+ 1.58705e-06 0.000 1.58800e-06 0.000 1.58805e-06 1.800 1.58900e-06 1.800 1.58905e-06 0.000 1.59000e-06 0.000
+ 1.59005e-06 1.800 1.59100e-06 1.800 1.59105e-06 0.000 1.59200e-06 0.000 1.59205e-06 1.800 1.59300e-06 1.800
+ 1.59305e-06 0.000 1.59400e-06 0.000 1.59405e-06 1.800 1.59500e-06 1.800 1.59505e-06 0.000 1.59600e-06 0.000
+ 1.59605e-06 1.800 1.59700e-06 1.800 1.59705e-06 0.000 1.59800e-06 0.000 1.59805e-06 1.800 1.59900e-06 1.800
+ 1.59905e-06 0.000 1.60000e-06 0.000 1.60005e-06 1.800 1.60100e-06 1.800 1.60105e-06 0.000 1.60200e-06 0.000
+ 1.60205e-06 1.800 1.60300e-06 1.800 1.60305e-06 0.000 1.60400e-06 0.000 1.60405e-06 1.800 1.60500e-06 1.800
+ 1.60505e-06 0.000 1.60600e-06 0.000 1.60605e-06 1.800 1.60700e-06 1.800 1.60705e-06 0.000 1.60800e-06 0.000
+ 1.60805e-06 1.800 1.60900e-06 1.800 1.60905e-06 0.000 1.61000e-06 0.000 1.61005e-06 1.800 1.61100e-06 1.800
+ 1.61105e-06 0.000 1.61200e-06 0.000 1.61205e-06 1.800 1.61300e-06 1.800 1.61305e-06 0.000 1.61400e-06 0.000
+ 1.61405e-06 1.800 1.61500e-06 1.800 1.61505e-06 0.000 1.61600e-06 0.000 1.61605e-06 1.800 1.61700e-06 1.800
+ 1.61705e-06 0.000 1.61800e-06 0.000 1.61805e-06 1.800 1.61900e-06 1.800 1.61905e-06 0.000 1.62000e-06 0.000
+ 1.62005e-06 1.800 1.62100e-06 1.800 1.62105e-06 0.000 1.62200e-06 0.000 1.62205e-06 1.800 1.62300e-06 1.800
+ 1.62305e-06 0.000 1.62400e-06 0.000 1.62405e-06 1.800 1.62500e-06 1.800 1.62505e-06 0.000 1.62600e-06 0.000
+ 1.62605e-06 1.800 1.62700e-06 1.800 1.62705e-06 0.000 1.62800e-06 0.000 1.62805e-06 1.800 1.62900e-06 1.800
+ 1.62905e-06 0.000 1.63000e-06 0.000 1.63005e-06 1.800 1.63100e-06 1.800 1.63105e-06 0.000 1.63200e-06 0.000
+ 1.63205e-06 1.800 1.63300e-06 1.800 1.63305e-06 0.000 1.63400e-06 0.000 1.63405e-06 1.800 1.63500e-06 1.800
+ 1.63505e-06 0.000 1.63600e-06 0.000 1.63605e-06 1.800 1.63700e-06 1.800 1.63705e-06 0.000 1.63800e-06 0.000
+ 1.63805e-06 1.800 1.63900e-06 1.800 1.63905e-06 0.000 1.64000e-06 0.000 1.64005e-06 1.800 1.64100e-06 1.800
+ 1.64105e-06 0.000 1.64200e-06 0.000 1.64205e-06 1.800 1.64300e-06 1.800 1.64305e-06 0.000 1.64400e-06 0.000
+ 1.64405e-06 1.800 1.64500e-06 1.800 1.64505e-06 0.000 1.64600e-06 0.000 1.64605e-06 1.800 1.64700e-06 1.800
+ 1.64705e-06 0.000 1.64800e-06 0.000 1.64805e-06 1.800 1.64900e-06 1.800 1.64905e-06 0.000 1.65000e-06 0.000
+ 1.65005e-06 1.800 1.65100e-06 1.800 1.65105e-06 0.000 1.65200e-06 0.000 1.65205e-06 1.800 1.65300e-06 1.800
+ 1.65305e-06 0.000 1.65400e-06 0.000 1.65405e-06 1.800 1.65500e-06 1.800 1.65505e-06 0.000 1.65600e-06 0.000
+ 1.65605e-06 1.800 1.65700e-06 1.800 1.65705e-06 0.000 1.65800e-06 0.000 1.65805e-06 1.800 1.65900e-06 1.800
+ 1.65905e-06 0.000 1.66000e-06 0.000 1.66005e-06 1.800 1.66100e-06 1.800 1.66105e-06 0.000 1.66200e-06 0.000
+ 1.66205e-06 1.800 1.66300e-06 1.800 1.66305e-06 0.000 1.66400e-06 0.000 1.66405e-06 1.800 1.66500e-06 1.800
+ 1.66505e-06 0.000 1.66600e-06 0.000 1.66605e-06 1.800 1.66700e-06 1.800 1.66705e-06 0.000 1.66800e-06 0.000
+ 1.66805e-06 1.800 1.66900e-06 1.800 1.66905e-06 0.000 1.67000e-06 0.000 1.67005e-06 1.800 1.67100e-06 1.800
+ 1.67105e-06 0.000 1.67200e-06 0.000 1.67205e-06 1.800 1.67300e-06 1.800 1.67305e-06 0.000 1.67400e-06 0.000
+ 1.67405e-06 1.800 1.67500e-06 1.800 1.67505e-06 0.000 1.67600e-06 0.000 1.67605e-06 1.800 1.67700e-06 1.800
+ 1.67705e-06 0.000 1.67800e-06 0.000 1.67805e-06 1.800 1.67900e-06 1.800 1.67905e-06 0.000 1.68000e-06 0.000
+ 1.68005e-06 1.800 1.68100e-06 1.800 1.68105e-06 0.000 1.68200e-06 0.000 1.68205e-06 1.800 1.68300e-06 1.800
+ 1.68305e-06 0.000 1.68400e-06 0.000 1.68405e-06 1.800 1.68500e-06 1.800 1.68505e-06 0.000 1.68600e-06 0.000
+ 1.68605e-06 1.800 1.68700e-06 1.800 1.68705e-06 0.000 1.68800e-06 0.000 1.68805e-06 1.800 1.68900e-06 1.800
+ 1.68905e-06 0.000 1.69000e-06 0.000 1.69005e-06 1.800 1.69100e-06 1.800 1.69105e-06 0.000 1.69200e-06 0.000
+ 1.69205e-06 1.800 1.69300e-06 1.800 1.69305e-06 0.000 1.69400e-06 0.000 1.69405e-06 1.800 1.69500e-06 1.800
+ 1.69505e-06 0.000 1.69600e-06 0.000 1.69605e-06 1.800 1.69700e-06 1.800 1.69705e-06 0.000 1.69800e-06 0.000
+ 1.69805e-06 1.800 1.69900e-06 1.800 1.69905e-06 0.000 1.70000e-06 0.000 1.70005e-06 1.800 1.70100e-06 1.800
+ 1.70105e-06 0.000 1.70200e-06 0.000 1.70205e-06 1.800 1.70300e-06 1.800 1.70305e-06 0.000 1.70400e-06 0.000
+ 1.70405e-06 1.800 1.70500e-06 1.800 1.70505e-06 0.000 1.70600e-06 0.000 1.70605e-06 1.800 1.70700e-06 1.800
+ 1.70705e-06 0.000 1.70800e-06 0.000 1.70805e-06 1.800 1.70900e-06 1.800 1.70905e-06 0.000 1.71000e-06 0.000
+ 1.71005e-06 1.800 1.71100e-06 1.800 1.71105e-06 0.000 1.71200e-06 0.000 1.71205e-06 1.800 1.71300e-06 1.800
+ 1.71305e-06 0.000 1.71400e-06 0.000 1.71405e-06 1.800 1.71500e-06 1.800 1.71505e-06 0.000 1.71600e-06 0.000
+ 1.71605e-06 1.800 1.71700e-06 1.800 1.71705e-06 0.000 1.71800e-06 0.000 1.71805e-06 1.800 1.71900e-06 1.800
+ 1.71905e-06 0.000 1.72000e-06 0.000 1.72005e-06 1.800 1.72100e-06 1.800 1.72105e-06 0.000 1.72200e-06 0.000
+ 1.72205e-06 1.800 1.72300e-06 1.800 1.72305e-06 0.000 1.72400e-06 0.000 1.72405e-06 1.800 1.72500e-06 1.800
+ 1.72505e-06 0.000 1.72600e-06 0.000 1.72605e-06 1.800 1.72700e-06 1.800 1.72705e-06 0.000 1.72800e-06 0.000
+ 1.72805e-06 1.800 1.72900e-06 1.800 1.72905e-06 0.000 1.73000e-06 0.000 1.73005e-06 1.800 1.73100e-06 1.800
+ 1.73105e-06 0.000 1.73200e-06 0.000 1.73205e-06 1.800 1.73300e-06 1.800 1.73305e-06 0.000 1.73400e-06 0.000
+ 1.73405e-06 1.800 1.73500e-06 1.800 1.73505e-06 0.000 1.73600e-06 0.000 1.73605e-06 1.800 1.73700e-06 1.800
+ 1.73705e-06 0.000 1.73800e-06 0.000 1.73805e-06 1.800 1.73900e-06 1.800 1.73905e-06 0.000 1.74000e-06 0.000
+ 1.74005e-06 1.800 1.74100e-06 1.800 1.74105e-06 0.000 1.74200e-06 0.000 1.74205e-06 1.800 1.74300e-06 1.800
+ 1.74305e-06 0.000 1.74400e-06 0.000 1.74405e-06 1.800 1.74500e-06 1.800 1.74505e-06 0.000 1.74600e-06 0.000
+ 1.74605e-06 1.800 1.74700e-06 1.800 1.74705e-06 0.000 1.74800e-06 0.000 1.74805e-06 1.800 1.74900e-06 1.800
+ 1.74905e-06 0.000 1.75000e-06 0.000 1.75005e-06 1.800 1.75100e-06 1.800 1.75105e-06 0.000 1.75200e-06 0.000
+ 1.75205e-06 1.800 1.75300e-06 1.800 1.75305e-06 0.000 1.75400e-06 0.000 1.75405e-06 1.800 1.75500e-06 1.800
+ 1.75505e-06 0.000 1.75600e-06 0.000 1.75605e-06 1.800 1.75700e-06 1.800 1.75705e-06 0.000 1.75800e-06 0.000
+ 1.75805e-06 1.800 1.75900e-06 1.800 1.75905e-06 0.000 1.76000e-06 0.000 1.76005e-06 1.800 1.76100e-06 1.800
+ 1.76105e-06 0.000 1.76200e-06 0.000 1.76205e-06 1.800 1.76300e-06 1.800 1.76305e-06 0.000 1.76400e-06 0.000
+ 1.76405e-06 1.800 1.76500e-06 1.800 1.76505e-06 0.000 1.76600e-06 0.000 1.76605e-06 1.800 1.76700e-06 1.800
+ 1.76705e-06 0.000 1.76800e-06 0.000 1.76805e-06 1.800 1.76900e-06 1.800 1.76905e-06 0.000 1.77000e-06 0.000
+ 1.77005e-06 1.800 1.77100e-06 1.800 1.77105e-06 0.000 1.77200e-06 0.000 1.77205e-06 1.800 1.77300e-06 1.800
+ 1.77305e-06 0.000 1.77400e-06 0.000 1.77405e-06 1.800 1.77500e-06 1.800 1.77505e-06 0.000 1.77600e-06 0.000
+ 1.77605e-06 1.800 1.77700e-06 1.800 1.77705e-06 0.000 1.77800e-06 0.000 1.77805e-06 1.800 1.77900e-06 1.800
+ 1.77905e-06 0.000 1.78000e-06 0.000 1.78005e-06 1.800 1.78100e-06 1.800 1.78105e-06 0.000 1.78200e-06 0.000
+ 1.78205e-06 1.800 1.78300e-06 1.800 1.78305e-06 0.000 1.78400e-06 0.000 1.78405e-06 1.800 1.78500e-06 1.800
+ 1.78505e-06 0.000 1.78600e-06 0.000 1.78605e-06 1.800 1.78700e-06 1.800 1.78705e-06 0.000 1.78800e-06 0.000
+ 1.78805e-06 1.800 1.78900e-06 1.800 1.78905e-06 0.000 1.79000e-06 0.000 1.79005e-06 1.800 1.79100e-06 1.800
+ 1.79105e-06 0.000 1.79200e-06 0.000 1.79205e-06 1.800 1.79300e-06 1.800 1.79305e-06 0.000 1.79400e-06 0.000
+ 1.79405e-06 1.800 1.79500e-06 1.800 1.79505e-06 0.000 1.79600e-06 0.000 1.79605e-06 1.800 1.79700e-06 1.800
+ 1.79705e-06 0.000 1.79800e-06 0.000 1.79805e-06 1.800 1.79900e-06 1.800 1.79905e-06 0.000 1.80000e-06 0.000
+ 1.80005e-06 1.800 1.80100e-06 1.800 1.80105e-06 0.000 1.80200e-06 0.000 1.80205e-06 1.800 1.80300e-06 1.800
+ 1.80305e-06 0.000 1.80400e-06 0.000 1.80405e-06 1.800 1.80500e-06 1.800 1.80505e-06 0.000 1.80600e-06 0.000
+ 1.80605e-06 1.800 1.80700e-06 1.800 1.80705e-06 0.000 1.80800e-06 0.000 1.80805e-06 1.800 1.80900e-06 1.800
+ 1.80905e-06 0.000 1.81000e-06 0.000 1.81005e-06 1.800 1.81100e-06 1.800 1.81105e-06 0.000 1.81200e-06 0.000
+ 1.81205e-06 1.800 1.81300e-06 1.800 1.81305e-06 0.000 1.81400e-06 0.000 1.81405e-06 1.800 1.81500e-06 1.800
+ 1.81505e-06 0.000 1.81600e-06 0.000 1.81605e-06 1.800 1.81700e-06 1.800 1.81705e-06 0.000 1.81800e-06 0.000
+ 1.81805e-06 1.800 1.81900e-06 1.800 1.81905e-06 0.000 1.82000e-06 0.000 1.82005e-06 1.800 1.82100e-06 1.800
+ 1.82105e-06 0.000 1.82200e-06 0.000 1.82205e-06 1.800 1.82300e-06 1.800 1.82305e-06 0.000 1.82400e-06 0.000
+ 1.82405e-06 1.800 1.82500e-06 1.800 1.82505e-06 0.000 1.82600e-06 0.000 1.82605e-06 1.800 1.82700e-06 1.800
+ 1.82705e-06 0.000 1.82800e-06 0.000 1.82805e-06 1.800 1.82900e-06 1.800 1.82905e-06 0.000 1.83000e-06 0.000
+ 1.83005e-06 1.800 1.83100e-06 1.800 1.83105e-06 0.000 1.83200e-06 0.000 1.83205e-06 1.800 1.83300e-06 1.800
+ 1.83305e-06 0.000 1.83400e-06 0.000 1.83405e-06 1.800 1.83500e-06 1.800 1.83505e-06 0.000 1.83600e-06 0.000
+ 1.83605e-06 1.800 1.83700e-06 1.800 1.83705e-06 0.000 1.83800e-06 0.000 1.83805e-06 1.800 1.83900e-06 1.800
+ 1.83905e-06 0.000 1.84000e-06 0.000 1.84005e-06 1.800 1.84100e-06 1.800 1.84105e-06 0.000 1.84200e-06 0.000
+ 1.84205e-06 1.800 1.84300e-06 1.800 1.84305e-06 0.000 1.84400e-06 0.000 1.84405e-06 1.800 1.84500e-06 1.800
+ 1.84505e-06 0.000 1.84600e-06 0.000 1.84605e-06 1.800 1.84700e-06 1.800 1.84705e-06 0.000 1.84800e-06 0.000
+ 1.84805e-06 1.800 1.84900e-06 1.800 1.84905e-06 0.000 1.85000e-06 0.000 1.85005e-06 1.800 1.85100e-06 1.800
+ 1.85105e-06 0.000 1.85200e-06 0.000 1.85205e-06 1.800 1.85300e-06 1.800 1.85305e-06 0.000 1.85400e-06 0.000
+ 1.85405e-06 1.800 1.85500e-06 1.800 1.85505e-06 0.000 1.85600e-06 0.000 1.85605e-06 1.800 1.85700e-06 1.800
+ 1.85705e-06 0.000 1.85800e-06 0.000 1.85805e-06 1.800 1.85900e-06 1.800 1.85905e-06 0.000 1.86000e-06 0.000
+ 1.86005e-06 1.800 1.86100e-06 1.800 1.86105e-06 0.000 1.86200e-06 0.000 1.86205e-06 1.800 1.86300e-06 1.800
+ 1.86305e-06 0.000 1.86400e-06 0.000 1.86405e-06 1.800 1.86500e-06 1.800 1.86505e-06 0.000 1.86600e-06 0.000
+ 1.86605e-06 1.800 1.86700e-06 1.800 1.86705e-06 0.000 1.86800e-06 0.000 1.86805e-06 1.800 1.86900e-06 1.800
+ 1.86905e-06 0.000 1.87000e-06 0.000 1.87005e-06 1.800 1.87100e-06 1.800 1.87105e-06 0.000 1.87200e-06 0.000
+ 1.87205e-06 1.800 1.87300e-06 1.800 1.87305e-06 0.000 1.87400e-06 0.000 1.87405e-06 1.800 1.87500e-06 1.800
+ 1.87505e-06 0.000 1.87600e-06 0.000 1.87605e-06 1.800 1.87700e-06 1.800 1.87705e-06 0.000 1.87800e-06 0.000
+ 1.87805e-06 1.800 1.87900e-06 1.800 1.87905e-06 0.000 1.88000e-06 0.000 1.88005e-06 1.800 1.88100e-06 1.800
+ 1.88105e-06 0.000 1.88200e-06 0.000 1.88205e-06 1.800 1.88300e-06 1.800 1.88305e-06 0.000 1.88400e-06 0.000
+ 1.88405e-06 1.800 1.88500e-06 1.800 1.88505e-06 0.000 1.88600e-06 0.000 1.88605e-06 1.800 1.88700e-06 1.800
+ 1.88705e-06 0.000 1.88800e-06 0.000 1.88805e-06 1.800 1.88900e-06 1.800 1.88905e-06 0.000 1.89000e-06 0.000
+ 1.89005e-06 1.800 1.89100e-06 1.800 1.89105e-06 0.000 1.89200e-06 0.000 1.89205e-06 1.800 1.89300e-06 1.800
+ 1.89305e-06 0.000 1.89400e-06 0.000 1.89405e-06 1.800 1.89500e-06 1.800 1.89505e-06 0.000 1.89600e-06 0.000
+ 1.89605e-06 1.800 1.89700e-06 1.800 1.89705e-06 0.000 1.89800e-06 0.000 1.89805e-06 1.800 1.89900e-06 1.800
+ 1.89905e-06 0.000 1.90000e-06 0.000 1.90005e-06 1.800 1.90100e-06 1.800 1.90105e-06 0.000 1.90200e-06 0.000
+ 1.90205e-06 1.800 1.90300e-06 1.800 1.90305e-06 0.000 1.90400e-06 0.000 1.90405e-06 1.800 1.90500e-06 1.800
+ 1.90505e-06 0.000 1.90600e-06 0.000 1.90605e-06 1.800 1.90700e-06 1.800 1.90705e-06 0.000 1.90800e-06 0.000
+ 1.90805e-06 1.800 1.90900e-06 1.800 1.90905e-06 0.000 1.91000e-06 0.000 1.91005e-06 1.800 1.91100e-06 1.800
+ 1.91105e-06 0.000 1.91200e-06 0.000 1.91205e-06 1.800 1.91300e-06 1.800 1.91305e-06 0.000 1.91400e-06 0.000
+ 1.91405e-06 1.800 1.91500e-06 1.800 1.91505e-06 0.000 1.91600e-06 0.000 1.91605e-06 1.800 1.91700e-06 1.800
+ 1.91705e-06 0.000 1.91800e-06 0.000 1.91805e-06 1.800 1.91900e-06 1.800 1.91905e-06 0.000 1.92000e-06 0.000
+ 1.92005e-06 1.800 1.92100e-06 1.800 1.92105e-06 0.000 1.92200e-06 0.000 1.92205e-06 1.800 1.92300e-06 1.800
+ 1.92305e-06 0.000 1.92400e-06 0.000 1.92405e-06 1.800 1.92500e-06 1.800 1.92505e-06 0.000 1.92600e-06 0.000
+ 1.92605e-06 1.800 1.92700e-06 1.800 1.92705e-06 0.000 1.92800e-06 0.000 1.92805e-06 1.800 1.92900e-06 1.800
+ 1.92905e-06 0.000 1.93000e-06 0.000 1.93005e-06 1.800 1.93100e-06 1.800 1.93105e-06 0.000 1.93200e-06 0.000
+ 1.93205e-06 1.800 1.93300e-06 1.800 1.93305e-06 0.000 1.93400e-06 0.000 1.93405e-06 1.800 1.93500e-06 1.800
+ 1.93505e-06 0.000 1.93600e-06 0.000 1.93605e-06 1.800 1.93700e-06 1.800 1.93705e-06 0.000 1.93800e-06 0.000
+ 1.93805e-06 1.800 1.93900e-06 1.800 1.93905e-06 0.000 1.94000e-06 0.000 1.94005e-06 1.800 1.94100e-06 1.800
+ 1.94105e-06 0.000 1.94200e-06 0.000 1.94205e-06 1.800 1.94300e-06 1.800 1.94305e-06 0.000 1.94400e-06 0.000
+ 1.94405e-06 1.800 1.94500e-06 1.800 1.94505e-06 0.000 1.94600e-06 0.000 1.94605e-06 1.800 1.94700e-06 1.800
+ 1.94705e-06 0.000 1.94800e-06 0.000 1.94805e-06 1.800 1.94900e-06 1.800 1.94905e-06 0.000 1.95000e-06 0.000
+ 1.95005e-06 1.800 1.95100e-06 1.800 1.95105e-06 0.000 1.95200e-06 0.000 1.95205e-06 1.800 1.95300e-06 1.800
+ 1.95305e-06 0.000 1.95400e-06 0.000 1.95405e-06 1.800 1.95500e-06 1.800 1.95505e-06 0.000 1.95600e-06 0.000
+ 1.95605e-06 1.800 1.95700e-06 1.800 1.95705e-06 0.000 1.95800e-06 0.000 1.95805e-06 1.800 1.95900e-06 1.800
+ 1.95905e-06 0.000 1.96000e-06 0.000 1.96005e-06 1.800 1.96100e-06 1.800 1.96105e-06 0.000 1.96200e-06 0.000
+ 1.96205e-06 1.800 1.96300e-06 1.800 1.96305e-06 0.000 1.96400e-06 0.000 1.96405e-06 1.800 1.96500e-06 1.800
+ 1.96505e-06 0.000 1.96600e-06 0.000 1.96605e-06 1.800 1.96700e-06 1.800 1.96705e-06 0.000 1.96800e-06 0.000
+ 1.96805e-06 1.800 1.96900e-06 1.800 1.96905e-06 0.000 1.97000e-06 0.000 1.97005e-06 1.800 1.97100e-06 1.800
+ 1.97105e-06 0.000 1.97200e-06 0.000 1.97205e-06 1.800 1.97300e-06 1.800 1.97305e-06 0.000 1.97400e-06 0.000
+ 1.97405e-06 1.800 1.97500e-06 1.800 1.97505e-06 0.000 1.97600e-06 0.000 1.97605e-06 1.800 1.97700e-06 1.800
+ 1.97705e-06 0.000 1.97800e-06 0.000 1.97805e-06 1.800 1.97900e-06 1.800 1.97905e-06 0.000 1.98000e-06 0.000
+ 1.98005e-06 1.800 1.98100e-06 1.800 1.98105e-06 0.000 1.98200e-06 0.000 1.98205e-06 1.800 1.98300e-06 1.800
+ 1.98305e-06 0.000 1.98400e-06 0.000 1.98405e-06 1.800 1.98500e-06 1.800 1.98505e-06 0.000 1.98600e-06 0.000
+ 1.98605e-06 1.800 1.98700e-06 1.800 1.98705e-06 0.000 1.98800e-06 0.000 1.98805e-06 1.800 1.98900e-06 1.800
+ 1.98905e-06 0.000 1.99000e-06 0.000 1.99005e-06 1.800 1.99100e-06 1.800 1.99105e-06 0.000 1.99200e-06 0.000
+ 1.99205e-06 1.800 1.99300e-06 1.800 1.99305e-06 0.000 1.99400e-06 0.000 1.99405e-06 1.800 1.99500e-06 1.800
+ 1.99505e-06 0.000 1.99600e-06 0.000 1.99605e-06 1.800 1.99700e-06 1.800 1.99705e-06 0.000 1.99800e-06 0.000
+ 1.99805e-06 1.800 1.99900e-06 1.800 1.99905e-06 0.000 2.00000e-06 0.000 2.00005e-06 1.800 2.00100e-06 1.800
+ 2.00105e-06 0.000 2.00200e-06 0.000 2.00205e-06 1.800 2.00300e-06 1.800 2.00305e-06 0.000 2.00400e-06 0.000
+ 2.00405e-06 1.800 2.00500e-06 1.800 2.00505e-06 0.000 2.00600e-06 0.000 2.00605e-06 1.800 2.00700e-06 1.800
+ 2.00705e-06 0.000 2.00800e-06 0.000 2.00805e-06 1.800 2.00900e-06 1.800 2.00905e-06 0.000 2.01000e-06 0.000
+ 2.01005e-06 1.800 2.01100e-06 1.800 2.01105e-06 0.000 2.01200e-06 0.000 2.01205e-06 1.800 2.01300e-06 1.800
+ 2.01305e-06 0.000 2.01400e-06 0.000 2.01405e-06 1.800 2.01500e-06 1.800 2.01505e-06 0.000 2.01600e-06 0.000
+ 2.01605e-06 1.800 2.01700e-06 1.800 2.01705e-06 0.000 2.01800e-06 0.000 2.01805e-06 1.800 2.01900e-06 1.800
+ 2.01905e-06 0.000 2.02000e-06 0.000 2.02005e-06 1.800 2.02100e-06 1.800 2.02105e-06 0.000 2.02200e-06 0.000
+ 2.02205e-06 1.800 2.02300e-06 1.800 2.02305e-06 0.000 2.02400e-06 0.000 2.02405e-06 1.800 2.02500e-06 1.800
+ 2.02505e-06 0.000 2.02600e-06 0.000 2.02605e-06 1.800 2.02700e-06 1.800 2.02705e-06 0.000 2.02800e-06 0.000
+ 2.02805e-06 1.800 2.02900e-06 1.800 2.02905e-06 0.000 2.03000e-06 0.000 2.03005e-06 1.800 2.03100e-06 1.800
+ 2.03105e-06 0.000 2.03200e-06 0.000 2.03205e-06 1.800 2.03300e-06 1.800 2.03305e-06 0.000 2.03400e-06 0.000
+ 2.03405e-06 1.800 2.03500e-06 1.800 2.03505e-06 0.000 2.03600e-06 0.000 2.03605e-06 1.800 2.03700e-06 1.800
+ 2.03705e-06 0.000 2.03800e-06 0.000 2.03805e-06 1.800 2.03900e-06 1.800 2.03905e-06 0.000 2.04000e-06 0.000
+ 2.04005e-06 1.800 2.04100e-06 1.800 2.04105e-06 0.000 2.04200e-06 0.000 2.04205e-06 1.800 2.04300e-06 1.800
+ 2.04305e-06 0.000 2.04400e-06 0.000 2.04405e-06 1.800 2.04500e-06 1.800 2.04505e-06 0.000 2.04600e-06 0.000
+ 2.04605e-06 1.800 2.04700e-06 1.800 2.04705e-06 0.000 2.04800e-06 0.000 2.04805e-06 1.800 2.04900e-06 1.800
+ 2.04905e-06 0.000 2.05100e-06 0.000 2.05105e-06 1.800 2.05200e-06 1.800 2.05205e-06 0.000 2.05400e-06 0.000
+ 2.05405e-06 1.800 2.05700e-06 1.800 2.05705e-06 0.000 2.05800e-06 0.000 2.05805e-06 1.800 2.05900e-06 1.800
+ 2.05905e-06 0.000 2.06100e-06 0.000 2.06105e-06 1.800 2.06200e-06 1.800 2.06205e-06 0.000 2.06300e-06 0.000
+ 2.06305e-06 1.800 2.06500e-06 1.800 2.06505e-06 0.000 2.06600e-06 0.000 2.06605e-06 1.800 2.06700e-06 1.800
+ 2.06705e-06 0.000 2.06900e-06 0.000 2.06905e-06 1.800 2.07000e-06 1.800 2.07005e-06 0.000 2.07100e-06 0.000
+ 2.07105e-06 1.800 2.07200e-06 1.800 2.07205e-06 0.000 2.07400e-06 0.000 2.07405e-06 1.800 2.07500e-06 1.800
+ 2.07505e-06 0.000 2.07600e-06 0.000 2.07605e-06 1.800 2.07900e-06 1.800 2.07905e-06 0.000 2.08400e-06 0.000
+ 2.08405e-06 1.800 2.08500e-06 1.800 2.08505e-06 0.000 2.08800e-06 0.000 2.08805e-06 1.800 2.09000e-06 1.800
+ 2.09005e-06 0.000 2.09100e-06 0.000 2.09105e-06 1.800 2.09200e-06 1.800 2.09205e-06 0.000 2.09600e-06 0.000
+ 2.09605e-06 1.800 2.09700e-06 1.800 2.09705e-06 0.000 2.09800e-06 0.000 2.09805e-06 1.800 2.10000e-06 1.800
+ 2.10005e-06 0.000 2.10100e-06 0.000 2.10105e-06 1.800 2.10200e-06 1.800 2.10205e-06 0.000 2.10300e-06 0.000
+ 2.10305e-06 1.800 2.10400e-06 1.800 2.10405e-06 0.000 2.10500e-06 0.000 2.10505e-06 1.800 2.10900e-06 1.800
+ 2.10905e-06 0.000 2.11000e-06 0.000 2.11005e-06 1.800 2.11200e-06 1.800 2.11205e-06 0.000 2.11300e-06 0.000
+ 2.11305e-06 1.800 2.11500e-06 1.800 2.11505e-06 0.000 2.11600e-06 0.000 2.11605e-06 1.800 2.11700e-06 1.800
+ 2.11705e-06 0.000 2.11900e-06 0.000 2.11905e-06 1.800 2.12000e-06 1.800 2.12005e-06 0.000 2.12100e-06 0.000
+ 2.12105e-06 1.800 2.12400e-06 1.800 2.12405e-06 0.000 2.12500e-06 0.000 2.12505e-06 1.800 2.12700e-06 1.800
+ 2.12705e-06 0.000 2.12900e-06 0.000 2.12905e-06 1.800 2.13100e-06 1.800 2.13105e-06 0.000 2.13200e-06 0.000
+ 2.13205e-06 1.800 2.13300e-06 1.800 2.13305e-06 0.000 2.13400e-06 0.000 2.13405e-06 1.800 2.13500e-06 1.800
+ 2.13505e-06 0.000 2.13600e-06 0.000 2.13605e-06 1.800 2.13800e-06 1.800 2.13805e-06 0.000 2.14000e-06 0.000
+ 2.14005e-06 1.800 2.14100e-06 1.800 2.14105e-06 0.000 2.14500e-06 0.000 2.14505e-06 1.800 2.14600e-06 1.800
+ 2.14605e-06 0.000 2.14700e-06 0.000 2.14705e-06 1.800 2.15000e-06 1.800 2.15005e-06 0.000 2.15100e-06 0.000
+ 2.15105e-06 1.800 2.15300e-06 1.800 2.15305e-06 0.000 2.15400e-06 0.000 2.15405e-06 1.800 2.15800e-06 1.800
+ 2.15805e-06 0.000 2.16700e-06 0.000 2.16705e-06 1.800 2.16800e-06 1.800 2.16805e-06 0.000 2.16900e-06 0.000
+ 2.16905e-06 1.800 2.17000e-06 1.800 2.17005e-06 0.000 2.17100e-06 0.000 2.17105e-06 1.800 2.17400e-06 1.800
+ 2.17405e-06 0.000 2.17500e-06 0.000 2.17505e-06 1.800 2.17600e-06 1.800 2.17605e-06 0.000 2.17700e-06 0.000
+ 2.17705e-06 1.800 2.17800e-06 1.800 2.17805e-06 0.000 2.18500e-06 0.000 2.18505e-06 1.800 2.18900e-06 1.800
+ 2.18905e-06 0.000 2.19000e-06 0.000 2.19005e-06 1.800 2.19200e-06 1.800 2.19205e-06 0.000 2.19300e-06 0.000
+ 2.19305e-06 1.800 2.19500e-06 1.800 2.19505e-06 0.000 2.19700e-06 0.000 2.19705e-06 1.800 2.19800e-06 1.800
+ 2.19805e-06 0.000 2.20300e-06 0.000 2.20305e-06 1.800 2.20400e-06 1.800 2.20405e-06 0.000 2.20800e-06 0.000
+ 2.20805e-06 1.800 2.20900e-06 1.800 2.20905e-06 0.000 2.21000e-06 0.000 2.21005e-06 1.800 2.21100e-06 1.800
+ 2.21105e-06 0.000 2.21400e-06 0.000 2.21405e-06 1.800 2.21500e-06 1.800 2.21505e-06 0.000 2.21700e-06 0.000
+ 2.21705e-06 1.800 2.21800e-06 1.800 2.21805e-06 0.000 2.21900e-06 0.000 2.21905e-06 1.800 2.22000e-06 1.800
+ 2.22005e-06 0.000 2.22200e-06 0.000 2.22205e-06 1.800 2.22500e-06 1.800 2.22505e-06 0.000 2.22600e-06 0.000
+ 2.22605e-06 1.800 2.22900e-06 1.800 2.22905e-06 0.000 2.23000e-06 0.000 2.23005e-06 1.800 2.23500e-06 1.800
+ 2.23505e-06 0.000 2.23700e-06 0.000 2.23705e-06 1.800 2.23800e-06 1.800 2.23805e-06 0.000 2.24200e-06 0.000
+ 2.24205e-06 1.800 2.24300e-06 1.800 2.24305e-06 0.000 2.24400e-06 0.000 2.24405e-06 1.800 2.24600e-06 1.800
+ 2.24605e-06 0.000 2.24900e-06 0.000 2.24905e-06 1.800 2.25200e-06 1.800 2.25205e-06 0.000 2.25500e-06 0.000
+ 2.25505e-06 1.800 2.25600e-06 1.800 2.25605e-06 0.000 2.25700e-06 0.000 2.25705e-06 1.800 2.25800e-06 1.800
+ 2.25805e-06 0.000 2.26000e-06 0.000 2.26005e-06 1.800 2.26300e-06 1.800 2.26305e-06 0.000 2.26500e-06 0.000
+ 2.26505e-06 1.800 2.26600e-06 1.800 2.26605e-06 0.000 2.26900e-06 0.000 2.26905e-06 1.800 2.27100e-06 1.800
+ 2.27105e-06 0.000 2.27200e-06 0.000 2.27205e-06 1.800 2.27400e-06 1.800 2.27405e-06 0.000 2.27500e-06 0.000
+ 2.27505e-06 1.800 2.27600e-06 1.800 2.27605e-06 0.000 2.27800e-06 0.000 2.27805e-06 1.800 2.28200e-06 1.800
+ 2.28205e-06 0.000 2.28300e-06 0.000 2.28305e-06 1.800 2.28500e-06 1.800 2.28505e-06 0.000 2.28900e-06 0.000
+ 2.28905e-06 1.800 2.29000e-06 1.800 2.29005e-06 0.000 2.29100e-06 0.000 2.29105e-06 1.800 2.29200e-06 1.800
+ 2.29205e-06 0.000 2.29300e-06 0.000 2.29305e-06 1.800 2.29400e-06 1.800 2.29405e-06 0.000 2.29700e-06 0.000
+ 2.29705e-06 1.800 2.29900e-06 1.800 2.29905e-06 0.000 2.30000e-06 0.000 2.30005e-06 1.800 2.30100e-06 1.800
+ 2.30105e-06 0.000 2.30200e-06 0.000 2.30205e-06 1.800 2.30500e-06 1.800 2.30505e-06 0.000 2.30600e-06 0.000
+ 2.30605e-06 1.800 2.31100e-06 1.800 2.31105e-06 0.000 2.31500e-06 0.000 2.31505e-06 1.800 2.31600e-06 1.800
+ 2.31605e-06 0.000 2.31700e-06 0.000 2.31705e-06 1.800 2.31800e-06 1.800 2.31805e-06 0.000 2.31900e-06 0.000
+ 2.31905e-06 1.800 2.32000e-06 1.800 2.32005e-06 0.000 2.32100e-06 0.000 2.32105e-06 1.800 2.32200e-06 1.800
+ 2.32205e-06 0.000 2.32300e-06 0.000 2.32305e-06 1.800 2.32900e-06 1.800 2.32905e-06 0.000 2.33000e-06 0.000
+ 2.33005e-06 1.800 2.33200e-06 1.800 2.33205e-06 0.000 2.33400e-06 0.000 2.33405e-06 1.800 2.33800e-06 1.800
+ 2.33805e-06 0.000 2.33900e-06 0.000 2.33905e-06 1.800 2.34100e-06 1.800 2.34105e-06 0.000 2.34400e-06 0.000
+ 2.34405e-06 1.800 2.34700e-06 1.800 2.34705e-06 0.000 2.34800e-06 0.000 2.34805e-06 1.800 2.35000e-06 1.800
+ 2.35005e-06 0.000 2.35100e-06 0.000 2.35105e-06 1.800 2.35200e-06 1.800 2.35205e-06 0.000 2.35400e-06 0.000
+ 2.35405e-06 1.800 2.35500e-06 1.800 2.35505e-06 0.000 2.35700e-06 0.000 2.35705e-06 1.800 2.36100e-06 1.800
+ 2.36105e-06 0.000 2.36200e-06 0.000 2.36205e-06 1.800 2.36300e-06 1.800 2.36305e-06 0.000 2.36400e-06 0.000
+ 2.36405e-06 1.800 2.36500e-06 1.800 2.36505e-06 0.000 2.36600e-06 0.000 2.36605e-06 1.800 2.36800e-06 1.800
+ 2.36805e-06 0.000 2.36900e-06 0.000 2.36905e-06 1.800 2.37000e-06 1.800 2.37005e-06 0.000 2.37400e-06 0.000
+ 2.37405e-06 1.800 2.37500e-06 1.800 2.37505e-06 0.000 2.37600e-06 0.000 2.37605e-06 1.800 2.37900e-06 1.800
+ 2.37905e-06 0.000 2.38100e-06 0.000 2.38105e-06 1.800 2.38400e-06 1.800 2.38405e-06 0.000 2.38600e-06 0.000
+ 2.38605e-06 1.800 2.38900e-06 1.800 2.38905e-06 0.000 2.39100e-06 0.000 2.39105e-06 1.800 2.39400e-06 1.800
+ 2.39405e-06 0.000 2.39600e-06 0.000 2.39605e-06 1.800 2.39700e-06 1.800 2.39705e-06 0.000 2.39800e-06 0.000
+ 2.39805e-06 1.800 2.39900e-06 1.800 2.39905e-06 0.000 2.40100e-06 0.000 2.40105e-06 1.800 2.40500e-06 1.800
+ 2.40505e-06 0.000 2.40600e-06 0.000 2.40605e-06 1.800 2.40700e-06 1.800 2.40705e-06 0.000 2.40900e-06 0.000
+ 2.40905e-06 1.800 2.41000e-06 1.800 2.41005e-06 0.000 2.41100e-06 0.000 2.41105e-06 1.800 2.41300e-06 1.800
+ 2.41305e-06 0.000 2.41400e-06 0.000 2.41405e-06 1.800 2.41600e-06 1.800 2.41605e-06 0.000 2.42100e-06 0.000
+ 2.42105e-06 1.800 2.42600e-06 1.800 2.42605e-06 0.000 2.42700e-06 0.000 2.42705e-06 1.800 2.42800e-06 1.800
+ 2.42805e-06 0.000 2.42900e-06 0.000 2.42905e-06 1.800 2.43200e-06 1.800 2.43205e-06 0.000 2.43600e-06 0.000
+ 2.43605e-06 1.800 2.43800e-06 1.800 2.43805e-06 0.000 2.43900e-06 0.000 2.43905e-06 1.800 2.44200e-06 1.800
+ 2.44205e-06 0.000 2.44300e-06 0.000 2.44305e-06 1.800 2.44400e-06 1.800 2.44405e-06 0.000 2.44600e-06 0.000
+ 2.44605e-06 1.800 2.44700e-06 1.800 2.44705e-06 0.000 2.45000e-06 0.000 2.45005e-06 1.800 2.45100e-06 1.800
+ 2.45105e-06 0.000 2.45200e-06 0.000 2.45205e-06 1.800 2.45500e-06 1.800 2.45505e-06 0.000 2.45600e-06 0.000
+ 2.45605e-06 1.800 2.45700e-06 1.800 2.45705e-06 0.000 2.45800e-06 0.000 2.45805e-06 1.800 2.45900e-06 1.800
+ 2.45905e-06 0.000 2.46200e-06 0.000 2.46205e-06 1.800 2.46400e-06 1.800 2.46405e-06 0.000 2.46700e-06 0.000
+ 2.46705e-06 1.800 2.46800e-06 1.800 2.46805e-06 0.000 2.46900e-06 0.000 2.46905e-06 1.800 2.47000e-06 1.800
+ 2.47005e-06 0.000 2.47100e-06 0.000 2.47105e-06 1.800 2.47200e-06 1.800 2.47205e-06 0.000 2.47300e-06 0.000
+ 2.47305e-06 1.800 2.47800e-06 1.800 2.47805e-06 0.000 2.47900e-06 0.000 2.47905e-06 1.800 2.48100e-06 1.800
+ 2.48105e-06 0.000 2.49000e-06 0.000 2.49005e-06 1.800 2.49100e-06 1.800 2.49105e-06 0.000 2.49400e-06 0.000
+ 2.49405e-06 1.800 2.49500e-06 1.800 2.49505e-06 0.000 2.49700e-06 0.000 2.49705e-06 1.800 2.50200e-06 1.800
+ 2.50205e-06 0.000 2.50400e-06 0.000 2.50405e-06 1.800 2.50800e-06 1.800 2.50805e-06 0.000 2.51000e-06 0.000
+ 2.51005e-06 1.800 2.51100e-06 1.800 2.51105e-06 0.000 2.51200e-06 0.000 2.51205e-06 1.800 2.51500e-06 1.800
+ 2.51505e-06 0.000 2.51600e-06 0.000 2.51605e-06 1.800 2.51900e-06 1.800 2.51905e-06 0.000 2.52100e-06 0.000
+ 2.52105e-06 1.800 2.52500e-06 1.800 2.52505e-06 0.000 2.53100e-06 0.000 2.53105e-06 1.800 2.53400e-06 1.800
+ 2.53405e-06 0.000 2.53500e-06 0.000 2.53505e-06 1.800 2.53600e-06 1.800 2.53605e-06 0.000 2.53700e-06 0.000
+ 2.53705e-06 1.800 2.53800e-06 1.800 2.53805e-06 0.000 2.54100e-06 0.000 2.54105e-06 1.800 2.54200e-06 1.800
+ 2.54205e-06 0.000 2.54300e-06 0.000 2.54305e-06 1.800 2.54600e-06 1.800 2.54605e-06 0.000 2.54900e-06 0.000
+ 2.54905e-06 1.800 2.55000e-06 1.800 2.55005e-06 0.000 2.55200e-06 0.000 2.55205e-06 1.800 2.55400e-06 1.800
+ 2.55405e-06 0.000 2.55500e-06 0.000 2.55505e-06 1.800 2.55900e-06 1.800 2.55905e-06 0.000 2.56000e-06 0.000
+ 2.56005e-06 1.800 2.56400e-06 1.800 2.56405e-06 0.000 2.56500e-06 0.000 2.56505e-06 1.800 2.56600e-06 1.800
+ 2.56605e-06 0.000 2.56700e-06 0.000 2.56705e-06 1.800 2.56800e-06 1.800 2.56805e-06 0.000 2.56900e-06 0.000
+ 2.56905e-06 1.800 2.57300e-06 1.800 2.57305e-06 0.000 2.57500e-06 0.000 2.57505e-06 1.800 2.57800e-06 1.800
+ 2.57805e-06 0.000 2.57900e-06 0.000 2.57905e-06 1.800 2.58600e-06 1.800 2.58605e-06 0.000 2.58900e-06 0.000
+ 2.58905e-06 1.800 2.59300e-06 1.800 2.59305e-06 0.000 2.59600e-06 0.000 2.59605e-06 1.800 2.59700e-06 1.800
+ 2.59705e-06 0.000 2.59900e-06 0.000 2.59905e-06 1.800 2.60100e-06 1.800 2.60105e-06 0.000 2.60200e-06 0.000
+ 2.60205e-06 1.800 2.60300e-06 1.800 2.60305e-06 0.000 2.60400e-06 0.000 2.60405e-06 1.800 2.60500e-06 1.800
+ 2.60505e-06 0.000 2.60600e-06 0.000 2.60605e-06 1.800 2.60700e-06 1.800 2.60705e-06 0.000 2.60800e-06 0.000
+ 2.60805e-06 1.800 2.60900e-06 1.800 2.60905e-06 0.000 2.61100e-06 0.000 2.61105e-06 1.800 2.61200e-06 1.800
+ 2.61205e-06 0.000 2.61300e-06 0.000 2.61305e-06 1.800 2.61500e-06 1.800 2.61505e-06 0.000 2.61900e-06 0.000
+ 2.61905e-06 1.800 2.62100e-06 1.800 2.62105e-06 0.000 2.62500e-06 0.000 2.62505e-06 1.800 2.62600e-06 1.800
+ 2.62605e-06 0.000 2.62700e-06 0.000 2.62705e-06 1.800 2.62900e-06 1.800 2.62905e-06 0.000 2.63000e-06 0.000
+ 2.63005e-06 1.800 2.63100e-06 1.800 2.63105e-06 0.000 2.63200e-06 0.000 2.63205e-06 1.800 2.63400e-06 1.800
+ 2.63405e-06 0.000 2.63800e-06 0.000 2.63805e-06 1.800 2.64000e-06 1.800 2.64005e-06 0.000 2.64100e-06 0.000
+ 2.64105e-06 1.800 2.64600e-06 1.800 2.64605e-06 0.000 2.64700e-06 0.000 2.64705e-06 1.800 2.64800e-06 1.800
+ 2.64805e-06 0.000 2.64900e-06 0.000 2.64905e-06 1.800 2.65200e-06 1.800 2.65205e-06 0.000 2.65300e-06 0.000
+ 2.65305e-06 1.800 2.65400e-06 1.800 2.65405e-06 0.000 2.65500e-06 0.000 2.65505e-06 1.800 2.65800e-06 1.800
+ 2.65805e-06 0.000 2.66200e-06 0.000 2.66205e-06 1.800 2.66300e-06 1.800 2.66305e-06 0.000 2.66400e-06 0.000
+ 2.66405e-06 1.800 2.66500e-06 1.800 2.66505e-06 0.000 2.66700e-06 0.000 2.66705e-06 1.800 2.66900e-06 1.800
+ 2.66905e-06 0.000 2.67000e-06 0.000 2.67005e-06 1.800 2.67100e-06 1.800 2.67105e-06 0.000 2.67200e-06 0.000
+ 2.67205e-06 1.800 2.67400e-06 1.800 2.67405e-06 0.000 2.67600e-06 0.000 2.67605e-06 1.800 2.67700e-06 1.800
+ 2.67705e-06 0.000 2.67800e-06 0.000 2.67805e-06 1.800 2.67900e-06 1.800 2.67905e-06 0.000 2.68200e-06 0.000
+ 2.68205e-06 1.800 2.68300e-06 1.800 2.68305e-06 0.000 2.68500e-06 0.000 2.68505e-06 1.800 2.68600e-06 1.800
+ 2.68605e-06 0.000 2.68700e-06 0.000 2.68705e-06 1.800 2.68800e-06 1.800 2.68805e-06 0.000 2.68900e-06 0.000
+ 2.68905e-06 1.800 2.69000e-06 1.800 2.69005e-06 0.000 2.69300e-06 0.000 2.69305e-06 1.800 2.69800e-06 1.800
+ 2.69805e-06 0.000 2.69900e-06 0.000 2.69905e-06 1.800 2.70100e-06 1.800 2.70105e-06 0.000 2.70200e-06 0.000
+ 2.70205e-06 1.800 2.70300e-06 1.800 2.70305e-06 0.000 2.70600e-06 0.000 2.70605e-06 1.800 2.70700e-06 1.800
+ 2.70705e-06 0.000 2.70800e-06 0.000 2.70805e-06 1.800 2.70900e-06 1.800 2.70905e-06 0.000 2.71200e-06 0.000
+ 2.71205e-06 1.800 2.71500e-06 1.800 2.71505e-06 0.000 2.71600e-06 0.000 2.71605e-06 1.800 2.71700e-06 1.800
+ 2.71705e-06 0.000 2.71800e-06 0.000 2.71805e-06 1.800 2.71900e-06 1.800 2.71905e-06 0.000 2.72300e-06 0.000
+ 2.72305e-06 1.800 2.72400e-06 1.800 2.72405e-06 0.000 2.72500e-06 0.000 2.72505e-06 1.800 2.72700e-06 1.800
+ 2.72705e-06 0.000 2.72900e-06 0.000 2.72905e-06 1.800 2.73000e-06 1.800 2.73005e-06 0.000 2.73500e-06 0.000
+ 2.73505e-06 1.800 2.73600e-06 1.800 2.73605e-06 0.000 2.73700e-06 0.000 2.73705e-06 1.800 2.73800e-06 1.800
+ 2.73805e-06 0.000 2.74000e-06 0.000 2.74005e-06 1.800 2.74100e-06 1.800 2.74105e-06 0.000 2.74200e-06 0.000
+ 2.74205e-06 1.800 2.74300e-06 1.800 2.74305e-06 0.000 2.74400e-06 0.000 2.74405e-06 1.800 2.74700e-06 1.800
+ 2.74705e-06 0.000 2.74900e-06 0.000 2.74905e-06 1.800 2.75000e-06 1.800 2.75005e-06 0.000 2.75100e-06 0.000
+ 2.75105e-06 1.800 2.75300e-06 1.800 2.75305e-06 0.000 2.75400e-06 0.000 2.75405e-06 1.800 2.75600e-06 1.800
+ 2.75605e-06 0.000 2.75700e-06 0.000 2.75705e-06 1.800 2.76100e-06 1.800 2.76105e-06 0.000 2.76400e-06 0.000
+ 2.76405e-06 1.800 2.76500e-06 1.800 2.76505e-06 0.000 2.76700e-06 0.000 2.76705e-06 1.800 2.76800e-06 1.800
+ 2.76805e-06 0.000 2.76900e-06 0.000 2.76905e-06 1.800 2.77000e-06 1.800 2.77005e-06 0.000 2.77400e-06 0.000
+ 2.77405e-06 1.800 2.77500e-06 1.800 2.77505e-06 0.000 2.77700e-06 0.000 2.77705e-06 1.800 2.77800e-06 1.800
+ 2.77805e-06 0.000 2.77900e-06 0.000 2.77905e-06 1.800 2.78000e-06 1.800 2.78005e-06 0.000 2.78100e-06 0.000
+ 2.78105e-06 1.800 2.78200e-06 1.800 2.78205e-06 0.000 2.78300e-06 0.000 2.78305e-06 1.800 2.78500e-06 1.800
+ 2.78505e-06 0.000 2.78600e-06 0.000 2.78605e-06 1.800 2.78700e-06 1.800 2.78705e-06 0.000 2.79100e-06 0.000
+ 2.79105e-06 1.800 2.79200e-06 1.800 2.79205e-06 0.000 2.79500e-06 0.000 2.79505e-06 1.800 2.79700e-06 1.800
+ 2.79705e-06 0.000 2.79800e-06 0.000 2.79805e-06 1.800 2.79900e-06 1.800 2.79905e-06 0.000 2.80100e-06 0.000
+ 2.80105e-06 1.800 2.80200e-06 1.800 2.80205e-06 0.000 2.80400e-06 0.000 2.80405e-06 1.800 2.80600e-06 1.800
+ 2.80605e-06 0.000 2.80800e-06 0.000 2.80805e-06 1.800 2.80900e-06 1.800 2.80905e-06 0.000 2.81300e-06 0.000
+ 2.81305e-06 1.800 2.81500e-06 1.800 2.81505e-06 0.000 2.81600e-06 0.000 2.81605e-06 1.800 2.81800e-06 1.800
+ 2.81805e-06 0.000 2.81900e-06 0.000 2.81905e-06 1.800 2.82400e-06 1.800 2.82405e-06 0.000 2.82500e-06 0.000
+ 2.82505e-06 1.800 2.82700e-06 1.800 2.82705e-06 0.000 2.82900e-06 0.000 2.82905e-06 1.800 2.83100e-06 1.800
+ 2.83105e-06 0.000 2.83200e-06 0.000 2.83205e-06 1.800 2.83300e-06 1.800 2.83305e-06 0.000 2.83500e-06 0.000
+ 2.83505e-06 1.800 2.83600e-06 1.800 2.83605e-06 0.000 2.83800e-06 0.000 2.83805e-06 1.800 2.83900e-06 1.800
+ 2.83905e-06 0.000 2.84000e-06 0.000 2.84005e-06 1.800 2.84100e-06 1.800 2.84105e-06 0.000 2.84200e-06 0.000
+ 2.84205e-06 1.800 2.84300e-06 1.800 2.84305e-06 0.000 2.84400e-06 0.000 2.84405e-06 1.800 2.84800e-06 1.800
+ 2.84805e-06 0.000 2.85000e-06 0.000 2.85005e-06 1.800 2.85100e-06 1.800 2.85105e-06 0.000 2.85300e-06 0.000
+ 2.85305e-06 1.800 2.85400e-06 1.800 2.85405e-06 0.000 2.86600e-06 0.000 2.86605e-06 1.800 2.87200e-06 1.800
+ 2.87205e-06 0.000 2.87300e-06 0.000 2.87305e-06 1.800 2.87400e-06 1.800 2.87405e-06 0.000 2.87500e-06 0.000
+ 2.87505e-06 1.800 2.87600e-06 1.800 2.87605e-06 0.000 2.87700e-06 0.000 2.87705e-06 1.800 2.87800e-06 1.800
+ 2.87805e-06 0.000 2.87900e-06 0.000 2.87905e-06 1.800 2.88000e-06 1.800 2.88005e-06 0.000 2.88100e-06 0.000
+ 2.88105e-06 1.800 2.88200e-06 1.800 2.88205e-06 0.000 2.88300e-06 0.000 2.88305e-06 1.800 2.88600e-06 1.800
+ 2.88605e-06 0.000 2.88700e-06 0.000 2.88705e-06 1.800 2.88900e-06 1.800 2.88905e-06 0.000 2.89000e-06 0.000
+ 2.89005e-06 1.800 2.89100e-06 1.800 2.89105e-06 0.000 2.89400e-06 0.000 2.89405e-06 1.800 2.89500e-06 1.800
+ 2.89505e-06 0.000 2.90000e-06 0.000 2.90005e-06 1.800 2.90100e-06 1.800 2.90105e-06 0.000 2.90200e-06 0.000
+ 2.90205e-06 1.800 2.90300e-06 1.800 2.90305e-06 0.000 2.90400e-06 0.000 2.90405e-06 1.800 2.90500e-06 1.800
+ 2.90505e-06 0.000 2.91100e-06 0.000 2.91105e-06 1.800 2.91700e-06 1.800 2.91705e-06 0.000 2.91800e-06 0.000
+ 2.91805e-06 1.800 2.92100e-06 1.800 2.92105e-06 0.000 2.92300e-06 0.000 2.92305e-06 1.800 2.92400e-06 1.800
+ 2.92405e-06 0.000 2.92500e-06 0.000 2.92505e-06 1.800 2.92700e-06 1.800 2.92705e-06 0.000 2.92800e-06 0.000
+ 2.92805e-06 1.800 2.92900e-06 1.800 2.92905e-06 0.000 2.93000e-06 0.000 2.93005e-06 1.800 2.93100e-06 1.800
+ 2.93105e-06 0.000 2.93400e-06 0.000 2.93405e-06 1.800 2.93500e-06 1.800 2.93505e-06 0.000 2.93900e-06 0.000
+ 2.93905e-06 1.800 2.94000e-06 1.800 2.94005e-06 0.000 2.94200e-06 0.000 2.94205e-06 1.800 2.94300e-06 1.800
+ 2.94305e-06 0.000 2.94500e-06 0.000 2.94505e-06 1.800 2.94700e-06 1.800 2.94705e-06 0.000 2.94900e-06 0.000
+ 2.94905e-06 1.800 2.95000e-06 1.800 2.95005e-06 0.000 2.95100e-06 0.000 2.95105e-06 1.800 2.95200e-06 1.800
+ 2.95205e-06 0.000 2.95300e-06 0.000 2.95305e-06 1.800 2.95500e-06 1.800 2.95505e-06 0.000 2.95600e-06 0.000
+ 2.95605e-06 1.800 2.96100e-06 1.800 2.96105e-06 0.000 2.96400e-06 0.000 2.96405e-06 1.800 2.96700e-06 1.800
+ 2.96705e-06 0.000 2.96800e-06 0.000 2.96805e-06 1.800 2.96900e-06 1.800 2.96905e-06 0.000 2.97300e-06 0.000
+ 2.97305e-06 1.800 2.97600e-06 1.800 2.97605e-06 0.000 2.97700e-06 0.000 2.97705e-06 1.800 2.98100e-06 1.800
+ 2.98105e-06 0.000 2.98200e-06 0.000 2.98205e-06 1.800 2.98400e-06 1.800 2.98405e-06 0.000 2.98500e-06 0.000
+ 2.98505e-06 1.800 2.98600e-06 1.800 2.98605e-06 0.000 2.98700e-06 0.000 2.98705e-06 1.800 2.99500e-06 1.800
+ 2.99505e-06 0.000 2.99600e-06 0.000 2.99605e-06 1.800 2.99700e-06 1.800 2.99705e-06 0.000 2.99900e-06 0.000
+ 2.99905e-06 1.800 3.00200e-06 1.800 3.00205e-06 0.000 3.00300e-06 0.000 3.00305e-06 1.800 3.00500e-06 1.800
+ 3.00505e-06 0.000 3.00600e-06 0.000 3.00605e-06 1.800 3.00800e-06 1.800 3.00805e-06 0.000 3.00900e-06 0.000
+ 3.00905e-06 1.800 3.01200e-06 1.800 3.01205e-06 0.000 3.01300e-06 0.000 3.01305e-06 1.800 3.01500e-06 1.800
+ 3.01505e-06 0.000 3.01800e-06 0.000 3.01805e-06 1.800 3.02100e-06 1.800 3.02105e-06 0.000 3.02300e-06 0.000
+ 3.02305e-06 1.800 3.02500e-06 1.800 3.02505e-06 0.000 3.02700e-06 0.000 3.02705e-06 1.800 3.02900e-06 1.800
+ 3.02905e-06 0.000 3.03100e-06 0.000 3.03105e-06 1.800 3.03200e-06 1.800 3.03205e-06 0.000 3.03500e-06 0.000
+ 3.03505e-06 1.800 3.03700e-06 1.800 3.03705e-06 0.000 3.04100e-06 0.000 3.04105e-06 1.800 3.04200e-06 1.800
+ 3.04205e-06 0.000 3.04400e-06 0.000 3.04405e-06 1.800 3.04500e-06 1.800 3.04505e-06 0.000 3.04600e-06 0.000
+ 3.04605e-06 1.800 3.04700e-06 1.800 3.04705e-06 0.000 3.04900e-06 0.000 3.04905e-06 1.800 3.05000e-06 1.800
+ 3.05005e-06 0.000 3.05100e-06 0.000 3.05105e-06 1.800 3.05500e-06 1.800 3.05505e-06 0.000 3.05700e-06 0.000
+ 3.05705e-06 1.800 3.06100e-06 1.800 3.06105e-06 0.000 3.06400e-06 0.000 3.06405e-06 1.800 3.06500e-06 1.800
+ 3.06505e-06 0.000 3.06700e-06 0.000 3.06705e-06 1.800 3.07200e-06 1.800 3.07205e-06 0.000 3.07300e-06 0.000
+ 3.07305e-06 1.800 3.07500e-06 1.800 3.07505e-06 0.000 3.07700e-06 0.000 3.07705e-06 1.800 3.07900e-06 1.800
+ 3.07905e-06 0.000 3.08000e-06 0.000 3.08005e-06 1.800 3.08200e-06 1.800 3.08205e-06 0.000 3.08300e-06 0.000
+ 3.08305e-06 1.800 3.08500e-06 1.800 3.08505e-06 0.000 3.08900e-06 0.000 3.08905e-06 1.800 3.09100e-06 1.800
+ 3.09105e-06 0.000 3.09200e-06 0.000 3.09205e-06 1.800 3.09300e-06 1.800 3.09305e-06 0.000 3.09400e-06 0.000
+ 3.09405e-06 1.800 3.09600e-06 1.800 3.09605e-06 0.000 3.09700e-06 0.000 3.09705e-06 1.800 3.09900e-06 1.800
+ 3.09905e-06 0.000 3.10300e-06 0.000 3.10305e-06 1.800 3.10400e-06 1.800 3.10405e-06 0.000 3.10500e-06 0.000
+ 3.10505e-06 1.800 3.10600e-06 1.800 3.10605e-06 0.000 3.10700e-06 0.000 3.10705e-06 1.800 3.10900e-06 1.800
+ 3.10905e-06 0.000 3.11100e-06 0.000 3.11105e-06 1.800 3.11200e-06 1.800 3.11205e-06 0.000 3.11300e-06 0.000
+ 3.11305e-06 1.800 3.11500e-06 1.800 3.11505e-06 0.000 3.11600e-06 0.000 3.11605e-06 1.800 3.12100e-06 1.800
+ 3.12105e-06 0.000 3.12300e-06 0.000 3.12305e-06 1.800 3.12500e-06 1.800 3.12505e-06 0.000 3.12900e-06 0.000
+ 3.12905e-06 1.800 3.13100e-06 1.800 3.13105e-06 0.000 3.13200e-06 0.000 3.13205e-06 1.800 3.13400e-06 1.800
+ 3.13405e-06 0.000 3.13500e-06 0.000 3.13505e-06 1.800 3.13600e-06 1.800 3.13605e-06 0.000 3.14000e-06 0.000
+ 3.14005e-06 1.800 3.14200e-06 1.800 3.14205e-06 0.000 3.14600e-06 0.000 3.14605e-06 1.800 3.14900e-06 1.800
+ 3.14905e-06 0.000 3.15000e-06 0.000 3.15005e-06 1.800 3.15300e-06 1.800 3.15305e-06 0.000 3.15900e-06 0.000
+ 3.15905e-06 1.800 3.16000e-06 1.800 3.16005e-06 0.000 3.16200e-06 0.000 3.16205e-06 1.800 3.16400e-06 1.800
+ 3.16405e-06 0.000 3.16800e-06 0.000 3.16805e-06 1.800 3.17500e-06 1.800 3.17505e-06 0.000 3.17700e-06 0.000
+ 3.17705e-06 1.800 3.17900e-06 1.800 3.17905e-06 0.000 3.18000e-06 0.000 3.18005e-06 1.800 3.18300e-06 1.800
+ 3.18305e-06 0.000 3.18400e-06 0.000 3.18405e-06 1.800 3.19300e-06 1.800 3.19305e-06 0.000 3.19600e-06 0.000
+ 3.19605e-06 1.800 3.19700e-06 1.800 3.19705e-06 0.000 3.19800e-06 0.000 3.19805e-06 1.800 3.19900e-06 1.800
+ 3.19905e-06 0.000 3.20000e-06 0.000 3.20005e-06 1.800 3.20300e-06 1.800 3.20305e-06 0.000 3.20700e-06 0.000
+ 3.20705e-06 1.800 3.21000e-06 1.800 3.21005e-06 0.000 3.21400e-06 0.000 3.21405e-06 1.800 3.21500e-06 1.800
+ 3.21505e-06 0.000 3.21600e-06 0.000 3.21605e-06 1.800 3.21800e-06 1.800 3.21805e-06 0.000 3.21900e-06 0.000
+ 3.21905e-06 1.800 3.22000e-06 1.800 3.22005e-06 0.000 3.22100e-06 0.000 3.22105e-06 1.800 3.22300e-06 1.800
+ 3.22305e-06 0.000 3.22500e-06 0.000 3.22505e-06 1.800 3.22700e-06 1.800 3.22705e-06 0.000 3.23100e-06 0.000
+ 3.23105e-06 1.800 3.23200e-06 1.800 3.23205e-06 0.000 3.23300e-06 0.000 3.23305e-06 1.800 3.23400e-06 1.800
+ 3.23405e-06 0.000 3.23500e-06 0.000 3.23505e-06 1.800 3.23600e-06 1.800 3.23605e-06 0.000 3.23700e-06 0.000
+ 3.23705e-06 1.800 3.24100e-06 1.800 3.24105e-06 0.000 3.24700e-06 0.000 3.24705e-06 1.800 3.24900e-06 1.800
+ 3.24905e-06 0.000 3.25000e-06 0.000 3.25005e-06 1.800 3.25100e-06 1.800 3.25105e-06 0.000 3.25200e-06 0.000
+ 3.25205e-06 1.800 3.25300e-06 1.800 3.25305e-06 0.000 3.25400e-06 0.000 3.25405e-06 1.800 3.25500e-06 1.800
+ 3.25505e-06 0.000 3.25600e-06 0.000 3.25605e-06 1.800 3.25700e-06 1.800 3.25705e-06 0.000 3.25800e-06 0.000
+ 3.25805e-06 1.800 3.25900e-06 1.800 3.25905e-06 0.000 3.26200e-06 0.000 3.26205e-06 1.800 3.26300e-06 1.800
+ 3.26305e-06 0.000 3.26600e-06 0.000 3.26605e-06 1.800 3.26700e-06 1.800 3.26705e-06 0.000 3.26800e-06 0.000
+ 3.26805e-06 1.800 3.27000e-06 1.800 3.27005e-06 0.000 3.27200e-06 0.000 3.27205e-06 1.800 3.27500e-06 1.800
+ 3.27505e-06 0.000 3.27700e-06 0.000 3.27705e-06 1.800 3.27800e-06 1.800 3.27805e-06 0.000 3.28100e-06 0.000
+ 3.28105e-06 1.800 3.28300e-06 1.800 3.28305e-06 0.000 3.28400e-06 0.000 3.28405e-06 1.800 3.28700e-06 1.800
+ 3.28705e-06 0.000 3.28800e-06 0.000 3.28805e-06 1.800 3.28900e-06 1.800 3.28905e-06 0.000 3.29200e-06 0.000
+ 3.29205e-06 1.800 3.29300e-06 1.800 3.29305e-06 0.000 3.29400e-06 0.000 3.29405e-06 1.800 3.29500e-06 1.800
+ 3.29505e-06 0.000 3.29600e-06 0.000 3.29605e-06 1.800 3.29700e-06 1.800 3.29705e-06 0.000 3.29800e-06 0.000
+ 3.29805e-06 1.800 3.29900e-06 1.800 3.29905e-06 0.000 3.30200e-06 0.000 3.30205e-06 1.800 3.30300e-06 1.800
+ 3.30305e-06 0.000 3.30500e-06 0.000 3.30505e-06 1.800 3.30700e-06 1.800 3.30705e-06 0.000 3.31200e-06 0.000
+ 3.31205e-06 1.800 3.31400e-06 1.800 3.31405e-06 0.000 3.31500e-06 0.000 3.31505e-06 1.800 3.31600e-06 1.800
+ 3.31605e-06 0.000 3.31700e-06 0.000 3.31705e-06 1.800 3.31900e-06 1.800 3.31905e-06 0.000 3.32000e-06 0.000
+ 3.32005e-06 1.800 3.32200e-06 1.800 3.32205e-06 0.000 3.32400e-06 0.000 3.32405e-06 1.800 3.32500e-06 1.800
+ 3.32505e-06 0.000 3.32600e-06 0.000 3.32605e-06 1.800 3.33000e-06 1.800 3.33005e-06 0.000 3.33200e-06 0.000
+ 3.33205e-06 1.800 3.33300e-06 1.800 3.33305e-06 0.000 3.33600e-06 0.000 3.33605e-06 1.800 3.33700e-06 1.800
+ 3.33705e-06 0.000 3.33900e-06 0.000 3.33905e-06 1.800 3.34300e-06 1.800 3.34305e-06 0.000 3.34600e-06 0.000
+ 3.34605e-06 1.800 3.34800e-06 1.800 3.34805e-06 0.000 3.35000e-06 0.000 3.35005e-06 1.800 3.35100e-06 1.800
+ 3.35105e-06 0.000 3.35300e-06 0.000 3.35305e-06 1.800 3.35400e-06 1.800 3.35405e-06 0.000 3.36000e-06 0.000
+ 3.36005e-06 1.800 3.36100e-06 1.800 3.36105e-06 0.000 3.36200e-06 0.000 3.36205e-06 1.800 3.36300e-06 1.800
+ 3.36305e-06 0.000 3.36500e-06 0.000 3.36505e-06 1.800 3.37000e-06 1.800 3.37005e-06 0.000 3.37100e-06 0.000
+ 3.37105e-06 1.800 3.37200e-06 1.800 3.37205e-06 0.000 3.37300e-06 0.000 3.37305e-06 1.800 3.37400e-06 1.800
+ 3.37405e-06 0.000 3.37500e-06 0.000 3.37505e-06 1.800 3.37800e-06 1.800 3.37805e-06 0.000 3.38800e-06 0.000
+ 3.38805e-06 1.800 3.38900e-06 1.800 3.38905e-06 0.000 3.39300e-06 0.000 3.39305e-06 1.800 3.39500e-06 1.800
+ 3.39505e-06 0.000 3.39900e-06 0.000 3.39905e-06 1.800 3.40400e-06 1.800 3.40405e-06 0.000 3.40500e-06 0.000
+ 3.40505e-06 1.800 3.40700e-06 1.800 3.40705e-06 0.000 3.40800e-06 0.000 3.40805e-06 1.800 3.40900e-06 1.800
+ 3.40905e-06 0.000 3.41200e-06 0.000 3.41205e-06 1.800 3.41300e-06 1.800 3.41305e-06 0.000 3.41600e-06 0.000
+ 3.41605e-06 1.800 3.41800e-06 1.800 3.41805e-06 0.000 3.42000e-06 0.000 3.42005e-06 1.800 3.42100e-06 1.800
+ 3.42105e-06 0.000 3.42500e-06 0.000 3.42505e-06 1.800 3.42600e-06 1.800 3.42605e-06 0.000 3.43200e-06 0.000
+ 3.43205e-06 1.800 3.43400e-06 1.800 3.43405e-06 0.000 3.43700e-06 0.000 3.43705e-06 1.800 3.43800e-06 1.800
+ 3.43805e-06 0.000 3.44000e-06 0.000 3.44005e-06 1.800 3.44400e-06 1.800 3.44405e-06 0.000 3.44500e-06 0.000
+ 3.44505e-06 1.800 3.44900e-06 1.800 3.44905e-06 0.000 3.45000e-06 0.000 3.45005e-06 1.800 3.45400e-06 1.800
+ 3.45405e-06 0.000 3.45700e-06 0.000 3.45705e-06 1.800 3.45900e-06 1.800 3.45905e-06 0.000 3.46000e-06 0.000
+ 3.46005e-06 1.800 3.46100e-06 1.800 3.46105e-06 0.000 3.46300e-06 0.000 3.46305e-06 1.800 3.46400e-06 1.800
+ 3.46405e-06 0.000 3.46500e-06 0.000 3.46505e-06 1.800 3.46600e-06 1.800 3.46605e-06 0.000 3.47000e-06 0.000
+ 3.47005e-06 1.800 3.47300e-06 1.800 3.47305e-06 0.000 3.47400e-06 0.000 3.47405e-06 1.800 3.47500e-06 1.800
+ 3.47505e-06 0.000 3.47900e-06 0.000 3.47905e-06 1.800 3.48600e-06 1.800 3.48605e-06 0.000 3.48900e-06 0.000
+ 3.48905e-06 1.800 3.49400e-06 1.800 3.49405e-06 0.000 3.49600e-06 0.000 3.49605e-06 1.800 3.49700e-06 1.800
+ 3.49705e-06 0.000 3.50000e-06 0.000 3.50005e-06 1.800 3.50800e-06 1.800 3.50805e-06 0.000 3.51200e-06 0.000
+ 3.51205e-06 1.800 3.51300e-06 1.800 3.51305e-06 0.000 3.51400e-06 0.000 3.51405e-06 1.800 3.51500e-06 1.800
+ 3.51505e-06 0.000 3.51600e-06 0.000 3.51605e-06 1.800 3.51700e-06 1.800 3.51705e-06 0.000 3.51800e-06 0.000
+ 3.51805e-06 1.800 3.52000e-06 1.800 3.52005e-06 0.000 3.52100e-06 0.000 3.52105e-06 1.800 3.52200e-06 1.800
+ 3.52205e-06 0.000 3.52300e-06 0.000 3.52305e-06 1.800 3.52400e-06 1.800 3.52405e-06 0.000 3.52600e-06 0.000
+ 3.52605e-06 1.800 3.52700e-06 1.800 3.52705e-06 0.000 3.52900e-06 0.000 3.52905e-06 1.800 3.53200e-06 1.800
+ 3.53205e-06 0.000 3.53400e-06 0.000 3.53405e-06 1.800 3.53500e-06 1.800 3.53505e-06 0.000 3.53700e-06 0.000
+ 3.53705e-06 1.800 3.53900e-06 1.800 3.53905e-06 0.000 3.54100e-06 0.000 3.54105e-06 1.800 3.54200e-06 1.800
+ 3.54205e-06 0.000 3.54500e-06 0.000 3.54505e-06 1.800 3.54700e-06 1.800 3.54705e-06 0.000 3.54900e-06 0.000
+ 3.54905e-06 1.800 3.55000e-06 1.800 3.55005e-06 0.000 3.55100e-06 0.000 3.55105e-06 1.800 3.55800e-06 1.800
+ 3.55805e-06 0.000 3.55900e-06 0.000 3.55905e-06 1.800 3.56000e-06 1.800 3.56005e-06 0.000 3.56100e-06 0.000
+ 3.56105e-06 1.800 3.56600e-06 1.800 3.56605e-06 0.000 3.57000e-06 0.000 3.57005e-06 1.800 3.57100e-06 1.800
+ 3.57105e-06 0.000 3.57500e-06 0.000 3.57505e-06 1.800 3.57900e-06 1.800 3.57905e-06 0.000 3.58100e-06 0.000
+ 3.58105e-06 1.800 3.58200e-06 1.800 3.58205e-06 0.000 3.58400e-06 0.000 3.58405e-06 1.800 3.58600e-06 1.800
+ 3.58605e-06 0.000 3.58700e-06 0.000 3.58705e-06 1.800 3.58800e-06 1.800 3.58805e-06 0.000 3.59100e-06 0.000
+ 3.59105e-06 1.800 3.59400e-06 1.800 3.59405e-06 0.000 3.59800e-06 0.000 3.59805e-06 1.800 3.60000e-06 1.800
+ 3.60005e-06 0.000 3.60600e-06 0.000 3.60605e-06 1.800 3.60700e-06 1.800 3.60705e-06 0.000 3.60900e-06 0.000
+ 3.60905e-06 1.800 3.61100e-06 1.800 3.61105e-06 0.000 3.61400e-06 0.000 3.61405e-06 1.800 3.62000e-06 1.800
+ 3.62005e-06 0.000 3.62300e-06 0.000 3.62305e-06 1.800 3.62500e-06 1.800 3.62505e-06 0.000 3.62600e-06 0.000
+ 3.62605e-06 1.800 3.63100e-06 1.800 3.63105e-06 0.000 3.63200e-06 0.000 3.63205e-06 1.800 3.63300e-06 1.800
+ 3.63305e-06 0.000 3.63400e-06 0.000 3.63405e-06 1.800 3.63600e-06 1.800 3.63605e-06 0.000 3.63800e-06 0.000
+ 3.63805e-06 1.800 3.64000e-06 1.800 3.64005e-06 0.000 3.64200e-06 0.000 3.64205e-06 1.800 3.64400e-06 1.800
+ 3.64405e-06 0.000 3.64600e-06 0.000 3.64605e-06 1.800 3.64700e-06 1.800 3.64705e-06 0.000 3.65400e-06 0.000
+ 3.65405e-06 1.800 3.65500e-06 1.800 3.65505e-06 0.000 3.65700e-06 0.000 3.65705e-06 1.800 3.66000e-06 1.800
+ 3.66005e-06 0.000 3.66300e-06 0.000 3.66305e-06 1.800 3.66400e-06 1.800 3.66405e-06 0.000 3.66500e-06 0.000
+ 3.66505e-06 1.800 3.66800e-06 1.800 3.66805e-06 0.000 3.66900e-06 0.000 3.66905e-06 1.800 3.67100e-06 1.800
+ 3.67105e-06 0.000 3.67200e-06 0.000 3.67205e-06 1.800 3.67600e-06 1.800 3.67605e-06 0.000 3.67700e-06 0.000
+ 3.67705e-06 1.800 3.67800e-06 1.800 3.67805e-06 0.000 3.68100e-06 0.000 3.68105e-06 1.800 3.68400e-06 1.800
+ 3.68405e-06 0.000 3.68500e-06 0.000 3.68505e-06 1.800 3.68600e-06 1.800 3.68605e-06 0.000 3.68700e-06 0.000
+ 3.68705e-06 1.800 3.68800e-06 1.800 3.68805e-06 0.000 3.69000e-06 0.000 3.69005e-06 1.800 3.69200e-06 1.800
+ 3.69205e-06 0.000 3.69300e-06 0.000 3.69305e-06 1.800 3.69600e-06 1.800 3.69605e-06 0.000 3.70000e-06 0.000
+ 3.70005e-06 1.800 3.70100e-06 1.800 3.70105e-06 0.000 3.70200e-06 0.000 3.70205e-06 1.800 3.70300e-06 1.800
+ 3.70305e-06 0.000 3.70500e-06 0.000 3.70505e-06 1.800 3.71000e-06 1.800 3.71005e-06 0.000 3.71100e-06 0.000
+ 3.71105e-06 1.800 3.71200e-06 1.800 3.71205e-06 0.000 3.71300e-06 0.000 3.71305e-06 1.800 3.71400e-06 1.800
+ 3.71405e-06 0.000 3.71600e-06 0.000 3.71605e-06 1.800 3.71800e-06 1.800 3.71805e-06 0.000 3.71900e-06 0.000
+ 3.71905e-06 1.800 3.72200e-06 1.800 3.72205e-06 0.000 3.72800e-06 0.000 3.72805e-06 1.800 3.72900e-06 1.800
+ 3.72905e-06 0.000 3.73100e-06 0.000 3.73105e-06 1.800 3.73200e-06 1.800 3.73205e-06 0.000 3.73400e-06 0.000
+ 3.73405e-06 1.800 3.73700e-06 1.800 3.73705e-06 0.000 3.73900e-06 0.000 3.73905e-06 1.800 3.74000e-06 1.800
+ 3.74005e-06 0.000 3.74300e-06 0.000 3.74305e-06 1.800 3.74500e-06 1.800 3.74505e-06 0.000 3.74600e-06 0.000
+ 3.74605e-06 1.800 3.75200e-06 1.800 3.75205e-06 0.000 3.75800e-06 0.000 3.75805e-06 1.800 3.75900e-06 1.800
+ 3.75905e-06 0.000 3.76000e-06 0.000 3.76005e-06 1.800 3.76100e-06 1.800 3.76105e-06 0.000 3.76300e-06 0.000
+ 3.76305e-06 1.800 3.76400e-06 1.800 3.76405e-06 0.000 3.76600e-06 0.000 3.76605e-06 1.800 3.77200e-06 1.800
+ 3.77205e-06 0.000 3.77300e-06 0.000 3.77305e-06 1.800 3.77500e-06 1.800 3.77505e-06 0.000 3.77700e-06 0.000
+ 3.77705e-06 1.800 3.77800e-06 1.800 3.77805e-06 0.000 3.78000e-06 0.000 3.78005e-06 1.800 3.78400e-06 1.800
+ 3.78405e-06 0.000 3.78800e-06 0.000 3.78805e-06 1.800 3.79000e-06 1.800 3.79005e-06 0.000 3.79100e-06 0.000
+ 3.79105e-06 1.800 3.79300e-06 1.800 3.79305e-06 0.000 3.80000e-06 0.000 3.80005e-06 1.800 3.80100e-06 1.800
+ 3.80105e-06 0.000 3.80300e-06 0.000 3.80305e-06 1.800 3.80500e-06 1.800 3.80505e-06 0.000 3.80700e-06 0.000
+ 3.80705e-06 1.800 3.81000e-06 1.800 3.81005e-06 0.000 3.81200e-06 0.000 3.81205e-06 1.800 3.81300e-06 1.800
+ 3.81305e-06 0.000 3.81400e-06 0.000 3.81405e-06 1.800 3.81500e-06 1.800 3.81505e-06 0.000 3.81600e-06 0.000
+ 3.81605e-06 1.800 3.82000e-06 1.800 3.82005e-06 0.000 3.82200e-06 0.000 3.82205e-06 1.800 3.82300e-06 1.800
+ 3.82305e-06 0.000 3.82500e-06 0.000 3.82505e-06 1.800 3.82700e-06 1.800 3.82705e-06 0.000 3.82900e-06 0.000
+ 3.82905e-06 1.800 3.83100e-06 1.800 3.83105e-06 0.000 3.83200e-06 0.000 3.83205e-06 1.800 3.83400e-06 1.800
+ 3.83405e-06 0.000 3.83500e-06 0.000 3.83505e-06 1.800 3.83600e-06 1.800 3.83605e-06 0.000 3.84000e-06 0.000
+ 3.84005e-06 1.800 3.84900e-06 1.800 3.84905e-06 0.000 3.85000e-06 0.000 3.85005e-06 1.800 3.85100e-06 1.800
+ 3.85105e-06 0.000 3.85300e-06 0.000 3.85305e-06 1.800 3.85400e-06 1.800 3.85405e-06 0.000 3.85800e-06 0.000
+ 3.85805e-06 1.800 3.85900e-06 1.800 3.85905e-06 0.000 3.86100e-06 0.000 3.86105e-06 1.800 3.86200e-06 1.800
+ 3.86205e-06 0.000 3.86300e-06 0.000 3.86305e-06 1.800 3.86600e-06 1.800 3.86605e-06 0.000 3.86700e-06 0.000
+ 3.86705e-06 1.800 3.86800e-06 1.800 3.86805e-06 0.000 3.86900e-06 0.000 3.86905e-06 1.800 3.87000e-06 1.800
+ 3.87005e-06 0.000 3.87100e-06 0.000 3.87105e-06 1.800 3.87300e-06 1.800 3.87305e-06 0.000 3.87600e-06 0.000
+ 3.87605e-06 1.800 3.87800e-06 1.800 3.87805e-06 0.000 3.87900e-06 0.000 3.87905e-06 1.800 3.88000e-06 1.800
+ 3.88005e-06 0.000 3.88100e-06 0.000 3.88105e-06 1.800 3.88200e-06 1.800 3.88205e-06 0.000 3.88400e-06 0.000
+ 3.88405e-06 1.800 3.89200e-06 1.800 3.89205e-06 0.000 3.89300e-06 0.000 3.89305e-06 1.800 3.89400e-06 1.800
+ 3.89405e-06 0.000 3.89500e-06 0.000 3.89505e-06 1.800 3.89600e-06 1.800 3.89605e-06 0.000 3.89800e-06 0.000
+ 3.89805e-06 1.800 3.89900e-06 1.800 3.89905e-06 0.000 3.90300e-06 0.000 3.90305e-06 1.800 3.90400e-06 1.800
+ 3.90405e-06 0.000 3.90600e-06 0.000 3.90605e-06 1.800 3.90900e-06 1.800 3.90905e-06 0.000 3.91000e-06 0.000
+ 3.91005e-06 1.800 3.91300e-06 1.800 3.91305e-06 0.000 3.91500e-06 0.000 3.91505e-06 1.800 3.91800e-06 1.800
+ 3.91805e-06 0.000 3.91900e-06 0.000 3.91905e-06 1.800 3.92000e-06 1.800 3.92005e-06 0.000 3.92400e-06 0.000
+ 3.92405e-06 1.800 3.92600e-06 1.800 3.92605e-06 0.000 3.92800e-06 0.000 3.92805e-06 1.800 3.92900e-06 1.800
+ 3.92905e-06 0.000 3.93200e-06 0.000 3.93205e-06 1.800 3.93500e-06 1.800 3.93505e-06 0.000 3.93600e-06 0.000
+ 3.93605e-06 1.800 3.93900e-06 1.800 3.93905e-06 0.000 3.94000e-06 0.000 3.94005e-06 1.800 3.94200e-06 1.800
+ 3.94205e-06 0.000 3.94300e-06 0.000 3.94305e-06 1.800 3.94500e-06 1.800 3.94505e-06 0.000 3.94600e-06 0.000
+ 3.94605e-06 1.800 3.94700e-06 1.800 3.94705e-06 0.000 3.94800e-06 0.000 3.94805e-06 1.800 3.95100e-06 1.800
+ 3.95105e-06 0.000 3.95300e-06 0.000 3.95305e-06 1.800 3.95400e-06 1.800 3.95405e-06 0.000 3.95700e-06 0.000
+ 3.95705e-06 1.800 3.96400e-06 1.800 3.96405e-06 0.000 3.96500e-06 0.000 3.96505e-06 1.800 3.96600e-06 1.800
+ 3.96605e-06 0.000 3.96900e-06 0.000 3.96905e-06 1.800 3.97000e-06 1.800 3.97005e-06 0.000 3.97400e-06 0.000
+ 3.97405e-06 1.800 3.97500e-06 1.800 3.97505e-06 0.000 3.97900e-06 0.000 3.97905e-06 1.800 3.98000e-06 1.800
+ 3.98005e-06 0.000 3.98100e-06 0.000 3.98105e-06 1.800 3.98200e-06 1.800 3.98205e-06 0.000 3.98700e-06 0.000
+ 3.98705e-06 1.800 3.98800e-06 1.800 3.98805e-06 0.000 3.98900e-06 0.000 3.98905e-06 1.800 3.99000e-06 1.800
+ 3.99005e-06 0.000 3.99100e-06 0.000 3.99105e-06 1.800 3.99300e-06 1.800 3.99305e-06 0.000 3.99400e-06 0.000
+ 3.99405e-06 1.800 3.99500e-06 1.800 3.99505e-06 0.000 3.99900e-06 0.000 3.99905e-06 1.800 4.00200e-06 1.800
+ 4.00205e-06 0.000 4.00700e-06 0.000 4.00705e-06 1.800 4.00800e-06 1.800 4.00805e-06 0.000 4.00900e-06 0.000
+ 4.00905e-06 1.800 4.01000e-06 1.800 4.01005e-06 0.000 4.01500e-06 0.000 4.01505e-06 1.800 4.01900e-06 1.800
+ 4.01905e-06 0.000 4.02000e-06 0.000 4.02005e-06 1.800 4.02100e-06 1.800 4.02105e-06 0.000 4.02200e-06 0.000
+ 4.02205e-06 1.800 4.02300e-06 1.800 4.02305e-06 0.000 4.02400e-06 0.000 4.02405e-06 1.800 4.02600e-06 1.800
+ 4.02605e-06 0.000 4.02800e-06 0.000 4.02805e-06 1.800 4.02900e-06 1.800 4.02905e-06 0.000 4.03000e-06 0.000
+ 4.03005e-06 1.800 4.03400e-06 1.800 4.03405e-06 0.000 4.03600e-06 0.000 4.03605e-06 1.800 4.03700e-06 1.800
+ 4.03705e-06 0.000 4.03900e-06 0.000 4.03905e-06 1.800 4.04000e-06 1.800 4.04005e-06 0.000 4.04100e-06 0.000
+ 4.04105e-06 1.800 4.04300e-06 1.800 4.04305e-06 0.000 4.04400e-06 0.000 4.04405e-06 1.800 4.04700e-06 1.800
+ 4.04705e-06 0.000 4.04900e-06 0.000 4.04905e-06 1.800 4.05100e-06 1.800 4.05105e-06 0.000 4.05200e-06 0.000
+ 4.05205e-06 1.800 4.05600e-06 1.800 4.05605e-06 0.000 4.05700e-06 0.000 4.05705e-06 1.800 4.06000e-06 1.800
+ 4.06005e-06 0.000 4.06200e-06 0.000 4.06205e-06 1.800 4.06500e-06 1.800 4.06505e-06 0.000 4.06700e-06 0.000
+ 4.06705e-06 1.800 4.06800e-06 1.800 4.06805e-06 0.000 4.06900e-06 0.000 4.06905e-06 1.800 4.07000e-06 1.800
+ 4.07005e-06 0.000 4.07200e-06 0.000 4.07205e-06 1.800 4.07500e-06 1.800 4.07505e-06 0.000 4.07700e-06 0.000
+ 4.07705e-06 1.800 4.07800e-06 1.800 4.07805e-06 0.000 4.07900e-06 0.000 4.07905e-06 1.800 4.08000e-06 1.800
+ 4.08005e-06 0.000 4.08300e-06 0.000 4.08305e-06 1.800 4.08400e-06 1.800 4.08405e-06 0.000 4.08500e-06 0.000
+ 4.08505e-06 1.800 4.08800e-06 1.800 4.08805e-06 0.000 4.08900e-06 0.000 4.08905e-06 1.800 4.09000e-06 1.800
+ 4.09005e-06 0.000 4.09100e-06 0.000 4.09105e-06 1.800 4.09200e-06 1.800 4.09205e-06 0.000 4.09500e-06 0.000
+ 4.09505e-06 1.800 4.09600e-06 1.800
+ )
Xd_b3 src_b3 b3 vdd gnd tb_inv
Xl_c1 c1 lo_c1 vdd gnd tb_inv
Xl_c2 c2 lo_c2 vdd gnd tb_inv
Xl_c3 c3 lo_c3 vdd gnd tb_inv
Xl_c4 c4 lo_c4 vdd gnd tb_inv
X0 g0b t0b g1b t1b g2b t2b c0 a2 b2 a3 b3 c1 c2 c3 c4 vdd gnd carry_r_x1
.tran 200p 4.09600e-06
.control
set wr_singlescale
set wr_vecnames
run
set curplottitle=Bhargav-2025102061-1.3-carry_r_x1-function
wrdata wave.txt v(g0b) v(t0b) v(g1b) v(t1b) v(g2b) v(t2b) v(c0) v(a2) v(b2) v(a3) v(b3) v(c1) v(c2) v(c3) v(c4) i(VDD)
quit
.endc
.end
