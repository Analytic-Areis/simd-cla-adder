* DC supply current of c4b_mirror_x1
.include ../../../../spice/models/TSMC_180nm.txt
VDD vdd gnd 1.8
* c4b_mirror_x1: C4-bar mirror gate, stack 3
* GENERATED from part1/cells/library.py. Do not edit by hand.
.subckt c4b_mirror_x1 a3 b3 a2 b2 c2 c4b vdd gnd
Mp1 xp1 b3 vdd vdd CMOSP W=3.6000e-06 L=1.8000e-07 AS=1.9440e-12 PS=8.2800e-06 AD=9.7200e-13 PD=7.7400e-06
Mp2 c4b a3 xp1 vdd CMOSP W=3.6000e-06 L=1.8000e-07 AS=9.7200e-13 PS=7.7400e-06 AD=1.9440e-12 PD=8.2800e-06
Mp3 xp2 a3 vdd vdd CMOSP W=5.4000e-06 L=1.8000e-07 AS=2.9160e-12 PS=1.1880e-05 AD=2.9160e-12 PD=1.1880e-05
Mp4 xp2 b3 vdd vdd CMOSP W=5.4000e-06 L=1.8000e-07 AS=2.9160e-12 PS=1.1880e-05 AD=2.9160e-12 PD=1.1880e-05
Mp5 xp3 b2 xp2 vdd CMOSP W=5.4000e-06 L=1.8000e-07 AS=2.9160e-12 PS=1.1880e-05 AD=1.4580e-12 PD=1.1340e-05
Mp6 c4b a2 xp3 vdd CMOSP W=5.4000e-06 L=1.8000e-07 AS=1.4580e-12 PS=1.1340e-05 AD=2.9160e-12 PD=1.1880e-05
Mp7 xp4 a2 xp2 vdd CMOSP W=5.4000e-06 L=1.8000e-07 AS=2.9160e-12 PS=1.1880e-05 AD=2.9160e-12 PD=1.1880e-05
Mp8 xp4 b2 xp2 vdd CMOSP W=5.4000e-06 L=1.8000e-07 AS=2.9160e-12 PS=1.1880e-05 AD=2.9160e-12 PD=1.1880e-05
Mp9 c4b c2 xp4 vdd CMOSP W=5.4000e-06 L=1.8000e-07 AS=2.9160e-12 PS=1.1880e-05 AD=2.9160e-12 PD=1.1880e-05
Mn1 c4b a3 xn1 gnd CMOSN W=1.8000e-06 L=1.8000e-07 AS=4.8600e-13 PS=4.1400e-06 AD=9.7200e-13 PD=4.6800e-06
Mn2 xn1 b3 gnd gnd CMOSN W=1.8000e-06 L=1.8000e-07 AS=9.7200e-13 PS=4.6800e-06 AD=4.8600e-13 PD=4.1400e-06
Mn3 c4b a2 xn3 gnd CMOSN W=2.7000e-06 L=1.8000e-07 AS=7.2900e-13 PS=5.9400e-06 AD=1.4580e-12 PD=6.4800e-06
Mn4 xn3 b2 xn2 gnd CMOSN W=2.7000e-06 L=1.8000e-07 AS=1.4580e-12 PS=6.4800e-06 AD=7.2900e-13 PD=5.9400e-06
Mn5 c4b c2 xn4 gnd CMOSN W=2.7000e-06 L=1.8000e-07 AS=1.4580e-12 PS=6.4800e-06 AD=1.4580e-12 PD=6.4800e-06
Mn6 xn4 a2 xn2 gnd CMOSN W=2.7000e-06 L=1.8000e-07 AS=1.4580e-12 PS=6.4800e-06 AD=1.4580e-12 PD=6.4800e-06
Mn7 xn4 b2 xn2 gnd CMOSN W=2.7000e-06 L=1.8000e-07 AS=1.4580e-12 PS=6.4800e-06 AD=1.4580e-12 PD=6.4800e-06
Mn8 xn2 a3 gnd gnd CMOSN W=2.7000e-06 L=1.8000e-07 AS=1.4580e-12 PS=6.4800e-06 AD=1.4580e-12 PD=6.4800e-06
Mn9 xn2 b3 gnd gnd CMOSN W=2.7000e-06 L=1.8000e-07 AS=1.4580e-12 PS=6.4800e-06 AD=1.4580e-12 PD=6.4800e-06
.ends c4b_mirror_x1
.subckt tb_inv a y vdd gnd
mp y a vdd vdd CMOSP W=1.8e-06 L=1.8e-07 AS=9.72e-13 PS=4.68e-06 AD=9.72e-13 PD=4.68e-06
mn y a gnd gnd CMOSN W=9.0e-07 L=1.8e-07 AS=4.86e-13 PS=2.88e-06 AD=4.86e-13 PD=2.88e-06
.ends
Va3 src_a3 gnd 1.8
Xd_a3 src_a3 a3 vdd gnd tb_inv
Vb3 src_b3 gnd 1.8
Xd_b3 src_b3 b3 vdd gnd tb_inv
Va2 src_a2 gnd 1.8
Xd_a2 src_a2 a2 vdd gnd tb_inv
Vb2 src_b2 gnd 1.8
Xd_b2 src_b2 b2 vdd gnd tb_inv
Vc2 src_c2 gnd 1.8
Xd_c2 src_c2 c2 vdd gnd tb_inv
Xl_c4b c4b lo_c4b vdd gnd tb_inv
X0 a3 b3 a2 b2 c2 c4b vdd gnd c4b_mirror_x1
.control
alter Va3 = 1.8
alter Vb3 = 1.8
alter Va2 = 1.8
alter Vb2 = 1.8
alter Vc2 = 1.8
op
print i(VDD) >> dc_current.txt
alter Va3 = 1.8
alter Vb3 = 1.8
alter Va2 = 1.8
alter Vb2 = 1.8
alter Vc2 = 0.0
op
print i(VDD) >> dc_current.txt
alter Va3 = 1.8
alter Vb3 = 1.8
alter Va2 = 1.8
alter Vb2 = 0.0
alter Vc2 = 1.8
op
print i(VDD) >> dc_current.txt
alter Va3 = 1.8
alter Vb3 = 1.8
alter Va2 = 1.8
alter Vb2 = 0.0
alter Vc2 = 0.0
op
print i(VDD) >> dc_current.txt
alter Va3 = 1.8
alter Vb3 = 1.8
alter Va2 = 0.0
alter Vb2 = 1.8
alter Vc2 = 1.8
op
print i(VDD) >> dc_current.txt
alter Va3 = 1.8
alter Vb3 = 1.8
alter Va2 = 0.0
alter Vb2 = 1.8
alter Vc2 = 0.0
op
print i(VDD) >> dc_current.txt
alter Va3 = 1.8
alter Vb3 = 1.8
alter Va2 = 0.0
alter Vb2 = 0.0
alter Vc2 = 1.8
op
print i(VDD) >> dc_current.txt
alter Va3 = 1.8
alter Vb3 = 1.8
alter Va2 = 0.0
alter Vb2 = 0.0
alter Vc2 = 0.0
op
print i(VDD) >> dc_current.txt
alter Va3 = 1.8
alter Vb3 = 0.0
alter Va2 = 1.8
alter Vb2 = 1.8
alter Vc2 = 1.8
op
print i(VDD) >> dc_current.txt
alter Va3 = 1.8
alter Vb3 = 0.0
alter Va2 = 1.8
alter Vb2 = 1.8
alter Vc2 = 0.0
op
print i(VDD) >> dc_current.txt
alter Va3 = 1.8
alter Vb3 = 0.0
alter Va2 = 1.8
alter Vb2 = 0.0
alter Vc2 = 1.8
op
print i(VDD) >> dc_current.txt
alter Va3 = 1.8
alter Vb3 = 0.0
alter Va2 = 1.8
alter Vb2 = 0.0
alter Vc2 = 0.0
op
print i(VDD) >> dc_current.txt
alter Va3 = 1.8
alter Vb3 = 0.0
alter Va2 = 0.0
alter Vb2 = 1.8
alter Vc2 = 1.8
op
print i(VDD) >> dc_current.txt
alter Va3 = 1.8
alter Vb3 = 0.0
alter Va2 = 0.0
alter Vb2 = 1.8
alter Vc2 = 0.0
op
print i(VDD) >> dc_current.txt
alter Va3 = 1.8
alter Vb3 = 0.0
alter Va2 = 0.0
alter Vb2 = 0.0
alter Vc2 = 1.8
op
print i(VDD) >> dc_current.txt
alter Va3 = 1.8
alter Vb3 = 0.0
alter Va2 = 0.0
alter Vb2 = 0.0
alter Vc2 = 0.0
op
print i(VDD) >> dc_current.txt
alter Va3 = 0.0
alter Vb3 = 1.8
alter Va2 = 1.8
alter Vb2 = 1.8
alter Vc2 = 1.8
op
print i(VDD) >> dc_current.txt
alter Va3 = 0.0
alter Vb3 = 1.8
alter Va2 = 1.8
alter Vb2 = 1.8
alter Vc2 = 0.0
op
print i(VDD) >> dc_current.txt
alter Va3 = 0.0
alter Vb3 = 1.8
alter Va2 = 1.8
alter Vb2 = 0.0
alter Vc2 = 1.8
op
print i(VDD) >> dc_current.txt
alter Va3 = 0.0
alter Vb3 = 1.8
alter Va2 = 1.8
alter Vb2 = 0.0
alter Vc2 = 0.0
op
print i(VDD) >> dc_current.txt
alter Va3 = 0.0
alter Vb3 = 1.8
alter Va2 = 0.0
alter Vb2 = 1.8
alter Vc2 = 1.8
op
print i(VDD) >> dc_current.txt
alter Va3 = 0.0
alter Vb3 = 1.8
alter Va2 = 0.0
alter Vb2 = 1.8
alter Vc2 = 0.0
op
print i(VDD) >> dc_current.txt
alter Va3 = 0.0
alter Vb3 = 1.8
alter Va2 = 0.0
alter Vb2 = 0.0
alter Vc2 = 1.8
op
print i(VDD) >> dc_current.txt
alter Va3 = 0.0
alter Vb3 = 1.8
alter Va2 = 0.0
alter Vb2 = 0.0
alter Vc2 = 0.0
op
print i(VDD) >> dc_current.txt
alter Va3 = 0.0
alter Vb3 = 0.0
alter Va2 = 1.8
alter Vb2 = 1.8
alter Vc2 = 1.8
op
print i(VDD) >> dc_current.txt
alter Va3 = 0.0
alter Vb3 = 0.0
alter Va2 = 1.8
alter Vb2 = 1.8
alter Vc2 = 0.0
op
print i(VDD) >> dc_current.txt
alter Va3 = 0.0
alter Vb3 = 0.0
alter Va2 = 1.8
alter Vb2 = 0.0
alter Vc2 = 1.8
op
print i(VDD) >> dc_current.txt
alter Va3 = 0.0
alter Vb3 = 0.0
alter Va2 = 1.8
alter Vb2 = 0.0
alter Vc2 = 0.0
op
print i(VDD) >> dc_current.txt
alter Va3 = 0.0
alter Vb3 = 0.0
alter Va2 = 0.0
alter Vb2 = 1.8
alter Vc2 = 1.8
op
print i(VDD) >> dc_current.txt
alter Va3 = 0.0
alter Vb3 = 0.0
alter Va2 = 0.0
alter Vb2 = 1.8
alter Vc2 = 0.0
op
print i(VDD) >> dc_current.txt
alter Va3 = 0.0
alter Vb3 = 0.0
alter Va2 = 0.0
alter Vb2 = 0.0
alter Vc2 = 1.8
op
print i(VDD) >> dc_current.txt
alter Va3 = 0.0
alter Vb3 = 0.0
alter Va2 = 0.0
alter Vb2 = 0.0
alter Vc2 = 0.0
op
print i(VDD) >> dc_current.txt
quit
.endc
.end
