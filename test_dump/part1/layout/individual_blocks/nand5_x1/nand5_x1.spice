* NGSPICE file created from nand5_x1.ext - technology: scmos

.global Vdd Gnd

.subckt nand5_x1 i0 i1 i2 i3 i4 y vdd gnd
M1000 y i1 vdd vdd pfet w=1.8u l=0.18u
+  ad=0.567p pd=2.43u as=0.567p ps=2.43u
M1001 y i3 vdd vdd pfet w=1.8u l=0.18u
+  ad=0.567p pd=2.43u as=0.567p ps=2.43u
M1002 a_43_10# i3 a_34_10# Gnd nfet w=4.5u l=0.18u
+  ad=1.4175p pd=5.13u as=1.4175p ps=5.13u
M1003 gnd i4 a_43_10# Gnd nfet w=4.5u l=0.18u
+  ad=2.025p pd=9.9u as=1.4175p ps=5.13u
M1004 vdd i0 y vdd pfet w=1.8u l=0.18u
+  ad=0.567p pd=2.43u as=0.972p ps=4.68u
M1005 a_16_10# i0 y Gnd nfet w=4.5u l=0.18u
+  ad=1.4175p pd=5.13u as=2.43p ps=10.08u
M1006 vdd i2 y vdd pfet w=1.8u l=0.18u
+  ad=0.567p pd=2.43u as=0.567p ps=2.43u
M1007 vdd i4 y vdd pfet w=1.8u l=0.18u
+  ad=0.81p pd=4.5u as=0.567p ps=2.43u
M1008 a_25_10# i1 a_16_10# Gnd nfet w=4.5u l=0.18u
+  ad=1.4175p pd=5.13u as=1.4175p ps=5.13u
M1009 a_34_10# i2 a_25_10# Gnd nfet w=4.5u l=0.18u
+  ad=1.4175p pd=5.13u as=1.4175p ps=5.13u
C0 i2 gnd 0.00105f
C1 i3 y 0.02206f
C2 i1 i4 0.00894f
C3 i0 y 0.41035f
C4 i2 i3 0.71863f
C5 i0 i2 0.00874f
C6 vdd i3 0.02202f
C7 a_25_10# gnd 0
C8 vdd i0 0.02222f
C9 i4 y 0.00625f
C10 i3 gnd 0.00105f
C11 i0 gnd 0.00105f
C12 i2 i4 0.00894f
C13 i1 y 0.0321f
C14 i0 i3 0.00874f
C15 i1 i2 0.71863f
C16 vdd i4 0.02378f
C17 a_34_10# gnd 0
C18 a_16_10# y 0.00113f
C19 vdd i1 0.02202f
C20 i4 gnd 0.00582f
C21 i1 gnd 0.00105f
C22 i2 y 0.02353f
C23 i3 i4 0.71883f
C24 vdd y 0.98559f
C25 i0 i4 0.00926f
C26 i1 i3 0.00874f
C27 a_43_10# gnd 0.00158f
C28 i0 i1 0.71863f
C29 vdd i2 0.02202f
C30 a_16_10# gnd 0
C31 y gnd 0.04128f
.ends
