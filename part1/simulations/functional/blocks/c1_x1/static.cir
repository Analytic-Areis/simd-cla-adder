* DC supply current of c1_x1
.include ../../../../spice/models/TSMC_180nm.txt
VDD vdd gnd 1.8
* c1_x1: C1 complex gate, stack 2
* GENERATED from part1/cells/library.py. Do not edit by hand.
.subckt c1_x1 g0b t0b c0b c1 vdd gnd
Mp1 c1 g0b vdd vdd CMOSP W=1.8000e-06 L=1.8000e-07 AS=9.7200e-13 PS=4.6800e-06 AD=9.7200e-13 PD=4.6800e-06
Mp2 xp1 t0b vdd vdd CMOSP W=3.6000e-06 L=1.8000e-07 AS=1.9440e-12 PS=8.2800e-06 AD=9.7200e-13 PD=7.7400e-06
Mp3 c1 c0b xp1 vdd CMOSP W=3.6000e-06 L=1.8000e-07 AS=9.7200e-13 PS=7.7400e-06 AD=1.9440e-12 PD=8.2800e-06
Mn1 c1 g0b xn1 gnd CMOSN W=1.8000e-06 L=1.8000e-07 AS=9.7200e-13 PS=4.6800e-06 AD=9.7200e-13 PD=4.6800e-06
Mn2 xn1 t0b gnd gnd CMOSN W=1.8000e-06 L=1.8000e-07 AS=9.7200e-13 PS=4.6800e-06 AD=9.7200e-13 PD=4.6800e-06
Mn3 xn1 c0b gnd gnd CMOSN W=1.8000e-06 L=1.8000e-07 AS=9.7200e-13 PS=4.6800e-06 AD=9.7200e-13 PD=4.6800e-06
.ends c1_x1
.subckt tb_inv a y vdd gnd
mp y a vdd vdd CMOSP W=1.8e-06 L=1.8e-07 AS=9.72e-13 PS=4.68e-06 AD=9.72e-13 PD=4.68e-06
mn y a gnd gnd CMOSN W=9.0e-07 L=1.8e-07 AS=4.86e-13 PS=2.88e-06 AD=4.86e-13 PD=2.88e-06
.ends
Vg0b src_g0b gnd 1.8
Xd_g0b src_g0b g0b vdd gnd tb_inv
Vt0b src_t0b gnd 1.8
Xd_t0b src_t0b t0b vdd gnd tb_inv
Vc0b src_c0b gnd 1.8
Xd_c0b src_c0b c0b vdd gnd tb_inv
Xl_c1 c1 lo_c1 vdd gnd tb_inv
X0 g0b t0b c0b c1 vdd gnd c1_x1
.control
alter Vg0b = 1.8
alter Vt0b = 1.8
alter Vc0b = 1.8
op
print i(VDD) >> dc_current.txt
alter Vg0b = 1.8
alter Vt0b = 1.8
alter Vc0b = 0.0
op
print i(VDD) >> dc_current.txt
alter Vg0b = 1.8
alter Vt0b = 0.0
alter Vc0b = 1.8
op
print i(VDD) >> dc_current.txt
alter Vg0b = 1.8
alter Vt0b = 0.0
alter Vc0b = 0.0
op
print i(VDD) >> dc_current.txt
alter Vg0b = 0.0
alter Vt0b = 1.8
alter Vc0b = 1.8
op
print i(VDD) >> dc_current.txt
alter Vg0b = 0.0
alter Vt0b = 1.8
alter Vc0b = 0.0
op
print i(VDD) >> dc_current.txt
alter Vg0b = 0.0
alter Vt0b = 0.0
alter Vc0b = 1.8
op
print i(VDD) >> dc_current.txt
alter Vg0b = 0.0
alter Vt0b = 0.0
alter Vc0b = 0.0
op
print i(VDD) >> dc_current.txt
quit
.endc
.end
