* DC supply current of c2_x1
.include ../../../../spice/models/TSMC_180nm.txt
VDD vdd gnd 1.8
* c2_x1: C2 complex gate, stack 3
* GENERATED from part1/cells/library.py. Do not edit by hand.
.subckt c2_x1 g0b t0b g1b t1b c0b c2 vdd gnd
Mp1 c2 g1b vdd vdd CMOSP W=1.8000e-06 L=1.8000e-07 AS=9.7200e-13 PS=4.6800e-06 AD=9.7200e-13 PD=4.6800e-06
Mp2 xp1 t1b vdd vdd CMOSP W=5.4000e-06 L=1.8000e-07 AS=2.9160e-12 PS=1.1880e-05 AD=2.9160e-12 PD=1.1880e-05
Mp3 c2 g0b xp1 vdd CMOSP W=3.6000e-06 L=1.8000e-07 AS=1.9440e-12 PS=8.2800e-06 AD=1.9440e-12 PD=8.2800e-06
Mp4 xp2 t0b xp1 vdd CMOSP W=5.4000e-06 L=1.8000e-07 AS=2.9160e-12 PS=1.1880e-05 AD=1.4580e-12 PD=1.1340e-05
Mp5 c2 c0b xp2 vdd CMOSP W=5.4000e-06 L=1.8000e-07 AS=1.4580e-12 PS=1.1340e-05 AD=2.9160e-12 PD=1.1880e-05
Mn1 c2 g1b xn1 gnd CMOSN W=2.7000e-06 L=1.8000e-07 AS=1.4580e-12 PS=6.4800e-06 AD=1.4580e-12 PD=6.4800e-06
Mn2 xn1 t1b gnd gnd CMOSN W=1.8000e-06 L=1.8000e-07 AS=9.7200e-13 PS=4.6800e-06 AD=9.7200e-13 PD=4.6800e-06
Mn3 xn1 g0b xn2 gnd CMOSN W=2.7000e-06 L=1.8000e-07 AS=1.4580e-12 PS=6.4800e-06 AD=1.4580e-12 PD=6.4800e-06
Mn4 xn2 t0b gnd gnd CMOSN W=2.7000e-06 L=1.8000e-07 AS=1.4580e-12 PS=6.4800e-06 AD=1.4580e-12 PD=6.4800e-06
Mn5 xn2 c0b gnd gnd CMOSN W=2.7000e-06 L=1.8000e-07 AS=1.4580e-12 PS=6.4800e-06 AD=1.4580e-12 PD=6.4800e-06
.ends c2_x1
.subckt tb_inv a y vdd gnd
mp y a vdd vdd CMOSP W=1.8e-06 L=1.8e-07 AS=9.72e-13 PS=4.68e-06 AD=9.72e-13 PD=4.68e-06
mn y a gnd gnd CMOSN W=9.0e-07 L=1.8e-07 AS=4.86e-13 PS=2.88e-06 AD=4.86e-13 PD=2.88e-06
.ends
Vg0b src_g0b gnd 1.8
Xd_g0b src_g0b g0b vdd gnd tb_inv
Vt0b src_t0b gnd 1.8
Xd_t0b src_t0b t0b vdd gnd tb_inv
Vg1b src_g1b gnd 1.8
Xd_g1b src_g1b g1b vdd gnd tb_inv
Vt1b src_t1b gnd 1.8
Xd_t1b src_t1b t1b vdd gnd tb_inv
Vc0b src_c0b gnd 1.8
Xd_c0b src_c0b c0b vdd gnd tb_inv
Xl_c2 c2 lo_c2 vdd gnd tb_inv
X0 g0b t0b g1b t1b c0b c2 vdd gnd c2_x1
.control
alter Vg0b = 1.8
alter Vt0b = 1.8
alter Vg1b = 1.8
alter Vt1b = 1.8
alter Vc0b = 1.8
op
print i(VDD) >> dc_current.txt
alter Vg0b = 1.8
alter Vt0b = 1.8
alter Vg1b = 1.8
alter Vt1b = 1.8
alter Vc0b = 0.0
op
print i(VDD) >> dc_current.txt
alter Vg0b = 1.8
alter Vt0b = 1.8
alter Vg1b = 1.8
alter Vt1b = 0.0
alter Vc0b = 1.8
op
print i(VDD) >> dc_current.txt
alter Vg0b = 1.8
alter Vt0b = 1.8
alter Vg1b = 1.8
alter Vt1b = 0.0
alter Vc0b = 0.0
op
print i(VDD) >> dc_current.txt
alter Vg0b = 1.8
alter Vt0b = 1.8
alter Vg1b = 0.0
alter Vt1b = 1.8
alter Vc0b = 1.8
op
print i(VDD) >> dc_current.txt
alter Vg0b = 1.8
alter Vt0b = 1.8
alter Vg1b = 0.0
alter Vt1b = 1.8
alter Vc0b = 0.0
op
print i(VDD) >> dc_current.txt
alter Vg0b = 1.8
alter Vt0b = 1.8
alter Vg1b = 0.0
alter Vt1b = 0.0
alter Vc0b = 1.8
op
print i(VDD) >> dc_current.txt
alter Vg0b = 1.8
alter Vt0b = 1.8
alter Vg1b = 0.0
alter Vt1b = 0.0
alter Vc0b = 0.0
op
print i(VDD) >> dc_current.txt
alter Vg0b = 1.8
alter Vt0b = 0.0
alter Vg1b = 1.8
alter Vt1b = 1.8
alter Vc0b = 1.8
op
print i(VDD) >> dc_current.txt
alter Vg0b = 1.8
alter Vt0b = 0.0
alter Vg1b = 1.8
alter Vt1b = 1.8
alter Vc0b = 0.0
op
print i(VDD) >> dc_current.txt
alter Vg0b = 1.8
alter Vt0b = 0.0
alter Vg1b = 1.8
alter Vt1b = 0.0
alter Vc0b = 1.8
op
print i(VDD) >> dc_current.txt
alter Vg0b = 1.8
alter Vt0b = 0.0
alter Vg1b = 1.8
alter Vt1b = 0.0
alter Vc0b = 0.0
op
print i(VDD) >> dc_current.txt
alter Vg0b = 1.8
alter Vt0b = 0.0
alter Vg1b = 0.0
alter Vt1b = 1.8
alter Vc0b = 1.8
op
print i(VDD) >> dc_current.txt
alter Vg0b = 1.8
alter Vt0b = 0.0
alter Vg1b = 0.0
alter Vt1b = 1.8
alter Vc0b = 0.0
op
print i(VDD) >> dc_current.txt
alter Vg0b = 1.8
alter Vt0b = 0.0
alter Vg1b = 0.0
alter Vt1b = 0.0
alter Vc0b = 1.8
op
print i(VDD) >> dc_current.txt
alter Vg0b = 1.8
alter Vt0b = 0.0
alter Vg1b = 0.0
alter Vt1b = 0.0
alter Vc0b = 0.0
op
print i(VDD) >> dc_current.txt
alter Vg0b = 0.0
alter Vt0b = 1.8
alter Vg1b = 1.8
alter Vt1b = 1.8
alter Vc0b = 1.8
op
print i(VDD) >> dc_current.txt
alter Vg0b = 0.0
alter Vt0b = 1.8
alter Vg1b = 1.8
alter Vt1b = 1.8
alter Vc0b = 0.0
op
print i(VDD) >> dc_current.txt
alter Vg0b = 0.0
alter Vt0b = 1.8
alter Vg1b = 1.8
alter Vt1b = 0.0
alter Vc0b = 1.8
op
print i(VDD) >> dc_current.txt
alter Vg0b = 0.0
alter Vt0b = 1.8
alter Vg1b = 1.8
alter Vt1b = 0.0
alter Vc0b = 0.0
op
print i(VDD) >> dc_current.txt
alter Vg0b = 0.0
alter Vt0b = 1.8
alter Vg1b = 0.0
alter Vt1b = 1.8
alter Vc0b = 1.8
op
print i(VDD) >> dc_current.txt
alter Vg0b = 0.0
alter Vt0b = 1.8
alter Vg1b = 0.0
alter Vt1b = 1.8
alter Vc0b = 0.0
op
print i(VDD) >> dc_current.txt
alter Vg0b = 0.0
alter Vt0b = 1.8
alter Vg1b = 0.0
alter Vt1b = 0.0
alter Vc0b = 1.8
op
print i(VDD) >> dc_current.txt
alter Vg0b = 0.0
alter Vt0b = 1.8
alter Vg1b = 0.0
alter Vt1b = 0.0
alter Vc0b = 0.0
op
print i(VDD) >> dc_current.txt
alter Vg0b = 0.0
alter Vt0b = 0.0
alter Vg1b = 1.8
alter Vt1b = 1.8
alter Vc0b = 1.8
op
print i(VDD) >> dc_current.txt
alter Vg0b = 0.0
alter Vt0b = 0.0
alter Vg1b = 1.8
alter Vt1b = 1.8
alter Vc0b = 0.0
op
print i(VDD) >> dc_current.txt
alter Vg0b = 0.0
alter Vt0b = 0.0
alter Vg1b = 1.8
alter Vt1b = 0.0
alter Vc0b = 1.8
op
print i(VDD) >> dc_current.txt
alter Vg0b = 0.0
alter Vt0b = 0.0
alter Vg1b = 1.8
alter Vt1b = 0.0
alter Vc0b = 0.0
op
print i(VDD) >> dc_current.txt
alter Vg0b = 0.0
alter Vt0b = 0.0
alter Vg1b = 0.0
alter Vt1b = 1.8
alter Vc0b = 1.8
op
print i(VDD) >> dc_current.txt
alter Vg0b = 0.0
alter Vt0b = 0.0
alter Vg1b = 0.0
alter Vt1b = 1.8
alter Vc0b = 0.0
op
print i(VDD) >> dc_current.txt
alter Vg0b = 0.0
alter Vt0b = 0.0
alter Vg1b = 0.0
alter Vt1b = 0.0
alter Vc0b = 1.8
op
print i(VDD) >> dc_current.txt
alter Vg0b = 0.0
alter Vt0b = 0.0
alter Vg1b = 0.0
alter Vt1b = 0.0
alter Vc0b = 0.0
op
print i(VDD) >> dc_current.txt
quit
.endc
.end
