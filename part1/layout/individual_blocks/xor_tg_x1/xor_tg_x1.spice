* NGSPICE file created from xor_tg_x1.ext - technology: scmos

.global Vdd Gnd

.subckt xor_tg_x1 c p pb s vdd gnd
M1000 pb c a_22_47# vdd pfet w=1.8u l=0.18u
+  ad=0.81p pd=4.5u as=0.567p ps=2.43u
M1001 vdd c a_8_10# vdd pfet w=1.8u l=0.18u
+  ad=0.567p pd=2.43u as=0.972p ps=4.68u
M1002 a_22_47# a_8_10# pb Gnd nfet w=0.9u l=0.18u
+  ad=0.2835p pd=1.53u as=0.486p ps=2.88u
M1003 s a_22_47# vdd vdd pfet w=1.8u l=0.18u
+  ad=0.81p pd=4.5u as=0.567p ps=2.43u
M1004 p c a_22_47# Gnd nfet w=0.9u l=0.18u
+  ad=0.405p pd=2.7u as=0.2835p ps=1.53u
M1005 gnd c a_8_10# Gnd nfet w=0.9u l=0.18u
+  ad=0.2835p pd=1.53u as=0.486p ps=2.88u
M1006 a_22_47# a_8_10# p vdd pfet w=1.8u l=0.18u
+  ad=0.567p pd=2.43u as=0.972p ps=4.68u
M1007 s a_22_47# gnd Gnd nfet w=0.9u l=0.18u
+  ad=0.405p pd=2.7u as=0.2835p ps=1.53u
C0 a_8_10# s 0.07805f
C1 a_22_47# p 0.51378f
C2 vdd c 0.04209f
C3 a_22_47# vdd 0.07459f
C4 p gnd 0.04126f
C5 c pb 0.0212f
C6 s p 0.2594f
C7 a_22_47# pb 0.57201f
C8 a_8_10# p 0.01215f
C9 vdd s 0.21793f
C10 a_22_47# c 0.54974f
C11 a_8_10# vdd 0.23836f
C12 pb gnd 0.04128f
C13 c gnd 0.00363f
C14 s pb 0.27127f
C15 c s 0.02242f
C16 vdd p 0.05288f
C17 a_22_47# gnd 0.04389f
C18 a_8_10# pb 0.0891f
C19 a_22_47# s 0.068f
C20 a_8_10# c 0.61439f
C21 a_22_47# a_8_10# 0.04035f
C22 s gnd 0.12391f
C23 p pb 0.36562f
C24 vdd pb 0.05287f
C25 c p 0.02395f
C26 a_8_10# gnd 0.12498f
.ends
