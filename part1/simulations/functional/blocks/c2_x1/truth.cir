* Truth table of c2_x1: inputs through unit inverters, outputs load 20L/10L inverter
.include ../../../../spice/models/TSMC_180nm.txt
.options reltol=1e-3
VDD vdd gnd 1.8
* c2_x1: C2 complex gate, stack 3
* GENERATED from part1/cells/library.py. Do not edit by hand.
.subckt c2_x1 g0b t0b g1b t1b c0b c2 vdd gnd
Mp1 c2 g1b vdd vdd CMOSP W=1.8000e-06 L=1.8000e-07 AS=9.7200e-13 PS=4.6800e-06 AD=9.7200e-13 PD=4.6800e-06
Mp2 xp1 t1b vdd vdd CMOSP W=5.4000e-06 L=1.8000e-07 AS=2.9160e-12 PS=1.1880e-05 AD=2.9160e-12 PD=1.1880e-05
Mp3 c2 g0b xp1 vdd CMOSP W=3.6000e-06 L=1.8000e-07 AS=1.9440e-12 PS=8.2800e-06 AD=1.9440e-12 PD=8.2800e-06
Mp4 xp2 t0b xp1 vdd CMOSP W=5.4000e-06 L=1.8000e-07 AS=2.9160e-12 PS=1.1880e-05 AD=1.4580e-12 PD=1.1340e-05
Mp5 c2 c0b xp2 vdd CMOSP W=5.4000e-06 L=1.8000e-07 AS=1.4580e-12 PS=1.1340e-05 AD=2.9160e-12 PD=1.1880e-05
Mn1 c2 g1b xn1 gnd CMOSN W=2.7000e-06 L=1.8000e-07 AS=1.4580e-12 PS=6.4800e-06 AD=1.4580e-12 PD=6.4800e-06
Mn2 xn1 t1b gnd gnd CMOSN W=1.8000e-06 L=1.8000e-07 AS=9.7200e-13 PS=4.6800e-06 AD=9.7200e-13 PD=4.6800e-06
Mn3 xn1 g0b xn2 gnd CMOSN W=2.7000e-06 L=1.8000e-07 AS=1.4580e-12 PS=6.4800e-06 AD=1.4580e-12 PD=6.4800e-06
Mn4 xn2 t0b gnd gnd CMOSN W=2.7000e-06 L=1.8000e-07 AS=1.4580e-12 PS=6.4800e-06 AD=1.4580e-12 PD=6.4800e-06
Mn5 xn2 c0b gnd gnd CMOSN W=2.7000e-06 L=1.8000e-07 AS=1.4580e-12 PS=6.4800e-06 AD=1.4580e-12 PD=6.4800e-06
.ends c2_x1
.subckt tb_inv a y vdd gnd
mp y a vdd vdd CMOSP W=1.8e-06 L=1.8e-07 AS=9.72e-13 PS=4.68e-06 AD=9.72e-13 PD=4.68e-06
mn y a gnd gnd CMOSN W=9.0e-07 L=1.8e-07 AS=4.86e-13 PS=2.88e-06 AD=4.86e-13 PD=2.88e-06
.ends
Vg0b src_g0b gnd PWL(
+ 0.00000e+00 1.800 1.60000e-08 1.800 1.60500e-08 0.000 3.40000e-08 0.000 3.40500e-08 1.800 3.60000e-08 1.800
+ 3.60500e-08 0.000 3.70000e-08 0.000 3.70500e-08 1.800 4.10000e-08 1.800 4.10500e-08 0.000 4.20000e-08 0.000
+ 4.20500e-08 1.800 4.30000e-08 1.800 4.30500e-08 0.000 4.50000e-08 0.000 4.50500e-08 1.800 4.60000e-08 1.800
+ 4.60500e-08 0.000 4.70000e-08 0.000 4.70500e-08 1.800 4.80000e-08 1.800 4.80500e-08 0.000 5.00000e-08 0.000
+ 5.00500e-08 1.800 5.20000e-08 1.800 5.20500e-08 0.000 5.40000e-08 0.000 5.40500e-08 1.800 5.70000e-08 1.800
+ 5.70500e-08 0.000 5.80000e-08 0.000 5.80500e-08 1.800 5.90000e-08 1.800 5.90500e-08 0.000 6.30000e-08 0.000
+ 6.30500e-08 1.800 6.40000e-08 1.800
+ )
Xd_g0b src_g0b g0b vdd gnd tb_inv
Vt0b src_t0b gnd PWL(
+ 0.00000e+00 1.800 8.00000e-09 1.800 8.05000e-09 0.000 1.60000e-08 0.000 1.60500e-08 1.800 2.40000e-08 1.800
+ 2.40500e-08 0.000 3.30000e-08 0.000 3.30500e-08 1.800 3.40000e-08 1.800 3.40500e-08 0.000 3.70000e-08 0.000
+ 3.70500e-08 1.800 4.20000e-08 1.800 4.20500e-08 0.000 4.30000e-08 0.000 4.30500e-08 1.800 4.40000e-08 1.800
+ 4.40500e-08 0.000 4.60000e-08 0.000 4.60500e-08 1.800 4.90000e-08 1.800 4.90500e-08 0.000 5.00000e-08 0.000
+ 5.00500e-08 1.800 5.10000e-08 1.800 5.10500e-08 0.000 5.20000e-08 0.000 5.20500e-08 1.800 5.40000e-08 1.800
+ 5.40500e-08 0.000 5.60000e-08 0.000 5.60500e-08 1.800 5.70000e-08 1.800 5.70500e-08 0.000 5.80000e-08 0.000
+ 5.80500e-08 1.800 5.90000e-08 1.800 5.90500e-08 0.000 6.20000e-08 0.000 6.20500e-08 1.800 6.30000e-08 1.800
+ 6.30500e-08 0.000 6.40000e-08 0.000
+ )
Xd_t0b src_t0b t0b vdd gnd tb_inv
Vg1b src_g1b gnd PWL(
+ 0.00000e+00 1.800 4.00000e-09 1.800 4.05000e-09 0.000 8.00000e-09 0.000 8.05000e-09 1.800 1.20000e-08 1.800
+ 1.20500e-08 0.000 1.60000e-08 0.000 1.60500e-08 1.800 2.00000e-08 1.800 2.00500e-08 0.000 2.40000e-08 0.000
+ 2.40500e-08 1.800 2.80000e-08 1.800 2.80500e-08 0.000 3.20000e-08 0.000 3.20500e-08 1.800 3.60000e-08 1.800
+ 3.60500e-08 0.000 3.70000e-08 0.000 3.70500e-08 1.800 3.80000e-08 1.800 3.80500e-08 0.000 4.10000e-08 0.000
+ 4.10500e-08 1.800 4.40000e-08 1.800 4.40500e-08 0.000 4.70000e-08 0.000 4.70500e-08 1.800 4.80000e-08 1.800
+ 4.80500e-08 0.000 5.60000e-08 0.000 5.60500e-08 1.800 5.70000e-08 1.800 5.70500e-08 0.000 5.80000e-08 0.000
+ 5.80500e-08 1.800 6.40000e-08 1.800
+ )
Xd_g1b src_g1b g1b vdd gnd tb_inv
Vt1b src_t1b gnd PWL(
+ 0.00000e+00 1.800 2.00000e-09 1.800 2.05000e-09 0.000 4.00000e-09 0.000 4.05000e-09 1.800 6.00000e-09 1.800
+ 6.05000e-09 0.000 8.00000e-09 0.000 8.05000e-09 1.800 1.00000e-08 1.800 1.00500e-08 0.000 1.20000e-08 0.000
+ 1.20500e-08 1.800 1.40000e-08 1.800 1.40500e-08 0.000 1.60000e-08 0.000 1.60500e-08 1.800 1.80000e-08 1.800
+ 1.80500e-08 0.000 2.00000e-08 0.000 2.00500e-08 1.800 2.20000e-08 1.800 2.20500e-08 0.000 2.40000e-08 0.000
+ 2.40500e-08 1.800 2.60000e-08 1.800 2.60500e-08 0.000 2.80000e-08 0.000 2.80500e-08 1.800 3.00000e-08 1.800
+ 3.00500e-08 0.000 3.30000e-08 0.000 3.30500e-08 1.800 3.40000e-08 1.800 3.40500e-08 0.000 3.60000e-08 0.000
+ 3.60500e-08 1.800 4.00000e-08 1.800 4.00500e-08 0.000 4.10000e-08 0.000 4.10500e-08 1.800 4.30000e-08 1.800
+ 4.30500e-08 0.000 4.50000e-08 0.000 4.50500e-08 1.800 4.60000e-08 1.800 4.60500e-08 0.000 4.70000e-08 0.000
+ 4.70500e-08 1.800 5.00000e-08 1.800 5.00500e-08 0.000 5.10000e-08 0.000 5.10500e-08 1.800 5.30000e-08 1.800
+ 5.30500e-08 0.000 5.90000e-08 0.000 5.90500e-08 1.800 6.10000e-08 1.800 6.10500e-08 0.000 6.30000e-08 0.000
+ 6.30500e-08 1.800 6.40000e-08 1.800
+ )
Xd_t1b src_t1b t1b vdd gnd tb_inv
Vc0b src_c0b gnd PWL(
+ 0.00000e+00 1.800 1.00000e-09 1.800 1.05000e-09 0.000 2.00000e-09 0.000 2.05000e-09 1.800 3.00000e-09 1.800
+ 3.05000e-09 0.000 4.00000e-09 0.000 4.05000e-09 1.800 5.00000e-09 1.800 5.05000e-09 0.000 6.00000e-09 0.000
+ 6.05000e-09 1.800 7.00000e-09 1.800 7.05000e-09 0.000 8.00000e-09 0.000 8.05000e-09 1.800 9.00000e-09 1.800
+ 9.05000e-09 0.000 1.00000e-08 0.000 1.00500e-08 1.800 1.10000e-08 1.800 1.10500e-08 0.000 1.20000e-08 0.000
+ 1.20500e-08 1.800 1.30000e-08 1.800 1.30500e-08 0.000 1.40000e-08 0.000 1.40500e-08 1.800 1.50000e-08 1.800
+ 1.50500e-08 0.000 1.60000e-08 0.000 1.60500e-08 1.800 1.70000e-08 1.800 1.70500e-08 0.000 1.80000e-08 0.000
+ 1.80500e-08 1.800 1.90000e-08 1.800 1.90500e-08 0.000 2.00000e-08 0.000 2.00500e-08 1.800 2.10000e-08 1.800
+ 2.10500e-08 0.000 2.20000e-08 0.000 2.20500e-08 1.800 2.30000e-08 1.800 2.30500e-08 0.000 2.40000e-08 0.000
+ 2.40500e-08 1.800 2.50000e-08 1.800 2.50500e-08 0.000 2.60000e-08 0.000 2.60500e-08 1.800 2.70000e-08 1.800
+ 2.70500e-08 0.000 2.80000e-08 0.000 2.80500e-08 1.800 2.90000e-08 1.800 2.90500e-08 0.000 3.00000e-08 0.000
+ 3.00500e-08 1.800 3.10000e-08 1.800 3.10500e-08 0.000 3.20000e-08 0.000 3.20500e-08 1.800 3.30000e-08 1.800
+ 3.30500e-08 0.000 3.50000e-08 0.000 3.50500e-08 1.800 3.70000e-08 1.800 3.70500e-08 0.000 3.90000e-08 0.000
+ 3.90500e-08 1.800 4.00000e-08 1.800 4.00500e-08 0.000 4.10000e-08 0.000 4.10500e-08 1.800 4.20000e-08 1.800
+ 4.20500e-08 0.000 4.40000e-08 0.000 4.40500e-08 1.800 4.50000e-08 1.800 4.50500e-08 0.000 4.60000e-08 0.000
+ 4.60500e-08 1.800 4.80000e-08 1.800 4.80500e-08 0.000 5.00000e-08 0.000 5.00500e-08 1.800 5.30000e-08 1.800
+ 5.30500e-08 0.000 5.40000e-08 0.000 5.40500e-08 1.800 5.50000e-08 1.800 5.50500e-08 0.000 5.80000e-08 0.000
+ 5.80500e-08 1.800 6.00000e-08 1.800 6.00500e-08 0.000 6.20000e-08 0.000 6.20500e-08 1.800 6.40000e-08 1.800
+ )
Xd_c0b src_c0b c0b vdd gnd tb_inv
Xl_c2 c2 lo_c2 vdd gnd tb_inv
X0 g0b t0b g1b t1b c0b c2 vdd gnd c2_x1
.tran 200p 6.40000e-08
.control
set wr_singlescale
set wr_vecnames
run
set curplottitle=Bhargav-2025102061-1.3-c2_x1-function
wrdata wave.txt v(g0b) v(t0b) v(g1b) v(t1b) v(c0b) v(c2) i(VDD)
quit
.endc
.end
