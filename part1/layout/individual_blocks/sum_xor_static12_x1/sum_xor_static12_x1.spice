* NGSPICE file created from sum_xor_static12_x1.ext - technology: scmos

.global Vdd Gnd

.subckt sum_xor_static12_x1 c0 c1 c2 c3 p0 p1 p2 p3 s0 s1 s2 s3 vdd gnd
M1000 gnd c2 a_169_10# Gnd nfet w=1.8u l=0.18u
+  ad=0.486p pd=2.43u as=0.567p ps=2.43u
M1001 s3 a_197_20# a_214_10# Gnd nfet w=1.8u l=0.18u
+  ad=0.567p pd=2.43u as=0.567p ps=2.43u
M1002 gnd c1 a_106_10# Gnd nfet w=1.8u l=0.18u
+  ad=0.486p pd=2.43u as=0.567p ps=2.43u
M1003 a_25_152# p0 vdd vdd pfet w=3.6u l=0.18u
+  ad=1.134p pd=4.23u as=1.053p ps=4.23u
M1004 a_88_152# p1 vdd vdd pfet w=3.6u l=0.18u
+  ad=1.134p pd=4.23u as=1.053p ps=4.23u
M1005 a_88_152# a_85_57# s1 vdd pfet w=3.6u l=0.18u
+  ad=1.134p pd=4.23u as=1.134p ps=4.23u
M1006 a_151_152# a_148_66# s2 vdd pfet w=3.6u l=0.18u
+  ad=1.134p pd=4.23u as=1.134p ps=4.23u
M1007 a_214_152# p3 vdd vdd pfet w=3.6u l=0.18u
+  ad=1.134p pd=4.23u as=1.053p ps=4.23u
M1008 a_43_10# p0 s0 Gnd nfet w=1.8u l=0.18u
+  ad=0.567p pd=2.43u as=0.567p ps=2.43u
M1009 a_25_152# a_22_48# s0 vdd pfet w=3.6u l=0.18u
+  ad=1.134p pd=4.23u as=1.134p ps=4.23u
M1010 gnd p1 a_71_20# Gnd nfet w=0.9u l=0.18u
+  ad=0.5265p pd=2.43u as=0.486p ps=2.88u
M1011 a_85_57# c1 vdd vdd pfet w=1.8u l=0.18u
+  ad=0.81p pd=4.5u as=0.972p ps=4.23u
M1012 a_148_66# c2 vdd vdd pfet w=1.8u l=0.18u
+  ad=0.81p pd=4.5u as=0.972p ps=4.23u
M1013 gnd p0 a_8_20# Gnd nfet w=0.9u l=0.18u
+  ad=0.5265p pd=2.43u as=0.486p ps=2.88u
M1014 a_232_10# p3 s3 Gnd nfet w=1.8u l=0.18u
+  ad=0.567p pd=2.43u as=0.567p ps=2.43u
M1015 gnd p3 a_197_20# Gnd nfet w=0.9u l=0.18u
+  ad=0.5265p pd=2.43u as=0.486p ps=2.88u
M1016 a_214_152# a_211_75# s3 vdd pfet w=3.6u l=0.18u
+  ad=1.134p pd=4.23u as=1.134p ps=4.23u
M1017 a_22_48# c0 vdd vdd pfet w=1.8u l=0.18u
+  ad=0.81p pd=4.5u as=0.972p ps=4.23u
M1018 vdd p2 a_134_20# vdd pfet w=1.8u l=0.18u
+  ad=1.053p pd=4.23u as=0.972p ps=4.68u
M1019 gnd p2 a_134_20# Gnd nfet w=0.9u l=0.18u
+  ad=0.5265p pd=2.43u as=0.486p ps=2.88u
M1020 a_151_10# a_148_66# gnd Gnd nfet w=1.8u l=0.18u
+  ad=0.567p pd=2.43u as=0.5265p ps=2.43u
M1021 gnd c0 a_43_10# Gnd nfet w=1.8u l=0.18u
+  ad=0.486p pd=2.43u as=0.567p ps=2.43u
M1022 a_211_75# c3 vdd vdd pfet w=1.8u l=0.18u
+  ad=0.81p pd=4.5u as=0.972p ps=4.23u
M1023 vdd p0 a_8_20# vdd pfet w=1.8u l=0.18u
+  ad=1.053p pd=4.23u as=0.972p ps=4.68u
M1024 vdd p1 a_71_20# vdd pfet w=1.8u l=0.18u
+  ad=1.053p pd=4.23u as=0.972p ps=4.68u
M1025 s2 a_134_20# a_151_152# vdd pfet w=3.6u l=0.18u
+  ad=1.134p pd=4.23u as=1.134p ps=4.23u
M1026 s2 a_134_20# a_151_10# Gnd nfet w=1.8u l=0.18u
+  ad=0.567p pd=2.43u as=0.567p ps=2.43u
M1027 vdd p3 a_197_20# vdd pfet w=1.8u l=0.18u
+  ad=1.053p pd=4.23u as=0.972p ps=4.68u
M1028 s0 a_8_20# a_25_152# vdd pfet w=3.6u l=0.18u
+  ad=1.134p pd=4.23u as=1.134p ps=4.23u
M1029 s1 a_71_20# a_88_152# vdd pfet w=3.6u l=0.18u
+  ad=1.134p pd=4.23u as=1.134p ps=4.23u
M1030 vdd c1 a_88_152# vdd pfet w=3.6u l=0.18u
+  ad=0.972p pd=4.23u as=1.134p ps=4.23u
M1031 vdd c2 a_151_152# vdd pfet w=3.6u l=0.18u
+  ad=0.972p pd=4.23u as=1.134p ps=4.23u
M1032 a_88_10# a_85_57# gnd Gnd nfet w=1.8u l=0.18u
+  ad=0.567p pd=2.43u as=0.5265p ps=2.43u
M1033 vdd c0 a_25_152# vdd pfet w=3.6u l=0.18u
+  ad=0.972p pd=4.23u as=1.134p ps=4.23u
M1034 s3 a_197_20# a_214_152# vdd pfet w=3.6u l=0.18u
+  ad=1.134p pd=4.23u as=1.134p ps=4.23u
M1035 a_25_10# a_22_48# gnd Gnd nfet w=1.8u l=0.18u
+  ad=0.567p pd=2.43u as=0.5265p ps=2.43u
M1036 a_22_48# c0 gnd Gnd nfet w=0.9u l=0.18u
+  ad=0.405p pd=2.7u as=0.486p ps=2.43u
M1037 a_169_10# p2 s2 Gnd nfet w=1.8u l=0.18u
+  ad=0.567p pd=2.43u as=0.567p ps=2.43u
M1038 a_106_10# p1 s1 Gnd nfet w=1.8u l=0.18u
+  ad=0.567p pd=2.43u as=0.567p ps=2.43u
M1039 a_214_10# a_211_75# gnd Gnd nfet w=1.8u l=0.18u
+  ad=0.567p pd=2.43u as=0.5265p ps=2.43u
M1040 a_211_75# c3 gnd Gnd nfet w=0.9u l=0.18u
+  ad=0.405p pd=2.7u as=0.486p ps=2.43u
M1041 vdd c3 a_214_152# vdd pfet w=3.6u l=0.18u
+  ad=0.972p pd=4.23u as=1.134p ps=4.23u
M1042 s1 a_71_20# a_88_10# Gnd nfet w=1.8u l=0.18u
+  ad=0.567p pd=2.43u as=0.567p ps=2.43u
M1043 a_148_66# c2 gnd Gnd nfet w=0.9u l=0.18u
+  ad=0.405p pd=2.7u as=0.486p ps=2.43u
M1044 gnd c3 a_232_10# Gnd nfet w=1.8u l=0.18u
+  ad=0.486p pd=2.43u as=0.567p ps=2.43u
M1045 a_151_152# p2 vdd vdd pfet w=3.6u l=0.18u
+  ad=1.134p pd=4.23u as=1.053p ps=4.23u
M1046 s0 a_8_20# a_25_10# Gnd nfet w=1.8u l=0.18u
+  ad=0.567p pd=2.43u as=0.567p ps=2.43u
M1047 a_85_57# c1 gnd Gnd nfet w=0.9u l=0.18u
+  ad=0.405p pd=2.7u as=0.486p ps=2.43u
C0 a_134_20# a_151_152# 0.0138f
C1 a_85_57# a_214_152# 0.23789f
C2 vdd c3 0.04494f
C3 a_106_10# gnd 0
C4 a_169_10# s2 0
C5 a_148_66# a_197_20# 0.59069f
C6 a_71_20# a_88_152# 0.01387f
C7 a_22_48# a_151_152# 0.23789f
C8 a_25_10# gnd 0
C9 a_106_10# s1 0
C10 vdd p2 0.04494f
C11 a_8_20# a_25_152# 0.01425f
C12 a_22_48# a_211_75# 0.66875f
C13 a_85_57# a_148_66# 1.43389f
C14 a_43_10# s0 0
C15 vdd c0 0.04494f
C16 a_22_48# a_134_20# 0.32664f
C17 a_71_20# a_85_57# 0.31078f
C18 a_88_152# s1 1.18796f
C19 a_197_20# gnd 0.08369f
C20 a_214_152# c3 0.00679f
C21 a_211_75# s3 0.01558f
C22 a_151_152# c2 0.00686f
C23 a_148_66# s2 0.01565f
C24 a_85_57# gnd 0.08604f
C25 a_22_48# s3 0.01991f
C26 a_8_20# gnd 0.08369f
C27 a_148_66# c3 0.03683f
C28 a_88_152# c1 0.00693f
C29 a_85_57# s1 0.01572f
C30 a_197_20# p3 0.47676f
C31 a_151_152# vdd 0.76812f
C32 a_25_152# c0 0.00699f
C33 a_22_48# s0 0.0161f
C34 a_85_57# p3 0.36766f
C35 a_148_66# p2 0.40467f
C36 s2 gnd 0.04131f
C37 a_22_48# c2 0.18229f
C38 a_85_57# c1 0.24686f
C39 a_211_75# vdd 0.19841f
C40 c3 gnd 0.00493f
C41 a_134_20# vdd 0.19641f
C42 a_22_48# p1 0.03728f
C43 p2 gnd 0.00258f
C44 a_8_20# p0 0.4772f
C45 a_22_48# vdd 0.19641f
C46 c0 gnd 0.00493f
C47 p3 c3 0.23626f
C48 a_211_75# a_214_152# 0.08335f
C49 a_232_10# gnd 0
C50 vdd s3 0.05318f
C51 a_148_66# a_151_152# 0.01517f
C52 vdd s0 0.05318f
C53 a_151_10# gnd 0
C54 a_148_66# a_211_75# 0.90106f
C55 a_85_57# a_88_152# 0.01525f
C56 a_43_10# gnd 0
C57 vdd c2 0.04494f
C58 a_85_57# a_197_20# 0.03765f
C59 a_134_20# a_148_66# 0.28164f
C60 a_22_48# a_25_152# 0.01532f
C61 a_214_152# s3 1.00004f
C62 p0 c0 0.11971f
C63 vdd p1 0.04494f
C64 a_22_48# a_148_66# 0.02749f
C65 a_211_75# gnd 0.08604f
C66 a_22_48# a_71_20# 0.92666f
C67 a_148_66# s3 0.07047f
C68 a_25_152# s0 1.28658f
C69 a_134_20# gnd 0.08369f
C70 a_85_57# s2 0.07047f
C71 a_22_48# gnd 0.08604f
C72 a_211_75# p3 0.17371f
C73 a_22_48# s1 0.07078f
C74 a_214_152# vdd 0.76812f
C75 a_85_57# c3 0.03683f
C76 a_148_66# c2 0.18854f
C77 s3 gnd 0.04131f
C78 a_25_152# vdd 0.76812f
C79 a_22_48# p3 0.36786f
C80 a_85_57# p2 0.03695f
C81 s0 gnd 0.04131f
C82 a_22_48# c1 0.18229f
C83 a_71_20# p1 0.47684f
C84 a_148_66# vdd 0.19641f
C85 c2 gnd 0.00493f
C86 p3 s3 0.01293f
C87 a_71_20# vdd 0.19641f
C88 a_22_48# p0 0.34672f
C89 p2 s2 0.01289f
C90 p1 gnd 0.00258f
C91 p1 s1 0.01288f
C92 a_148_66# a_214_152# 0.25672f
C93 p0 s0 0.01286f
C94 a_214_10# s3 0
C95 a_169_10# gnd 0
C96 vdd s1 0.05318f
C97 a_197_20# a_211_75# 0.25251f
C98 a_85_57# a_151_152# 0.25672f
C99 a_88_10# gnd 0
C100 p1 c1 0.14885f
C101 vdd p3 0.04494f
C102 a_151_10# s2 0
C103 a_22_48# a_88_152# 0.25672f
C104 a_85_57# a_211_75# 0.02757f
C105 a_88_10# s1 0
C106 vdd c1 0.04494f
C107 a_22_48# a_197_20# 0.32664f
C108 a_85_57# a_134_20# 0.61418f
C109 a_151_152# s2 1.094f
C110 vdd p0 0.04494f
C111 a_25_10# s0 0
C112 a_22_48# a_85_57# 1.96742f
C113 a_197_20# s3 0.02636f
C114 a_148_66# gnd 0.08604f
C115 a_214_152# p3 0.00661f
C116 a_8_20# a_22_48# 0.48489f
C117 a_134_20# s2 0.0264f
C118 a_85_57# s3 0.0196f
C119 a_71_20# gnd 0.08369f
C120 a_211_75# c3 0.12956f
C121 a_151_152# p2 0.00668f
C122 a_71_20# s1 0.02644f
C123 a_22_48# s2 0.01991f
C124 a_148_66# p3 0.03695f
C125 a_88_152# p1 0.20374f
C126 a_88_152# vdd 0.76812f
C127 a_22_48# c3 0.18144f
C128 a_85_57# c2 0.03683f
C129 a_134_20# p2 0.4768f
C130 a_25_152# p0 0.2038f
C131 a_8_20# s0 0.02648f
C132 s1 gnd 0.04131f
C133 a_197_20# vdd 0.19641f
C134 a_22_48# p2 0.36798f
C135 a_85_57# p1 0.37554f
C136 p3 gnd 0.00258f
C137 a_22_48# c0 0.45065f
C138 a_85_57# vdd 0.19641f
C139 c1 gnd 0.00493f
C140 a_8_20# vdd 0.19695f
C141 p0 gnd 0.00258f
C142 a_197_20# a_214_152# 0.01373f
C143 a_232_10# s3 0
C144 a_214_10# gnd 0
C145 vdd s2 0.05318f
C146 p2 c2 0.17798f
.ends
