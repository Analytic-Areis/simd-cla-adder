* All-arc segment for cla_C2_tg_t
.include ../../../../../spice/models/TSMC_180nm.txt
.options reltol=1e-3
VDD vdd gnd 1.8
* nand2_x0p74: 2-input NAND
* GENERATED from part1/cells/library.py. Do not edit by hand.
.subckt nand2_x0p74 i0 i1 y vdd gnd
Mp1 y i0 vdd vdd CMOSP W=1.3500e-06 L=1.8000e-07 AS=7.2900e-13 PS=3.7800e-06 AD=7.2900e-13 PD=3.7800e-06
Mp2 y i1 vdd vdd CMOSP W=1.3500e-06 L=1.8000e-07 AS=7.2900e-13 PS=3.7800e-06 AD=7.2900e-13 PD=3.7800e-06
Mn1 y i0 xn1 gnd CMOSN W=1.3500e-06 L=1.8000e-07 AS=3.6450e-13 PS=3.2400e-06 AD=7.2900e-13 PD=3.7800e-06
Mn2 xn1 i1 gnd gnd CMOSN W=1.3500e-06 L=1.8000e-07 AS=7.2900e-13 PS=3.7800e-06 AD=3.6450e-13 PD=3.2400e-06
.ends nand2_x0p74
* nor2_x1p25: 2-input NOR
* GENERATED from part1/cells/library.py. Do not edit by hand.
.subckt nor2_x1p25 i0 i1 y vdd gnd
Mp1 xp1 i0 vdd vdd CMOSP W=4.5000e-06 L=1.8000e-07 AS=2.4300e-12 PS=1.0080e-05 AD=1.2150e-12 PD=9.5400e-06
Mp2 y i1 xp1 vdd CMOSP W=4.5000e-06 L=1.8000e-07 AS=1.2150e-12 PS=9.5400e-06 AD=2.4300e-12 PD=1.0080e-05
Mn1 y i0 gnd gnd CMOSN W=1.0800e-06 L=1.8000e-07 AS=5.8320e-13 PS=3.2400e-06 AD=5.8320e-13 PD=3.2400e-06
Mn2 y i1 gnd gnd CMOSN W=1.0800e-06 L=1.8000e-07 AS=5.8320e-13 PS=3.2400e-06 AD=5.8320e-13 PD=3.2400e-06
.ends nor2_x1p25
* aoi21_x0p41: NOT(a b + c)
* GENERATED from part1/cells/library.py. Do not edit by hand.
.subckt aoi21_x0p41 a b c y vdd gnd
Mp1 xp1 a vdd vdd CMOSP W=1.4400e-06 L=1.8000e-07 AS=7.7760e-13 PS=3.9600e-06 AD=7.7760e-13 PD=3.9600e-06
Mp2 xp1 b vdd vdd CMOSP W=1.4400e-06 L=1.8000e-07 AS=7.7760e-13 PS=3.9600e-06 AD=7.7760e-13 PD=3.9600e-06
Mp3 y c xp1 vdd CMOSP W=1.4400e-06 L=1.8000e-07 AS=7.7760e-13 PS=3.9600e-06 AD=7.7760e-13 PD=3.9600e-06
Mn1 y a xn1 gnd CMOSN W=7.2000e-07 L=1.8000e-07 AS=1.9440e-13 PS=1.9800e-06 AD=3.8880e-13 PD=2.5200e-06
Mn2 xn1 b gnd gnd CMOSN W=7.2000e-07 L=1.8000e-07 AS=3.8880e-13 PS=2.5200e-06 AD=1.9440e-13 PD=1.9800e-06
Mn3 y c gnd gnd CMOSN W=3.6000e-07 L=1.8000e-07 AS=1.9440e-13 PS=1.8000e-06 AD=1.9440e-13 PD=1.8000e-06
.ends aoi21_x0p41
* oai21_x0p41: NOT((a + b) c)
* GENERATED from part1/cells/library.py. Do not edit by hand.
.subckt oai21_x0p41 a b c y vdd gnd
Mp1 xp1 a vdd vdd CMOSP W=1.4400e-06 L=1.8000e-07 AS=7.7760e-13 PS=3.9600e-06 AD=3.8880e-13 PD=3.4200e-06
Mp2 y b xp1 vdd CMOSP W=1.4400e-06 L=1.8000e-07 AS=3.8880e-13 PS=3.4200e-06 AD=7.7760e-13 PD=3.9600e-06
Mp3 y c vdd vdd CMOSP W=7.2000e-07 L=1.8000e-07 AS=3.8880e-13 PS=2.5200e-06 AD=3.8880e-13 PD=2.5200e-06
Mn1 y a xn1 gnd CMOSN W=7.2000e-07 L=1.8000e-07 AS=3.8880e-13 PS=2.5200e-06 AD=3.8880e-13 PD=2.5200e-06
Mn2 y b xn1 gnd CMOSN W=7.2000e-07 L=1.8000e-07 AS=3.8880e-13 PS=2.5200e-06 AD=3.8880e-13 PD=2.5200e-06
Mn3 xn1 c gnd gnd CMOSN W=7.2000e-07 L=1.8000e-07 AS=3.8880e-13 PS=2.5200e-06 AD=3.8880e-13 PD=2.5200e-06
.ends oai21_x0p41
* nand2_x0p41: 2-input NAND
* GENERATED from part1/cells/library.py. Do not edit by hand.
.subckt nand2_x0p41 i0 i1 y vdd gnd
Mp1 y i0 vdd vdd CMOSP W=7.2000e-07 L=1.8000e-07 AS=3.8880e-13 PS=2.5200e-06 AD=3.8880e-13 PD=2.5200e-06
Mp2 y i1 vdd vdd CMOSP W=7.2000e-07 L=1.8000e-07 AS=3.8880e-13 PS=2.5200e-06 AD=3.8880e-13 PD=2.5200e-06
Mn1 y i0 xn1 gnd CMOSN W=7.2000e-07 L=1.8000e-07 AS=1.9440e-13 PS=1.9800e-06 AD=3.8880e-13 PD=2.5200e-06
Mn2 xn1 i1 gnd gnd CMOSN W=7.2000e-07 L=1.8000e-07 AS=3.8880e-13 PS=2.5200e-06 AD=1.9440e-13 PD=1.9800e-06
.ends nand2_x0p41
* nor2_x1p95: 2-input NOR
* GENERATED from part1/cells/library.py. Do not edit by hand.
.subckt nor2_x1p95 i0 i1 y vdd gnd
Mp1 xp1 i0 vdd vdd CMOSP W=7.0200e-06 L=1.8000e-07 AS=3.7908e-12 PS=1.5120e-05 AD=1.8954e-12 PD=1.4580e-05
Mp2 y i1 xp1 vdd CMOSP W=7.0200e-06 L=1.8000e-07 AS=1.8954e-12 PS=1.4580e-05 AD=3.7908e-12 PD=1.5120e-05
Mn1 y i0 gnd gnd CMOSN W=1.8000e-06 L=1.8000e-07 AS=9.7200e-13 PS=4.6800e-06 AD=9.7200e-13 PD=4.6800e-06
Mn2 y i1 gnd gnd CMOSN W=1.8000e-06 L=1.8000e-07 AS=9.7200e-13 PS=4.6800e-06 AD=9.7200e-13 PD=4.6800e-06
.ends nor2_x1p95
* aoi21_x0p33: NOT(a b + c)
* GENERATED from part1/cells/library.py. Do not edit by hand.
.subckt aoi21_x0p33 a b c y vdd gnd
Mp1 xp1 a vdd vdd CMOSP W=1.1700e-06 L=1.8000e-07 AS=6.3180e-13 PS=3.4200e-06 AD=6.3180e-13 PD=3.4200e-06
Mp2 xp1 b vdd vdd CMOSP W=1.1700e-06 L=1.8000e-07 AS=6.3180e-13 PS=3.4200e-06 AD=6.3180e-13 PD=3.4200e-06
Mp3 y c xp1 vdd CMOSP W=1.1700e-06 L=1.8000e-07 AS=6.3180e-13 PS=3.4200e-06 AD=6.3180e-13 PD=3.4200e-06
Mn1 y a xn1 gnd CMOSN W=6.3000e-07 L=1.8000e-07 AS=1.7010e-13 PS=1.8000e-06 AD=3.4020e-13 PD=2.3400e-06
Mn2 xn1 b gnd gnd CMOSN W=6.3000e-07 L=1.8000e-07 AS=3.4020e-13 PS=2.3400e-06 AD=1.7010e-13 PD=1.8000e-06
Mn3 y c gnd gnd CMOSN W=2.7000e-07 L=1.8000e-07 AS=1.4580e-13 PS=1.6200e-06 AD=1.4580e-13 PD=1.6200e-06
.ends aoi21_x0p33
* nand2_x0p8: 2-input NAND
* GENERATED from part1/cells/library.py. Do not edit by hand.
.subckt nand2_x0p8 i0 i1 y vdd gnd
Mp1 y i0 vdd vdd CMOSP W=1.4400e-06 L=1.8000e-07 AS=7.7760e-13 PS=3.9600e-06 AD=7.7760e-13 PD=3.9600e-06
Mp2 y i1 vdd vdd CMOSP W=1.4400e-06 L=1.8000e-07 AS=7.7760e-13 PS=3.9600e-06 AD=7.7760e-13 PD=3.9600e-06
Mn1 y i0 xn1 gnd CMOSN W=1.4400e-06 L=1.8000e-07 AS=3.8880e-13 PS=3.4200e-06 AD=7.7760e-13 PD=3.9600e-06
Mn2 xn1 i1 gnd gnd CMOSN W=1.4400e-06 L=1.8000e-07 AS=7.7760e-13 PS=3.9600e-06 AD=3.8880e-13 PD=3.4200e-06
.ends nand2_x0p8
* nand2_x1: 2-input NAND
* GENERATED from part1/cells/library.py. Do not edit by hand.
.subckt nand2_x1 i0 i1 y vdd gnd
Mp1 y i0 vdd vdd CMOSP W=1.8000e-06 L=1.8000e-07 AS=9.7200e-13 PS=4.6800e-06 AD=9.7200e-13 PD=4.6800e-06
Mp2 y i1 vdd vdd CMOSP W=1.8000e-06 L=1.8000e-07 AS=9.7200e-13 PS=4.6800e-06 AD=9.7200e-13 PD=4.6800e-06
Mn1 y i0 xn1 gnd CMOSN W=1.8000e-06 L=1.8000e-07 AS=4.8600e-13 PS=4.1400e-06 AD=9.7200e-13 PD=4.6800e-06
Mn2 xn1 i1 gnd gnd CMOSN W=1.8000e-06 L=1.8000e-07 AS=9.7200e-13 PS=4.6800e-06 AD=4.8600e-13 PD=4.1400e-06
.ends nand2_x1
* nor2_x1p56: 2-input NOR
* GENERATED from part1/cells/library.py. Do not edit by hand.
.subckt nor2_x1p56 i0 i1 y vdd gnd
Mp1 xp1 i0 vdd vdd CMOSP W=5.5800e-06 L=1.8000e-07 AS=3.0132e-12 PS=1.2240e-05 AD=1.5066e-12 PD=1.1700e-05
Mp2 y i1 xp1 vdd CMOSP W=5.5800e-06 L=1.8000e-07 AS=1.5066e-12 PS=1.1700e-05 AD=3.0132e-12 PD=1.2240e-05
Mn1 y i0 gnd gnd CMOSN W=1.4400e-06 L=1.8000e-07 AS=7.7760e-13 PS=3.9600e-06 AD=7.7760e-13 PD=3.9600e-06
Mn2 y i1 gnd gnd CMOSN W=1.4400e-06 L=1.8000e-07 AS=7.7760e-13 PS=3.9600e-06 AD=7.7760e-13 PD=3.9600e-06
.ends nor2_x1p56
* aoi21_x1: NOT(a b + c)
* GENERATED from part1/cells/library.py. Do not edit by hand.
.subckt aoi21_x1 a b c y vdd gnd
Mp1 xp1 a vdd vdd CMOSP W=3.6000e-06 L=1.8000e-07 AS=1.9440e-12 PS=8.2800e-06 AD=1.9440e-12 PD=8.2800e-06
Mp2 xp1 b vdd vdd CMOSP W=3.6000e-06 L=1.8000e-07 AS=1.9440e-12 PS=8.2800e-06 AD=1.9440e-12 PD=8.2800e-06
Mp3 y c xp1 vdd CMOSP W=3.6000e-06 L=1.8000e-07 AS=1.9440e-12 PS=8.2800e-06 AD=1.9440e-12 PD=8.2800e-06
Mn1 y a xn1 gnd CMOSN W=1.8000e-06 L=1.8000e-07 AS=4.8600e-13 PS=4.1400e-06 AD=9.7200e-13 PD=4.6800e-06
Mn2 xn1 b gnd gnd CMOSN W=1.8000e-06 L=1.8000e-07 AS=9.7200e-13 PS=4.6800e-06 AD=4.8600e-13 PD=4.1400e-06
Mn3 y c gnd gnd CMOSN W=9.0000e-07 L=1.8000e-07 AS=4.8600e-13 PS=2.8800e-06 AD=4.8600e-13 PD=2.8800e-06
.ends aoi21_x1
* oai21_x0p8: NOT((a + b) c)
* GENERATED from part1/cells/library.py. Do not edit by hand.
.subckt oai21_x0p8 a b c y vdd gnd
Mp1 xp1 a vdd vdd CMOSP W=2.8800e-06 L=1.8000e-07 AS=1.5552e-12 PS=6.8400e-06 AD=7.7760e-13 PD=6.3000e-06
Mp2 y b xp1 vdd CMOSP W=2.8800e-06 L=1.8000e-07 AS=7.7760e-13 PS=6.3000e-06 AD=1.5552e-12 PD=6.8400e-06
Mp3 y c vdd vdd CMOSP W=1.4400e-06 L=1.8000e-07 AS=7.7760e-13 PS=3.9600e-06 AD=7.7760e-13 PD=3.9600e-06
Mn1 y a xn1 gnd CMOSN W=1.4400e-06 L=1.8000e-07 AS=7.7760e-13 PS=3.9600e-06 AD=7.7760e-13 PD=3.9600e-06
Mn2 y b xn1 gnd CMOSN W=1.4400e-06 L=1.8000e-07 AS=7.7760e-13 PS=3.9600e-06 AD=7.7760e-13 PD=3.9600e-06
Mn3 xn1 c gnd gnd CMOSN W=1.4400e-06 L=1.8000e-07 AS=7.7760e-13 PS=3.9600e-06 AD=7.7760e-13 PD=3.9600e-06
.ends oai21_x0p8
* inv_x2p44: inverter
* GENERATED from part1/cells/library.py. Do not edit by hand.
.subckt inv_x2p44 a y vdd gnd
Mp1 y a vdd vdd CMOSP W=4.4100e-06 L=1.8000e-07 AS=2.3814e-12 PS=9.9000e-06 AD=2.3814e-12 PD=9.9000e-06
Mn1 y a gnd gnd CMOSN W=2.1600e-06 L=1.8000e-07 AS=1.1664e-12 PS=5.4000e-06 AD=1.1664e-12 PD=5.4000e-06
.ends inv_x2p44
* c1_x0p51: C1 complex gate, stack 2
* GENERATED from part1/cells/library.py. Do not edit by hand.
.subckt c1_x0p51 g0b t0b c0b c1 vdd gnd
Mp1 c1 g0b vdd vdd CMOSP W=9.0000e-07 L=1.8000e-07 AS=4.8600e-13 PS=2.8800e-06 AD=4.8600e-13 PD=2.8800e-06
Mp2 xp1 t0b vdd vdd CMOSP W=1.8000e-06 L=1.8000e-07 AS=9.7200e-13 PS=4.6800e-06 AD=4.8600e-13 PD=4.1400e-06
Mp3 c1 c0b xp1 vdd CMOSP W=1.8000e-06 L=1.8000e-07 AS=4.8600e-13 PS=4.1400e-06 AD=9.7200e-13 PD=4.6800e-06
Mn1 c1 g0b xn1 gnd CMOSN W=9.0000e-07 L=1.8000e-07 AS=4.8600e-13 PS=2.8800e-06 AD=4.8600e-13 PD=2.8800e-06
Mn2 xn1 t0b gnd gnd CMOSN W=9.0000e-07 L=1.8000e-07 AS=4.8600e-13 PS=2.8800e-06 AD=4.8600e-13 PD=2.8800e-06
Mn3 xn1 c0b gnd gnd CMOSN W=9.0000e-07 L=1.8000e-07 AS=4.8600e-13 PS=2.8800e-06 AD=4.8600e-13 PD=2.8800e-06
.ends c1_x0p51
* c2_x0p41: C2 complex gate, stack 3
* GENERATED from part1/cells/library.py. Do not edit by hand.
.subckt c2_x0p41 g0b t0b g1b t1b c0b c2 vdd gnd
Mp1 c2 g1b vdd vdd CMOSP W=7.2000e-07 L=1.8000e-07 AS=3.8880e-13 PS=2.5200e-06 AD=3.8880e-13 PD=2.5200e-06
Mp2 xp1 t1b vdd vdd CMOSP W=2.2500e-06 L=1.8000e-07 AS=1.2150e-12 PS=5.5800e-06 AD=1.2150e-12 PD=5.5800e-06
Mp3 c2 g0b xp1 vdd CMOSP W=1.4400e-06 L=1.8000e-07 AS=7.7760e-13 PS=3.9600e-06 AD=7.7760e-13 PD=3.9600e-06
Mp4 xp2 t0b xp1 vdd CMOSP W=2.2500e-06 L=1.8000e-07 AS=1.2150e-12 PS=5.5800e-06 AD=6.0750e-13 PD=5.0400e-06
Mp5 c2 c0b xp2 vdd CMOSP W=2.2500e-06 L=1.8000e-07 AS=6.0750e-13 PS=5.0400e-06 AD=1.2150e-12 PD=5.5800e-06
Mn1 c2 g1b xn1 gnd CMOSN W=1.0800e-06 L=1.8000e-07 AS=5.8320e-13 PS=3.2400e-06 AD=5.8320e-13 PD=3.2400e-06
Mn2 xn1 t1b gnd gnd CMOSN W=7.2000e-07 L=1.8000e-07 AS=3.8880e-13 PS=2.5200e-06 AD=3.8880e-13 PD=2.5200e-06
Mn3 xn1 g0b xn2 gnd CMOSN W=1.0800e-06 L=1.8000e-07 AS=5.8320e-13 PS=3.2400e-06 AD=5.8320e-13 PD=3.2400e-06
Mn4 xn2 t0b gnd gnd CMOSN W=1.0800e-06 L=1.8000e-07 AS=5.8320e-13 PS=3.2400e-06 AD=5.8320e-13 PD=3.2400e-06
Mn5 xn2 c0b gnd gnd CMOSN W=1.0800e-06 L=1.8000e-07 AS=5.8320e-13 PS=3.2400e-06 AD=5.8320e-13 PD=3.2400e-06
.ends c2_x0p41
* c3_x0p51: C3 complex gate, stack 4
* GENERATED from part1/cells/library.py. Do not edit by hand.
.subckt c3_x0p51 g0b t0b g1b t1b g2b t2b c0b c3 vdd gnd
Mp1 c3 g2b vdd vdd CMOSP W=9.0000e-07 L=1.8000e-07 AS=4.8600e-13 PS=2.8800e-06 AD=4.8600e-13 PD=2.8800e-06
Mp2 xp1 t2b vdd vdd CMOSP W=3.6900e-06 L=1.8000e-07 AS=1.9926e-12 PS=8.4600e-06 AD=1.9926e-12 PD=8.4600e-06
Mp3 c3 g1b xp1 vdd CMOSP W=1.8000e-06 L=1.8000e-07 AS=9.7200e-13 PS=4.6800e-06 AD=9.7200e-13 PD=4.6800e-06
Mp4 xp2 t1b xp1 vdd CMOSP W=3.6900e-06 L=1.8000e-07 AS=1.9926e-12 PS=8.4600e-06 AD=1.9926e-12 PD=8.4600e-06
Mp5 c3 g0b xp2 vdd CMOSP W=2.7900e-06 L=1.8000e-07 AS=1.5066e-12 PS=6.6600e-06 AD=1.5066e-12 PD=6.6600e-06
Mp6 xp3 t0b xp2 vdd CMOSP W=3.6900e-06 L=1.8000e-07 AS=1.9926e-12 PS=8.4600e-06 AD=9.9630e-13 PD=7.9200e-06
Mp7 c3 c0b xp3 vdd CMOSP W=3.6900e-06 L=1.8000e-07 AS=9.9630e-13 PS=7.9200e-06 AD=1.9926e-12 PD=8.4600e-06
Mn1 c3 g2b xn1 gnd CMOSN W=1.8000e-06 L=1.8000e-07 AS=9.7200e-13 PS=4.6800e-06 AD=9.7200e-13 PD=4.6800e-06
Mn2 xn1 t2b gnd gnd CMOSN W=9.0000e-07 L=1.8000e-07 AS=4.8600e-13 PS=2.8800e-06 AD=4.8600e-13 PD=2.8800e-06
Mn3 xn1 g1b xn2 gnd CMOSN W=1.8000e-06 L=1.8000e-07 AS=9.7200e-13 PS=4.6800e-06 AD=9.7200e-13 PD=4.6800e-06
Mn4 xn2 t1b gnd gnd CMOSN W=1.3500e-06 L=1.8000e-07 AS=7.2900e-13 PS=3.7800e-06 AD=7.2900e-13 PD=3.7800e-06
Mn5 xn2 g0b xn3 gnd CMOSN W=1.8000e-06 L=1.8000e-07 AS=9.7200e-13 PS=4.6800e-06 AD=9.7200e-13 PD=4.6800e-06
Mn6 xn3 t0b gnd gnd CMOSN W=1.8000e-06 L=1.8000e-07 AS=9.7200e-13 PS=4.6800e-06 AD=9.7200e-13 PD=4.6800e-06
Mn7 xn3 c0b gnd gnd CMOSN W=1.8000e-06 L=1.8000e-07 AS=9.7200e-13 PS=4.6800e-06 AD=9.7200e-13 PD=4.6800e-06
.ends c3_x0p51
* c4_x0p33: C4 complex gate, stack 5
* GENERATED from part1/cells/library.py. Do not edit by hand.
.subckt c4_x0p33 g0b t0b g1b t1b g2b t2b g3b t3b c0b c4 vdd gnd
Mp1 c4 g3b vdd vdd CMOSP W=6.3000e-07 L=1.8000e-07 AS=3.4020e-13 PS=2.3400e-06 AD=3.4020e-13 PD=2.3400e-06
Mp2 xp1 t3b vdd vdd CMOSP W=2.9700e-06 L=1.8000e-07 AS=1.6038e-12 PS=7.0200e-06 AD=1.6038e-12 PD=7.0200e-06
Mp3 c4 g2b xp1 vdd CMOSP W=1.1700e-06 L=1.8000e-07 AS=6.3180e-13 PS=3.4200e-06 AD=6.3180e-13 PD=3.4200e-06
Mp4 xp2 t2b xp1 vdd CMOSP W=2.9700e-06 L=1.8000e-07 AS=1.6038e-12 PS=7.0200e-06 AD=1.6038e-12 PD=7.0200e-06
Mp5 c4 g1b xp2 vdd CMOSP W=1.8000e-06 L=1.8000e-07 AS=9.7200e-13 PS=4.6800e-06 AD=9.7200e-13 PD=4.6800e-06
Mp6 xp3 t1b xp2 vdd CMOSP W=2.9700e-06 L=1.8000e-07 AS=1.6038e-12 PS=7.0200e-06 AD=1.6038e-12 PD=7.0200e-06
Mp7 c4 g0b xp3 vdd CMOSP W=2.3400e-06 L=1.8000e-07 AS=1.2636e-12 PS=5.7600e-06 AD=1.2636e-12 PD=5.7600e-06
Mp8 xp4 t0b xp3 vdd CMOSP W=2.9700e-06 L=1.8000e-07 AS=1.6038e-12 PS=7.0200e-06 AD=8.0190e-13 PD=6.4800e-06
Mp9 c4 c0b xp4 vdd CMOSP W=2.9700e-06 L=1.8000e-07 AS=8.0190e-13 PS=6.4800e-06 AD=1.6038e-12 PD=7.0200e-06
Mn1 c4 g3b xn1 gnd CMOSN W=1.4400e-06 L=1.8000e-07 AS=7.7760e-13 PS=3.9600e-06 AD=7.7760e-13 PD=3.9600e-06
Mn2 xn1 t3b gnd gnd CMOSN W=6.3000e-07 L=1.8000e-07 AS=3.4020e-13 PS=2.3400e-06 AD=3.4020e-13 PD=2.3400e-06
Mn3 xn1 g2b xn2 gnd CMOSN W=1.4400e-06 L=1.8000e-07 AS=7.7760e-13 PS=3.9600e-06 AD=7.7760e-13 PD=3.9600e-06
Mn4 xn2 t2b gnd gnd CMOSN W=9.0000e-07 L=1.8000e-07 AS=4.8600e-13 PS=2.8800e-06 AD=4.8600e-13 PD=2.8800e-06
Mn5 xn2 g1b xn3 gnd CMOSN W=1.4400e-06 L=1.8000e-07 AS=7.7760e-13 PS=3.9600e-06 AD=7.7760e-13 PD=3.9600e-06
Mn6 xn3 t1b gnd gnd CMOSN W=1.1700e-06 L=1.8000e-07 AS=6.3180e-13 PS=3.4200e-06 AD=6.3180e-13 PD=3.4200e-06
Mn7 xn3 g0b xn4 gnd CMOSN W=1.4400e-06 L=1.8000e-07 AS=7.7760e-13 PS=3.9600e-06 AD=7.7760e-13 PD=3.9600e-06
Mn8 xn4 t0b gnd gnd CMOSN W=1.4400e-06 L=1.8000e-07 AS=7.7760e-13 PS=3.9600e-06 AD=7.7760e-13 PD=3.9600e-06
Mn9 xn4 c0b gnd gnd CMOSN W=1.4400e-06 L=1.8000e-07 AS=7.7760e-13 PS=3.9600e-06 AD=7.7760e-13 PD=3.9600e-06
.ends c4_x0p33
* xor_tg_x1p25: transmission-gate mux XOR with output inverter
* GENERATED from part1/cells/library.py. Do not edit by hand.
.subckt xor_tg_x1p25 p pb c s vdd gnd
Ms0p1 cb c vdd vdd CMOSP W=2.2500e-06 L=1.8000e-07 AS=1.2150e-12 PS=5.5800e-06 AD=1.2150e-12 PD=5.5800e-06
Ms0n1 cb c gnd gnd CMOSN W=1.0800e-06 L=1.8000e-07 AS=5.8320e-13 PS=3.2400e-06 AD=5.8320e-13 PD=3.2400e-06
Ms1n p c m gnd CMOSN W=9.0000e-07 L=1.8000e-07 AS=4.8600e-13 PS=2.8800e-06 AD=4.8600e-13 PD=2.8800e-06
Ms1p p cb m vdd CMOSP W=1.8000e-06 L=1.8000e-07 AS=9.7200e-13 PS=4.6800e-06 AD=9.7200e-13 PD=4.6800e-06
Ms2n pb cb m gnd CMOSN W=9.0000e-07 L=1.8000e-07 AS=4.8600e-13 PS=2.8800e-06 AD=4.8600e-13 PD=2.8800e-06
Ms2p pb c m vdd CMOSP W=1.8000e-06 L=1.8000e-07 AS=9.7200e-13 PS=4.6800e-06 AD=9.7200e-13 PD=4.6800e-06
Ms3p1 s m vdd vdd CMOSP W=2.2500e-06 L=1.8000e-07 AS=1.2150e-12 PS=5.5800e-06 AD=1.2150e-12 PD=5.5800e-06
Ms3n1 s m gnd gnd CMOSN W=1.0800e-06 L=1.8000e-07 AS=5.8320e-13 PS=3.2400e-06 AD=5.8320e-13 PD=3.2400e-06
.ends xor_tg_x1p25
* xor_tg_x1: transmission-gate mux XOR with output inverter
* GENERATED from part1/cells/library.py. Do not edit by hand.
.subckt xor_tg_x1 p pb c s vdd gnd
Ms0p1 cb c vdd vdd CMOSP W=1.8000e-06 L=1.8000e-07 AS=9.7200e-13 PS=4.6800e-06 AD=9.7200e-13 PD=4.6800e-06
Ms0n1 cb c gnd gnd CMOSN W=9.0000e-07 L=1.8000e-07 AS=4.8600e-13 PS=2.8800e-06 AD=4.8600e-13 PD=2.8800e-06
Ms1n p c m gnd CMOSN W=9.0000e-07 L=1.8000e-07 AS=4.8600e-13 PS=2.8800e-06 AD=4.8600e-13 PD=2.8800e-06
Ms1p p cb m vdd CMOSP W=1.8000e-06 L=1.8000e-07 AS=9.7200e-13 PS=4.6800e-06 AD=9.7200e-13 PD=4.6800e-06
Ms2n pb cb m gnd CMOSN W=9.0000e-07 L=1.8000e-07 AS=4.8600e-13 PS=2.8800e-06 AD=4.8600e-13 PD=2.8800e-06
Ms2p pb c m vdd CMOSP W=1.8000e-06 L=1.8000e-07 AS=9.7200e-13 PS=4.6800e-06 AD=9.7200e-13 PD=4.6800e-06
Ms3p1 s m vdd vdd CMOSP W=1.8000e-06 L=1.8000e-07 AS=9.7200e-13 PS=4.6800e-06 AD=9.7200e-13 PD=4.6800e-06
Ms3n1 s m gnd gnd CMOSN W=9.0000e-07 L=1.8000e-07 AS=4.8600e-13 PS=2.8800e-06 AD=4.8600e-13 PD=2.8800e-06
.ends xor_tg_x1
* xor_tg_x0p8_0p64_0p51: transmission-gate mux XOR with output inverter
* GENERATED from part1/cells/library.py. Do not edit by hand.
.subckt xor_tg_x0p8_0p64_0p51 p pb c s vdd gnd
Ms0p1 cb c vdd vdd CMOSP W=1.1700e-06 L=1.8000e-07 AS=6.3180e-13 PS=3.4200e-06 AD=6.3180e-13 PD=3.4200e-06
Ms0n1 cb c gnd gnd CMOSN W=5.4000e-07 L=1.8000e-07 AS=2.9160e-13 PS=2.1600e-06 AD=2.9160e-13 PD=2.1600e-06
Ms1n p c m gnd CMOSN W=4.5000e-07 L=1.8000e-07 AS=2.4300e-13 PS=1.9800e-06 AD=2.4300e-13 PD=1.9800e-06
Ms1p p cb m vdd CMOSP W=9.0000e-07 L=1.8000e-07 AS=4.8600e-13 PS=2.8800e-06 AD=4.8600e-13 PD=2.8800e-06
Ms2n pb cb m gnd CMOSN W=4.5000e-07 L=1.8000e-07 AS=2.4300e-13 PS=1.9800e-06 AD=2.4300e-13 PD=1.9800e-06
Ms2p pb c m vdd CMOSP W=9.0000e-07 L=1.8000e-07 AS=4.8600e-13 PS=2.8800e-06 AD=4.8600e-13 PD=2.8800e-06
Ms3p1 s m vdd vdd CMOSP W=1.4400e-06 L=1.8000e-07 AS=7.7760e-13 PS=3.9600e-06 AD=7.7760e-13 PD=3.9600e-06
Ms3n1 s m gnd gnd CMOSN W=7.2000e-07 L=1.8000e-07 AS=3.8880e-13 PS=2.5200e-06 AD=3.8880e-13 PD=2.5200e-06
.ends xor_tg_x0p8_0p64_0p51
* xor_tg_x0p8_0p8_0p51: transmission-gate mux XOR with output inverter
* GENERATED from part1/cells/library.py. Do not edit by hand.
.subckt xor_tg_x0p8_0p8_0p51 p pb c s vdd gnd
Ms0p1 cb c vdd vdd CMOSP W=1.4400e-06 L=1.8000e-07 AS=7.7760e-13 PS=3.9600e-06 AD=7.7760e-13 PD=3.9600e-06
Ms0n1 cb c gnd gnd CMOSN W=7.2000e-07 L=1.8000e-07 AS=3.8880e-13 PS=2.5200e-06 AD=3.8880e-13 PD=2.5200e-06
Ms1n p c m gnd CMOSN W=4.5000e-07 L=1.8000e-07 AS=2.4300e-13 PS=1.9800e-06 AD=2.4300e-13 PD=1.9800e-06
Ms1p p cb m vdd CMOSP W=9.0000e-07 L=1.8000e-07 AS=4.8600e-13 PS=2.8800e-06 AD=4.8600e-13 PD=2.8800e-06
Ms2n pb cb m gnd CMOSN W=4.5000e-07 L=1.8000e-07 AS=2.4300e-13 PS=1.9800e-06 AD=2.4300e-13 PD=1.9800e-06
Ms2p pb c m vdd CMOSP W=9.0000e-07 L=1.8000e-07 AS=4.8600e-13 PS=2.8800e-06 AD=4.8600e-13 PD=2.8800e-06
Ms3p1 s m vdd vdd CMOSP W=1.4400e-06 L=1.8000e-07 AS=7.7760e-13 PS=3.9600e-06 AD=7.7760e-13 PD=3.9600e-06
Ms3n1 s m gnd gnd CMOSN W=7.2000e-07 L=1.8000e-07 AS=3.8880e-13 PS=2.5200e-06 AD=3.8880e-13 PD=2.5200e-06
.ends xor_tg_x0p8_0p8_0p51
* cla_C2_tg_t: Candidate C2: one complex gate per carry, stack up to 5
* GENERATED from part1/cells/library.py. Do not edit by hand.
.subckt cla_C2_tg_t a0 a1 a2 a3 b0 b1 b2 b3 c0 s0 s1 s2 s3 c4 vdd gnd
Xnand0 a0 b0 g0b vdd gnd nand2_x0p74
Xnor0 a0 b0 t0b vdd gnd nor2_x1p25
Xaoi0 a0 b0 t0b p0 vdd gnd aoi21_x0p41
Xoai0 a0 b0 g0b p0b vdd gnd oai21_x0p41
Xnand1 a1 b1 g1b vdd gnd nand2_x0p41
Xnor1 a1 b1 t1b vdd gnd nor2_x1p95
Xaoi1 a1 b1 t1b p1 vdd gnd aoi21_x0p33
Xoai1 a1 b1 g1b p1b vdd gnd oai21_x0p41
Xnand2 a2 b2 g2b vdd gnd nand2_x0p8
Xnor2 a2 b2 t2b vdd gnd nor2_x1p95
Xaoi2 a2 b2 t2b p2 vdd gnd aoi21_x0p41
Xoai2 a2 b2 g2b p2b vdd gnd oai21_x0p41
Xnand3 a3 b3 g3b vdd gnd nand2_x1
Xnor3 a3 b3 t3b vdd gnd nor2_x1p56
Xaoi3 a3 b3 t3b p3 vdd gnd aoi21_x1
Xoai3 a3 b3 g3b p3b vdd gnd oai21_x0p8
Xinvc0 c0 c0b vdd gnd inv_x2p44
Xc1 g0b t0b c0b c1 vdd gnd c1_x0p51
Xc2 g0b t0b g1b t1b c0b c2 vdd gnd c2_x0p41
Xc3 g0b t0b g1b t1b g2b t2b c0b c3 vdd gnd c3_x0p51
Xc4 g0b t0b g1b t1b g2b t2b g3b t3b c0b c4 vdd gnd c4_x0p33
Xx0 p0 p0b c0 s0 vdd gnd xor_tg_x1p25
Xx1 p1 p1b c1 s1 vdd gnd xor_tg_x1
Xx2 p2 p2b c2 s2 vdd gnd xor_tg_x0p8_0p64_0p51
Xx3 p3 p3b c3 s3 vdd gnd xor_tg_x0p8_0p8_0p51
.ends cla_C2_tg_t
.subckt tb_x1 a y vdd gnd
mp y a vdd vdd CMOSP W=1.8e-06 L=1.8e-07 AS=9.72e-13 PS=4.68e-06 AD=9.72e-13 PD=4.68e-06
mn y a gnd gnd CMOSN W=9.0e-07 L=1.8e-07 AS=4.86e-13 PS=2.88e-06 AD=4.86e-13 PD=2.88e-06
.ends
.subckt tb_x2 a y vdd gnd
mp y a vdd vdd CMOSP W=3.6e-06 L=1.8e-07 AS=1.944e-12 PS=8.28e-06 AD=1.944e-12 PD=8.28e-06
mn y a gnd gnd CMOSN W=1.8e-06 L=1.8e-07 AS=9.72e-13 PS=4.68e-06 AD=9.72e-13 PD=4.68e-06
.ends
Va0 src_a0 gnd PWL(
+ 0.00000e+00 1.800 6.40000e-09 1.800 6.42000e-09 0.000 9.60000e-09 0.000 9.62000e-09 1.800 1.60000e-08 1.800
+ 1.60200e-08 0.000 5.44000e-08 0.000 5.44200e-08 1.800 6.08000e-08 1.800 6.08200e-08 0.000 6.72000e-08 0.000
+ 6.72200e-08 1.800 7.36000e-08 1.800 7.36200e-08 0.000 7.68000e-08 0.000 7.68200e-08 1.800 8.00000e-08 1.800
+ 8.00200e-08 0.000 8.96000e-08 0.000 8.96200e-08 1.800 9.12000e-08 1.800 9.12200e-08 0.000 9.28000e-08 0.000
+ 9.28200e-08 1.800 9.60000e-08 1.800 9.60200e-08 0.000 1.02400e-07 0.000 1.02420e-07 1.800 1.07200e-07 1.800
+ 1.07220e-07 0.000 1.12000e-07 0.000 1.12020e-07 1.800 1.15200e-07 1.800
+ )
Xs_a0 src_a0 drv_a0 vdd gnd tb_x1
Xd_a0 drv_a0 a0 vdd gnd tb_x2
Va1 src_a1 gnd PWL(
+ 0.00000e+00 1.800 6.40000e-09 1.800 6.42000e-09 0.000 9.60000e-09 0.000 9.62000e-09 1.800 1.60000e-08 1.800
+ 1.60200e-08 0.000 1.76000e-08 0.000 1.76200e-08 1.800 1.92000e-08 1.800 1.92200e-08 0.000 2.08000e-08 0.000
+ 2.08200e-08 1.800 2.24000e-08 1.800 2.24200e-08 0.000 4.00000e-08 0.000 4.00200e-08 1.800 4.16000e-08 1.800
+ 4.16200e-08 0.000 4.48000e-08 0.000 4.48200e-08 1.800 4.96000e-08 1.800 4.96200e-08 0.000 5.12000e-08 0.000
+ 5.12200e-08 1.800 5.76000e-08 1.800 5.76200e-08 0.000 6.08000e-08 0.000 6.08200e-08 1.800 6.24000e-08 1.800
+ 6.24200e-08 0.000 6.56000e-08 0.000 6.56200e-08 1.800 8.16000e-08 1.800 8.16200e-08 0.000 8.64000e-08 0.000
+ 8.64200e-08 1.800 8.96000e-08 1.800 8.96200e-08 0.000 9.76000e-08 0.000 9.76200e-08 1.800 1.00800e-07 1.800
+ 1.00820e-07 0.000 1.15200e-07 0.000
+ )
Xs_a1 src_a1 drv_a1 vdd gnd tb_x1
Xd_a1 drv_a1 a1 vdd gnd tb_x2
Va2 src_a2 gnd PWL(
+ 0.00000e+00 1.800 3.20000e-09 1.800 3.22000e-09 0.000 4.80000e-09 0.000 4.82000e-09 1.800 6.40000e-09 1.800
+ 6.42000e-09 0.000 1.12000e-08 0.000 1.12200e-08 1.800 1.28000e-08 1.800 1.28200e-08 0.000 1.44000e-08 0.000
+ 1.44200e-08 1.800 1.60000e-08 1.800 1.60200e-08 0.000 1.92000e-08 0.000 1.92200e-08 1.800 2.24000e-08 1.800
+ 2.24200e-08 0.000 3.20000e-08 0.000 3.20200e-08 1.800 3.84000e-08 1.800 3.84200e-08 0.000 4.16000e-08 0.000
+ 4.16200e-08 1.800 4.48000e-08 1.800 4.48200e-08 0.000 5.44000e-08 0.000 5.44200e-08 1.800 5.60000e-08 1.800
+ 5.60200e-08 0.000 5.76000e-08 0.000 5.76200e-08 1.800 6.08000e-08 1.800 6.08200e-08 0.000 6.72000e-08 0.000
+ 6.72200e-08 1.800 6.88000e-08 1.800 6.88200e-08 0.000 8.32000e-08 0.000 8.32200e-08 1.800 9.28000e-08 1.800
+ 9.28200e-08 0.000 9.60000e-08 0.000 9.60200e-08 1.800 1.05600e-07 1.800 1.05620e-07 0.000 1.15200e-07 0.000
+ )
Xs_a2 src_a2 drv_a2 vdd gnd tb_x1
Xd_a2 drv_a2 a2 vdd gnd tb_x2
Va3 src_a3 gnd PWL(
+ 0.00000e+00 0.000 1.60000e-09 0.000 1.62000e-09 1.800 6.40000e-09 1.800 6.42000e-09 0.000 9.60000e-09 0.000
+ 9.62000e-09 1.800 1.28000e-08 1.800 1.28200e-08 0.000 1.60000e-08 0.000 1.60200e-08 1.800 4.48000e-08 1.800
+ 4.48200e-08 0.000 5.12000e-08 0.000 5.12200e-08 1.800 5.44000e-08 1.800 5.44200e-08 0.000 5.76000e-08 0.000
+ 5.76200e-08 1.800 7.04000e-08 1.800 7.04200e-08 0.000 7.36000e-08 0.000 7.36200e-08 1.800 8.00000e-08 1.800
+ 8.00200e-08 0.000 8.32000e-08 0.000 8.32200e-08 1.800 8.96000e-08 1.800 8.96200e-08 0.000 9.28000e-08 0.000
+ 9.28200e-08 1.800 1.15200e-07 1.800
+ )
Xs_a3 src_a3 drv_a3 vdd gnd tb_x1
Xd_a3 drv_a3 a3 vdd gnd tb_x2
Vb0 src_b0 gnd PWL(
+ 0.00000e+00 0.000 6.40000e-09 0.000 6.42000e-09 1.800 9.60000e-09 1.800 9.62000e-09 0.000 1.60000e-08 0.000
+ 1.60200e-08 1.800 4.48000e-08 1.800 4.48200e-08 0.000 5.44000e-08 0.000 5.44200e-08 1.800 5.92000e-08 1.800
+ 5.92200e-08 0.000 6.40000e-08 0.000 6.40200e-08 1.800 7.36000e-08 1.800 7.36200e-08 0.000 7.68000e-08 0.000
+ 7.68200e-08 1.800 8.00000e-08 1.800 8.00200e-08 0.000 8.32000e-08 0.000 8.32200e-08 1.800 8.64000e-08 1.800
+ 8.64200e-08 0.000 8.96000e-08 0.000 8.96200e-08 1.800 9.44000e-08 1.800 9.44200e-08 0.000 9.60000e-08 0.000
+ 9.60200e-08 1.800 9.92000e-08 1.800 9.92200e-08 0.000 1.02400e-07 0.000 1.02420e-07 1.800 1.04000e-07 1.800
+ 1.04020e-07 0.000 1.05600e-07 0.000 1.05620e-07 1.800 1.12000e-07 1.800 1.12020e-07 0.000 1.15200e-07 0.000
+ )
Xs_b0 src_b0 drv_b0 vdd gnd tb_x1
Xd_b0 drv_b0 b0 vdd gnd tb_x2
Vb1 src_b1 gnd PWL(
+ 0.00000e+00 0.000 6.40000e-09 0.000 6.42000e-09 1.800 9.60000e-09 1.800 9.62000e-09 0.000 2.24000e-08 0.000
+ 2.24200e-08 1.800 3.20000e-08 1.800 3.20200e-08 0.000 3.36000e-08 0.000 3.36200e-08 1.800 3.52000e-08 1.800
+ 3.52200e-08 0.000 3.68000e-08 0.000 3.68200e-08 1.800 3.84000e-08 1.800 3.84200e-08 0.000 4.32000e-08 0.000
+ 4.32200e-08 1.800 4.64000e-08 1.800 4.64200e-08 0.000 4.80000e-08 0.000 4.80200e-08 1.800 5.28000e-08 1.800
+ 5.28200e-08 0.000 5.76000e-08 0.000 5.76200e-08 1.800 6.40000e-08 1.800 6.40200e-08 0.000 7.36000e-08 0.000
+ 7.36200e-08 1.800 7.52000e-08 1.800 7.52200e-08 0.000 8.00000e-08 0.000 8.00200e-08 1.800 8.32000e-08 1.800
+ 8.32200e-08 0.000 8.48000e-08 0.000 8.48200e-08 1.800 8.80000e-08 1.800 8.80200e-08 0.000 8.96000e-08 0.000
+ 8.96200e-08 1.800 9.60000e-08 1.800 9.60200e-08 0.000 9.92000e-08 0.000 9.92200e-08 1.800 1.15200e-07 1.800
+ )
Xs_b1 src_b1 drv_b1 vdd gnd tb_x1
Xd_b1 drv_b1 b1 vdd gnd tb_x2
Vb2 src_b2 gnd PWL(
+ 0.00000e+00 0.000 6.40000e-09 0.000 6.42000e-09 1.800 9.60000e-09 1.800 9.62000e-09 0.000 1.60000e-08 0.000
+ 1.60200e-08 1.800 1.92000e-08 1.800 1.92200e-08 0.000 2.40000e-08 0.000 2.40200e-08 1.800 2.56000e-08 1.800
+ 2.56200e-08 0.000 2.72000e-08 0.000 2.72200e-08 1.800 2.88000e-08 1.800 2.88200e-08 0.000 3.04000e-08 0.000
+ 3.04200e-08 1.800 3.20000e-08 1.800 3.20200e-08 0.000 3.84000e-08 0.000 3.84200e-08 1.800 4.16000e-08 1.800
+ 4.16200e-08 0.000 4.48000e-08 0.000 4.48200e-08 1.800 5.44000e-08 1.800 5.44200e-08 0.000 6.08000e-08 0.000
+ 6.08200e-08 1.800 6.72000e-08 1.800 6.72200e-08 0.000 7.04000e-08 0.000 7.04200e-08 1.800 7.20000e-08 1.800
+ 7.20200e-08 0.000 7.36000e-08 0.000 7.36200e-08 1.800 7.84000e-08 1.800 7.84200e-08 0.000 8.00000e-08 0.000
+ 8.00200e-08 1.800 8.32000e-08 1.800 8.32200e-08 0.000 8.64000e-08 0.000 8.64200e-08 1.800 8.96000e-08 1.800
+ 8.96200e-08 0.000 9.28000e-08 0.000 9.28200e-08 1.800 1.02400e-07 1.800 1.02420e-07 0.000 1.05600e-07 0.000
+ 1.05620e-07 1.800 1.15200e-07 1.800
+ )
Xs_b2 src_b2 drv_b2 vdd gnd tb_x1
Xd_b2 drv_b2 b2 vdd gnd tb_x2
Vb3 src_b3 gnd PWL(
+ 0.00000e+00 0.000 8.00000e-09 0.000 8.02000e-09 1.800 1.60000e-08 1.800 1.60200e-08 0.000 1.92000e-08 0.000
+ 1.92200e-08 1.800 2.24000e-08 1.800 2.24200e-08 0.000 2.56000e-08 0.000 2.56200e-08 1.800 2.88000e-08 1.800
+ 2.88200e-08 0.000 3.52000e-08 0.000 3.52200e-08 1.800 3.84000e-08 1.800 3.84200e-08 0.000 4.48000e-08 0.000
+ 4.48200e-08 1.800 5.76000e-08 1.800 5.76200e-08 0.000 6.08000e-08 0.000 6.08200e-08 1.800 6.40000e-08 1.800
+ 6.40200e-08 0.000 6.72000e-08 0.000 6.72200e-08 1.800 8.32000e-08 1.800 8.32200e-08 0.000 8.64000e-08 0.000
+ 8.64200e-08 1.800 1.02400e-07 1.800 1.02420e-07 0.000 1.05600e-07 0.000 1.05620e-07 1.800 1.08800e-07 1.800
+ 1.08820e-07 0.000 1.12000e-07 0.000 1.12020e-07 1.800 1.15200e-07 1.800
+ )
Xs_b3 src_b3 drv_b3 vdd gnd tb_x1
Xd_b3 drv_b3 b3 vdd gnd tb_x2
Vc0 src_c0 gnd PWL(
+ 0.00000e+00 1.800 5.76000e-08 1.800 5.76200e-08 0.000 6.08000e-08 0.000 6.08200e-08 1.800 8.96000e-08 1.800
+ 8.96200e-08 0.000 9.60000e-08 0.000 9.60200e-08 1.800 1.02400e-07 1.800 1.02420e-07 0.000 1.10400e-07 0.000
+ 1.10420e-07 1.800 1.12000e-07 1.800 1.12020e-07 0.000 1.13600e-07 0.000 1.13620e-07 1.800 1.15200e-07 1.800
+ )
Xs_c0 src_c0 drv_c0 vdd gnd tb_x1
Xd_c0 drv_c0 c0 vdd gnd tb_x2
Xl_s0 s0 lo_s0 vdd gnd tb_x1
Xl_s1 s1 lo_s1 vdd gnd tb_x1
Xl_s2 s2 lo_s2 vdd gnd tb_x1
Xl_s3 s3 lo_s3 vdd gnd tb_x1
Xl_c4 c4 lo_c4 vdd gnd tb_x1
X0 a0 a1 a2 a3 b0 b1 b2 b3 c0 s0 s1 s2 s3 c4 vdd gnd cla_C2_tg_t
.tran 20p 1.15200e-07
.control
set wr_singlescale
set wr_vecnames
run
wrdata s.txt v(a0) v(a1) v(a2) v(a3) v(b0) v(b1) v(b2) v(b3) v(c0) v(drv_a0) v(drv_a1) v(drv_a2) v(drv_a3) v(drv_b0) v(drv_b1) v(drv_b2) v(drv_b3) v(drv_c0) v(s0) v(s1) v(s2) v(s3) v(c4)
quit
.endc
.end
