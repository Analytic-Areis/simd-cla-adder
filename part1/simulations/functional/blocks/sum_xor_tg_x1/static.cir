* DC supply current of sum_xor_tg_x1
.include ../../../../spice/models/TSMC_180nm.txt
VDD vdd gnd 1.8
* xor_tg_x1: transmission-gate mux XOR with output inverter
* GENERATED from part1/cells/library.py. Do not edit by hand.
.subckt xor_tg_x1 p pb c s vdd gnd
Ms0p1 cb c vdd vdd CMOSP W=1.8000e-06 L=1.8000e-07 AS=9.7200e-13 PS=4.6800e-06 AD=9.7200e-13 PD=4.6800e-06
Ms0n1 cb c gnd gnd CMOSN W=9.0000e-07 L=1.8000e-07 AS=4.8600e-13 PS=2.8800e-06 AD=4.8600e-13 PD=2.8800e-06
Ms1n p c m gnd CMOSN W=9.0000e-07 L=1.8000e-07 AS=4.8600e-13 PS=2.8800e-06 AD=4.8600e-13 PD=2.8800e-06
Ms1p p cb m vdd CMOSP W=1.8000e-06 L=1.8000e-07 AS=9.7200e-13 PS=4.6800e-06 AD=9.7200e-13 PD=4.6800e-06
Ms2n pb cb m gnd CMOSN W=9.0000e-07 L=1.8000e-07 AS=4.8600e-13 PS=2.8800e-06 AD=4.8600e-13 PD=2.8800e-06
Ms2p pb c m vdd CMOSP W=1.8000e-06 L=1.8000e-07 AS=9.7200e-13 PS=4.6800e-06 AD=9.7200e-13 PD=4.6800e-06
Ms3p1 s m vdd vdd CMOSP W=1.8000e-06 L=1.8000e-07 AS=9.7200e-13 PS=4.6800e-06 AD=9.7200e-13 PD=4.6800e-06
Ms3n1 s m gnd gnd CMOSN W=9.0000e-07 L=1.8000e-07 AS=4.8600e-13 PS=2.8800e-06 AD=4.8600e-13 PD=2.8800e-06
.ends xor_tg_x1
* sum_xor_tg_x1: 4-bit sum block using xor_tg
* GENERATED from part1/cells/library.py. Do not edit by hand.
.subckt sum_xor_tg_x1 p0 p1 p2 p3 p0b p1b p2b p3b c0 c1 c2 c3 s0 s1 s2 s3 vdd gnd
Xsum0 p0 p0b c0 s0 vdd gnd xor_tg_x1
Xsum1 p1 p1b c1 s1 vdd gnd xor_tg_x1
Xsum2 p2 p2b c2 s2 vdd gnd xor_tg_x1
Xsum3 p3 p3b c3 s3 vdd gnd xor_tg_x1
.ends sum_xor_tg_x1
.subckt tb_inv a y vdd gnd
mp y a vdd vdd CMOSP W=1.8e-06 L=1.8e-07 AS=9.72e-13 PS=4.68e-06 AD=9.72e-13 PD=4.68e-06
mn y a gnd gnd CMOSN W=9.0e-07 L=1.8e-07 AS=4.86e-13 PS=2.88e-06 AD=4.86e-13 PD=2.88e-06
.ends
Vp0 src_p0 gnd 1.8
Xd_p0 src_p0 p0 vdd gnd tb_inv
Vp1 src_p1 gnd 1.8
Xd_p1 src_p1 p1 vdd gnd tb_inv
Vp2 src_p2 gnd 1.8
Xd_p2 src_p2 p2 vdd gnd tb_inv
Vp3 src_p3 gnd 1.8
Xd_p3 src_p3 p3 vdd gnd tb_inv
Vp0b src_p0b gnd 0.0
Xd_p0b src_p0b p0b vdd gnd tb_inv
Vp1b src_p1b gnd 0.0
Xd_p1b src_p1b p1b vdd gnd tb_inv
Vp2b src_p2b gnd 0.0
Xd_p2b src_p2b p2b vdd gnd tb_inv
Vp3b src_p3b gnd 0.0
Xd_p3b src_p3b p3b vdd gnd tb_inv
Vc0 src_c0 gnd 1.8
Xd_c0 src_c0 c0 vdd gnd tb_inv
Vc1 src_c1 gnd 1.8
Xd_c1 src_c1 c1 vdd gnd tb_inv
Vc2 src_c2 gnd 1.8
Xd_c2 src_c2 c2 vdd gnd tb_inv
Vc3 src_c3 gnd 1.8
Xd_c3 src_c3 c3 vdd gnd tb_inv
Xl_s0 s0 lo_s0 vdd gnd tb_inv
Xl_s1 s1 lo_s1 vdd gnd tb_inv
Xl_s2 s2 lo_s2 vdd gnd tb_inv
Xl_s3 s3 lo_s3 vdd gnd tb_inv
X0 p0 p1 p2 p3 p0b p1b p2b p3b c0 c1 c2 c3 s0 s1 s2 s3 vdd gnd sum_xor_tg_x1
.control
alter Vp0 = 1.8
alter Vp1 = 1.8
alter Vp2 = 1.8
alter Vp3 = 1.8
alter Vp0b = 0.0
alter Vp1b = 0.0
alter Vp2b = 0.0
alter Vp3b = 0.0
alter Vc0 = 1.8
alter Vc1 = 1.8
alter Vc2 = 1.8
alter Vc3 = 1.8
op
print i(VDD) >> dc_current.txt
alter Vp0 = 1.8
alter Vp1 = 1.8
alter Vp2 = 1.8
alter Vp3 = 1.8
alter Vp0b = 0.0
alter Vp1b = 0.0
alter Vp2b = 0.0
alter Vp3b = 0.0
alter Vc0 = 1.8
alter Vc1 = 1.8
alter Vc2 = 1.8
alter Vc3 = 0.0
op
print i(VDD) >> dc_current.txt
alter Vp0 = 1.8
alter Vp1 = 1.8
alter Vp2 = 1.8
alter Vp3 = 1.8
alter Vp0b = 0.0
alter Vp1b = 0.0
alter Vp2b = 0.0
alter Vp3b = 0.0
alter Vc0 = 1.8
alter Vc1 = 1.8
alter Vc2 = 0.0
alter Vc3 = 1.8
op
print i(VDD) >> dc_current.txt
alter Vp0 = 1.8
alter Vp1 = 1.8
alter Vp2 = 1.8
alter Vp3 = 1.8
alter Vp0b = 0.0
alter Vp1b = 0.0
alter Vp2b = 0.0
alter Vp3b = 0.0
alter Vc0 = 1.8
alter Vc1 = 1.8
alter Vc2 = 0.0
alter Vc3 = 0.0
op
print i(VDD) >> dc_current.txt
alter Vp0 = 1.8
alter Vp1 = 1.8
alter Vp2 = 1.8
alter Vp3 = 1.8
alter Vp0b = 0.0
alter Vp1b = 0.0
alter Vp2b = 0.0
alter Vp3b = 0.0
alter Vc0 = 1.8
alter Vc1 = 0.0
alter Vc2 = 1.8
alter Vc3 = 1.8
op
print i(VDD) >> dc_current.txt
alter Vp0 = 1.8
alter Vp1 = 1.8
alter Vp2 = 1.8
alter Vp3 = 1.8
alter Vp0b = 0.0
alter Vp1b = 0.0
alter Vp2b = 0.0
alter Vp3b = 0.0
alter Vc0 = 1.8
alter Vc1 = 0.0
alter Vc2 = 1.8
alter Vc3 = 0.0
op
print i(VDD) >> dc_current.txt
alter Vp0 = 1.8
alter Vp1 = 1.8
alter Vp2 = 1.8
alter Vp3 = 1.8
alter Vp0b = 0.0
alter Vp1b = 0.0
alter Vp2b = 0.0
alter Vp3b = 0.0
alter Vc0 = 1.8
alter Vc1 = 0.0
alter Vc2 = 0.0
alter Vc3 = 1.8
op
print i(VDD) >> dc_current.txt
alter Vp0 = 1.8
alter Vp1 = 1.8
alter Vp2 = 1.8
alter Vp3 = 1.8
alter Vp0b = 0.0
alter Vp1b = 0.0
alter Vp2b = 0.0
alter Vp3b = 0.0
alter Vc0 = 1.8
alter Vc1 = 0.0
alter Vc2 = 0.0
alter Vc3 = 0.0
op
print i(VDD) >> dc_current.txt
alter Vp0 = 1.8
alter Vp1 = 1.8
alter Vp2 = 1.8
alter Vp3 = 1.8
alter Vp0b = 0.0
alter Vp1b = 0.0
alter Vp2b = 0.0
alter Vp3b = 0.0
alter Vc0 = 0.0
alter Vc1 = 1.8
alter Vc2 = 1.8
alter Vc3 = 1.8
op
print i(VDD) >> dc_current.txt
alter Vp0 = 1.8
alter Vp1 = 1.8
alter Vp2 = 1.8
alter Vp3 = 1.8
alter Vp0b = 0.0
alter Vp1b = 0.0
alter Vp2b = 0.0
alter Vp3b = 0.0
alter Vc0 = 0.0
alter Vc1 = 1.8
alter Vc2 = 1.8
alter Vc3 = 0.0
op
print i(VDD) >> dc_current.txt
alter Vp0 = 1.8
alter Vp1 = 1.8
alter Vp2 = 1.8
alter Vp3 = 1.8
alter Vp0b = 0.0
alter Vp1b = 0.0
alter Vp2b = 0.0
alter Vp3b = 0.0
alter Vc0 = 0.0
alter Vc1 = 1.8
alter Vc2 = 0.0
alter Vc3 = 1.8
op
print i(VDD) >> dc_current.txt
alter Vp0 = 1.8
alter Vp1 = 1.8
alter Vp2 = 1.8
alter Vp3 = 1.8
alter Vp0b = 0.0
alter Vp1b = 0.0
alter Vp2b = 0.0
alter Vp3b = 0.0
alter Vc0 = 0.0
alter Vc1 = 1.8
alter Vc2 = 0.0
alter Vc3 = 0.0
op
print i(VDD) >> dc_current.txt
alter Vp0 = 1.8
alter Vp1 = 1.8
alter Vp2 = 1.8
alter Vp3 = 1.8
alter Vp0b = 0.0
alter Vp1b = 0.0
alter Vp2b = 0.0
alter Vp3b = 0.0
alter Vc0 = 0.0
alter Vc1 = 0.0
alter Vc2 = 1.8
alter Vc3 = 1.8
op
print i(VDD) >> dc_current.txt
alter Vp0 = 1.8
alter Vp1 = 1.8
alter Vp2 = 1.8
alter Vp3 = 1.8
alter Vp0b = 0.0
alter Vp1b = 0.0
alter Vp2b = 0.0
alter Vp3b = 0.0
alter Vc0 = 0.0
alter Vc1 = 0.0
alter Vc2 = 1.8
alter Vc3 = 0.0
op
print i(VDD) >> dc_current.txt
alter Vp0 = 1.8
alter Vp1 = 1.8
alter Vp2 = 1.8
alter Vp3 = 1.8
alter Vp0b = 0.0
alter Vp1b = 0.0
alter Vp2b = 0.0
alter Vp3b = 0.0
alter Vc0 = 0.0
alter Vc1 = 0.0
alter Vc2 = 0.0
alter Vc3 = 1.8
op
print i(VDD) >> dc_current.txt
alter Vp0 = 1.8
alter Vp1 = 1.8
alter Vp2 = 1.8
alter Vp3 = 1.8
alter Vp0b = 0.0
alter Vp1b = 0.0
alter Vp2b = 0.0
alter Vp3b = 0.0
alter Vc0 = 0.0
alter Vc1 = 0.0
alter Vc2 = 0.0
alter Vc3 = 0.0
op
print i(VDD) >> dc_current.txt
alter Vp0 = 1.8
alter Vp1 = 1.8
alter Vp2 = 1.8
alter Vp3 = 0.0
alter Vp0b = 0.0
alter Vp1b = 0.0
alter Vp2b = 0.0
alter Vp3b = 1.8
alter Vc0 = 1.8
alter Vc1 = 1.8
alter Vc2 = 1.8
alter Vc3 = 1.8
op
print i(VDD) >> dc_current.txt
alter Vp0 = 1.8
alter Vp1 = 1.8
alter Vp2 = 1.8
alter Vp3 = 0.0
alter Vp0b = 0.0
alter Vp1b = 0.0
alter Vp2b = 0.0
alter Vp3b = 1.8
alter Vc0 = 1.8
alter Vc1 = 1.8
alter Vc2 = 1.8
alter Vc3 = 0.0
op
print i(VDD) >> dc_current.txt
alter Vp0 = 1.8
alter Vp1 = 1.8
alter Vp2 = 1.8
alter Vp3 = 0.0
alter Vp0b = 0.0
alter Vp1b = 0.0
alter Vp2b = 0.0
alter Vp3b = 1.8
alter Vc0 = 1.8
alter Vc1 = 1.8
alter Vc2 = 0.0
alter Vc3 = 1.8
op
print i(VDD) >> dc_current.txt
alter Vp0 = 1.8
alter Vp1 = 1.8
alter Vp2 = 1.8
alter Vp3 = 0.0
alter Vp0b = 0.0
alter Vp1b = 0.0
alter Vp2b = 0.0
alter Vp3b = 1.8
alter Vc0 = 1.8
alter Vc1 = 1.8
alter Vc2 = 0.0
alter Vc3 = 0.0
op
print i(VDD) >> dc_current.txt
alter Vp0 = 1.8
alter Vp1 = 1.8
alter Vp2 = 1.8
alter Vp3 = 0.0
alter Vp0b = 0.0
alter Vp1b = 0.0
alter Vp2b = 0.0
alter Vp3b = 1.8
alter Vc0 = 1.8
alter Vc1 = 0.0
alter Vc2 = 1.8
alter Vc3 = 1.8
op
print i(VDD) >> dc_current.txt
alter Vp0 = 1.8
alter Vp1 = 1.8
alter Vp2 = 1.8
alter Vp3 = 0.0
alter Vp0b = 0.0
alter Vp1b = 0.0
alter Vp2b = 0.0
alter Vp3b = 1.8
alter Vc0 = 1.8
alter Vc1 = 0.0
alter Vc2 = 1.8
alter Vc3 = 0.0
op
print i(VDD) >> dc_current.txt
alter Vp0 = 1.8
alter Vp1 = 1.8
alter Vp2 = 1.8
alter Vp3 = 0.0
alter Vp0b = 0.0
alter Vp1b = 0.0
alter Vp2b = 0.0
alter Vp3b = 1.8
alter Vc0 = 1.8
alter Vc1 = 0.0
alter Vc2 = 0.0
alter Vc3 = 1.8
op
print i(VDD) >> dc_current.txt
alter Vp0 = 1.8
alter Vp1 = 1.8
alter Vp2 = 1.8
alter Vp3 = 0.0
alter Vp0b = 0.0
alter Vp1b = 0.0
alter Vp2b = 0.0
alter Vp3b = 1.8
alter Vc0 = 1.8
alter Vc1 = 0.0
alter Vc2 = 0.0
alter Vc3 = 0.0
op
print i(VDD) >> dc_current.txt
alter Vp0 = 1.8
alter Vp1 = 1.8
alter Vp2 = 1.8
alter Vp3 = 0.0
alter Vp0b = 0.0
alter Vp1b = 0.0
alter Vp2b = 0.0
alter Vp3b = 1.8
alter Vc0 = 0.0
alter Vc1 = 1.8
alter Vc2 = 1.8
alter Vc3 = 1.8
op
print i(VDD) >> dc_current.txt
alter Vp0 = 1.8
alter Vp1 = 1.8
alter Vp2 = 1.8
alter Vp3 = 0.0
alter Vp0b = 0.0
alter Vp1b = 0.0
alter Vp2b = 0.0
alter Vp3b = 1.8
alter Vc0 = 0.0
alter Vc1 = 1.8
alter Vc2 = 1.8
alter Vc3 = 0.0
op
print i(VDD) >> dc_current.txt
alter Vp0 = 1.8
alter Vp1 = 1.8
alter Vp2 = 1.8
alter Vp3 = 0.0
alter Vp0b = 0.0
alter Vp1b = 0.0
alter Vp2b = 0.0
alter Vp3b = 1.8
alter Vc0 = 0.0
alter Vc1 = 1.8
alter Vc2 = 0.0
alter Vc3 = 1.8
op
print i(VDD) >> dc_current.txt
alter Vp0 = 1.8
alter Vp1 = 1.8
alter Vp2 = 1.8
alter Vp3 = 0.0
alter Vp0b = 0.0
alter Vp1b = 0.0
alter Vp2b = 0.0
alter Vp3b = 1.8
alter Vc0 = 0.0
alter Vc1 = 1.8
alter Vc2 = 0.0
alter Vc3 = 0.0
op
print i(VDD) >> dc_current.txt
alter Vp0 = 1.8
alter Vp1 = 1.8
alter Vp2 = 1.8
alter Vp3 = 0.0
alter Vp0b = 0.0
alter Vp1b = 0.0
alter Vp2b = 0.0
alter Vp3b = 1.8
alter Vc0 = 0.0
alter Vc1 = 0.0
alter Vc2 = 1.8
alter Vc3 = 1.8
op
print i(VDD) >> dc_current.txt
alter Vp0 = 1.8
alter Vp1 = 1.8
alter Vp2 = 1.8
alter Vp3 = 0.0
alter Vp0b = 0.0
alter Vp1b = 0.0
alter Vp2b = 0.0
alter Vp3b = 1.8
alter Vc0 = 0.0
alter Vc1 = 0.0
alter Vc2 = 1.8
alter Vc3 = 0.0
op
print i(VDD) >> dc_current.txt
alter Vp0 = 1.8
alter Vp1 = 1.8
alter Vp2 = 1.8
alter Vp3 = 0.0
alter Vp0b = 0.0
alter Vp1b = 0.0
alter Vp2b = 0.0
alter Vp3b = 1.8
alter Vc0 = 0.0
alter Vc1 = 0.0
alter Vc2 = 0.0
alter Vc3 = 1.8
op
print i(VDD) >> dc_current.txt
alter Vp0 = 1.8
alter Vp1 = 1.8
alter Vp2 = 1.8
alter Vp3 = 0.0
alter Vp0b = 0.0
alter Vp1b = 0.0
alter Vp2b = 0.0
alter Vp3b = 1.8
alter Vc0 = 0.0
alter Vc1 = 0.0
alter Vc2 = 0.0
alter Vc3 = 0.0
op
print i(VDD) >> dc_current.txt
alter Vp0 = 1.8
alter Vp1 = 1.8
alter Vp2 = 0.0
alter Vp3 = 1.8
alter Vp0b = 0.0
alter Vp1b = 0.0
alter Vp2b = 1.8
alter Vp3b = 0.0
alter Vc0 = 1.8
alter Vc1 = 1.8
alter Vc2 = 1.8
alter Vc3 = 1.8
op
print i(VDD) >> dc_current.txt
alter Vp0 = 1.8
alter Vp1 = 1.8
alter Vp2 = 0.0
alter Vp3 = 1.8
alter Vp0b = 0.0
alter Vp1b = 0.0
alter Vp2b = 1.8
alter Vp3b = 0.0
alter Vc0 = 1.8
alter Vc1 = 1.8
alter Vc2 = 1.8
alter Vc3 = 0.0
op
print i(VDD) >> dc_current.txt
alter Vp0 = 1.8
alter Vp1 = 1.8
alter Vp2 = 0.0
alter Vp3 = 1.8
alter Vp0b = 0.0
alter Vp1b = 0.0
alter Vp2b = 1.8
alter Vp3b = 0.0
alter Vc0 = 1.8
alter Vc1 = 1.8
alter Vc2 = 0.0
alter Vc3 = 1.8
op
print i(VDD) >> dc_current.txt
alter Vp0 = 1.8
alter Vp1 = 1.8
alter Vp2 = 0.0
alter Vp3 = 1.8
alter Vp0b = 0.0
alter Vp1b = 0.0
alter Vp2b = 1.8
alter Vp3b = 0.0
alter Vc0 = 1.8
alter Vc1 = 1.8
alter Vc2 = 0.0
alter Vc3 = 0.0
op
print i(VDD) >> dc_current.txt
alter Vp0 = 1.8
alter Vp1 = 1.8
alter Vp2 = 0.0
alter Vp3 = 1.8
alter Vp0b = 0.0
alter Vp1b = 0.0
alter Vp2b = 1.8
alter Vp3b = 0.0
alter Vc0 = 1.8
alter Vc1 = 0.0
alter Vc2 = 1.8
alter Vc3 = 1.8
op
print i(VDD) >> dc_current.txt
alter Vp0 = 1.8
alter Vp1 = 1.8
alter Vp2 = 0.0
alter Vp3 = 1.8
alter Vp0b = 0.0
alter Vp1b = 0.0
alter Vp2b = 1.8
alter Vp3b = 0.0
alter Vc0 = 1.8
alter Vc1 = 0.0
alter Vc2 = 1.8
alter Vc3 = 0.0
op
print i(VDD) >> dc_current.txt
alter Vp0 = 1.8
alter Vp1 = 1.8
alter Vp2 = 0.0
alter Vp3 = 1.8
alter Vp0b = 0.0
alter Vp1b = 0.0
alter Vp2b = 1.8
alter Vp3b = 0.0
alter Vc0 = 1.8
alter Vc1 = 0.0
alter Vc2 = 0.0
alter Vc3 = 1.8
op
print i(VDD) >> dc_current.txt
alter Vp0 = 1.8
alter Vp1 = 1.8
alter Vp2 = 0.0
alter Vp3 = 1.8
alter Vp0b = 0.0
alter Vp1b = 0.0
alter Vp2b = 1.8
alter Vp3b = 0.0
alter Vc0 = 1.8
alter Vc1 = 0.0
alter Vc2 = 0.0
alter Vc3 = 0.0
op
print i(VDD) >> dc_current.txt
alter Vp0 = 1.8
alter Vp1 = 1.8
alter Vp2 = 0.0
alter Vp3 = 1.8
alter Vp0b = 0.0
alter Vp1b = 0.0
alter Vp2b = 1.8
alter Vp3b = 0.0
alter Vc0 = 0.0
alter Vc1 = 1.8
alter Vc2 = 1.8
alter Vc3 = 1.8
op
print i(VDD) >> dc_current.txt
alter Vp0 = 1.8
alter Vp1 = 1.8
alter Vp2 = 0.0
alter Vp3 = 1.8
alter Vp0b = 0.0
alter Vp1b = 0.0
alter Vp2b = 1.8
alter Vp3b = 0.0
alter Vc0 = 0.0
alter Vc1 = 1.8
alter Vc2 = 1.8
alter Vc3 = 0.0
op
print i(VDD) >> dc_current.txt
alter Vp0 = 1.8
alter Vp1 = 1.8
alter Vp2 = 0.0
alter Vp3 = 1.8
alter Vp0b = 0.0
alter Vp1b = 0.0
alter Vp2b = 1.8
alter Vp3b = 0.0
alter Vc0 = 0.0
alter Vc1 = 1.8
alter Vc2 = 0.0
alter Vc3 = 1.8
op
print i(VDD) >> dc_current.txt
alter Vp0 = 1.8
alter Vp1 = 1.8
alter Vp2 = 0.0
alter Vp3 = 1.8
alter Vp0b = 0.0
alter Vp1b = 0.0
alter Vp2b = 1.8
alter Vp3b = 0.0
alter Vc0 = 0.0
alter Vc1 = 1.8
alter Vc2 = 0.0
alter Vc3 = 0.0
op
print i(VDD) >> dc_current.txt
alter Vp0 = 1.8
alter Vp1 = 1.8
alter Vp2 = 0.0
alter Vp3 = 1.8
alter Vp0b = 0.0
alter Vp1b = 0.0
alter Vp2b = 1.8
alter Vp3b = 0.0
alter Vc0 = 0.0
alter Vc1 = 0.0
alter Vc2 = 1.8
alter Vc3 = 1.8
op
print i(VDD) >> dc_current.txt
alter Vp0 = 1.8
alter Vp1 = 1.8
alter Vp2 = 0.0
alter Vp3 = 1.8
alter Vp0b = 0.0
alter Vp1b = 0.0
alter Vp2b = 1.8
alter Vp3b = 0.0
alter Vc0 = 0.0
alter Vc1 = 0.0
alter Vc2 = 1.8
alter Vc3 = 0.0
op
print i(VDD) >> dc_current.txt
alter Vp0 = 1.8
alter Vp1 = 1.8
alter Vp2 = 0.0
alter Vp3 = 1.8
alter Vp0b = 0.0
alter Vp1b = 0.0
alter Vp2b = 1.8
alter Vp3b = 0.0
alter Vc0 = 0.0
alter Vc1 = 0.0
alter Vc2 = 0.0
alter Vc3 = 1.8
op
print i(VDD) >> dc_current.txt
alter Vp0 = 1.8
alter Vp1 = 1.8
alter Vp2 = 0.0
alter Vp3 = 1.8
alter Vp0b = 0.0
alter Vp1b = 0.0
alter Vp2b = 1.8
alter Vp3b = 0.0
alter Vc0 = 0.0
alter Vc1 = 0.0
alter Vc2 = 0.0
alter Vc3 = 0.0
op
print i(VDD) >> dc_current.txt
alter Vp0 = 1.8
alter Vp1 = 1.8
alter Vp2 = 0.0
alter Vp3 = 0.0
alter Vp0b = 0.0
alter Vp1b = 0.0
alter Vp2b = 1.8
alter Vp3b = 1.8
alter Vc0 = 1.8
alter Vc1 = 1.8
alter Vc2 = 1.8
alter Vc3 = 1.8
op
print i(VDD) >> dc_current.txt
alter Vp0 = 1.8
alter Vp1 = 1.8
alter Vp2 = 0.0
alter Vp3 = 0.0
alter Vp0b = 0.0
alter Vp1b = 0.0
alter Vp2b = 1.8
alter Vp3b = 1.8
alter Vc0 = 1.8
alter Vc1 = 1.8
alter Vc2 = 1.8
alter Vc3 = 0.0
op
print i(VDD) >> dc_current.txt
alter Vp0 = 1.8
alter Vp1 = 1.8
alter Vp2 = 0.0
alter Vp3 = 0.0
alter Vp0b = 0.0
alter Vp1b = 0.0
alter Vp2b = 1.8
alter Vp3b = 1.8
alter Vc0 = 1.8
alter Vc1 = 1.8
alter Vc2 = 0.0
alter Vc3 = 1.8
op
print i(VDD) >> dc_current.txt
alter Vp0 = 1.8
alter Vp1 = 1.8
alter Vp2 = 0.0
alter Vp3 = 0.0
alter Vp0b = 0.0
alter Vp1b = 0.0
alter Vp2b = 1.8
alter Vp3b = 1.8
alter Vc0 = 1.8
alter Vc1 = 1.8
alter Vc2 = 0.0
alter Vc3 = 0.0
op
print i(VDD) >> dc_current.txt
alter Vp0 = 1.8
alter Vp1 = 1.8
alter Vp2 = 0.0
alter Vp3 = 0.0
alter Vp0b = 0.0
alter Vp1b = 0.0
alter Vp2b = 1.8
alter Vp3b = 1.8
alter Vc0 = 1.8
alter Vc1 = 0.0
alter Vc2 = 1.8
alter Vc3 = 1.8
op
print i(VDD) >> dc_current.txt
alter Vp0 = 1.8
alter Vp1 = 1.8
alter Vp2 = 0.0
alter Vp3 = 0.0
alter Vp0b = 0.0
alter Vp1b = 0.0
alter Vp2b = 1.8
alter Vp3b = 1.8
alter Vc0 = 1.8
alter Vc1 = 0.0
alter Vc2 = 1.8
alter Vc3 = 0.0
op
print i(VDD) >> dc_current.txt
alter Vp0 = 1.8
alter Vp1 = 1.8
alter Vp2 = 0.0
alter Vp3 = 0.0
alter Vp0b = 0.0
alter Vp1b = 0.0
alter Vp2b = 1.8
alter Vp3b = 1.8
alter Vc0 = 1.8
alter Vc1 = 0.0
alter Vc2 = 0.0
alter Vc3 = 1.8
op
print i(VDD) >> dc_current.txt
alter Vp0 = 1.8
alter Vp1 = 1.8
alter Vp2 = 0.0
alter Vp3 = 0.0
alter Vp0b = 0.0
alter Vp1b = 0.0
alter Vp2b = 1.8
alter Vp3b = 1.8
alter Vc0 = 1.8
alter Vc1 = 0.0
alter Vc2 = 0.0
alter Vc3 = 0.0
op
print i(VDD) >> dc_current.txt
alter Vp0 = 1.8
alter Vp1 = 1.8
alter Vp2 = 0.0
alter Vp3 = 0.0
alter Vp0b = 0.0
alter Vp1b = 0.0
alter Vp2b = 1.8
alter Vp3b = 1.8
alter Vc0 = 0.0
alter Vc1 = 1.8
alter Vc2 = 1.8
alter Vc3 = 1.8
op
print i(VDD) >> dc_current.txt
alter Vp0 = 1.8
alter Vp1 = 1.8
alter Vp2 = 0.0
alter Vp3 = 0.0
alter Vp0b = 0.0
alter Vp1b = 0.0
alter Vp2b = 1.8
alter Vp3b = 1.8
alter Vc0 = 0.0
alter Vc1 = 1.8
alter Vc2 = 1.8
alter Vc3 = 0.0
op
print i(VDD) >> dc_current.txt
alter Vp0 = 1.8
alter Vp1 = 1.8
alter Vp2 = 0.0
alter Vp3 = 0.0
alter Vp0b = 0.0
alter Vp1b = 0.0
alter Vp2b = 1.8
alter Vp3b = 1.8
alter Vc0 = 0.0
alter Vc1 = 1.8
alter Vc2 = 0.0
alter Vc3 = 1.8
op
print i(VDD) >> dc_current.txt
alter Vp0 = 1.8
alter Vp1 = 1.8
alter Vp2 = 0.0
alter Vp3 = 0.0
alter Vp0b = 0.0
alter Vp1b = 0.0
alter Vp2b = 1.8
alter Vp3b = 1.8
alter Vc0 = 0.0
alter Vc1 = 1.8
alter Vc2 = 0.0
alter Vc3 = 0.0
op
print i(VDD) >> dc_current.txt
alter Vp0 = 1.8
alter Vp1 = 1.8
alter Vp2 = 0.0
alter Vp3 = 0.0
alter Vp0b = 0.0
alter Vp1b = 0.0
alter Vp2b = 1.8
alter Vp3b = 1.8
alter Vc0 = 0.0
alter Vc1 = 0.0
alter Vc2 = 1.8
alter Vc3 = 1.8
op
print i(VDD) >> dc_current.txt
alter Vp0 = 1.8
alter Vp1 = 1.8
alter Vp2 = 0.0
alter Vp3 = 0.0
alter Vp0b = 0.0
alter Vp1b = 0.0
alter Vp2b = 1.8
alter Vp3b = 1.8
alter Vc0 = 0.0
alter Vc1 = 0.0
alter Vc2 = 1.8
alter Vc3 = 0.0
op
print i(VDD) >> dc_current.txt
alter Vp0 = 1.8
alter Vp1 = 1.8
alter Vp2 = 0.0
alter Vp3 = 0.0
alter Vp0b = 0.0
alter Vp1b = 0.0
alter Vp2b = 1.8
alter Vp3b = 1.8
alter Vc0 = 0.0
alter Vc1 = 0.0
alter Vc2 = 0.0
alter Vc3 = 1.8
op
print i(VDD) >> dc_current.txt
alter Vp0 = 1.8
alter Vp1 = 1.8
alter Vp2 = 0.0
alter Vp3 = 0.0
alter Vp0b = 0.0
alter Vp1b = 0.0
alter Vp2b = 1.8
alter Vp3b = 1.8
alter Vc0 = 0.0
alter Vc1 = 0.0
alter Vc2 = 0.0
alter Vc3 = 0.0
op
print i(VDD) >> dc_current.txt
alter Vp0 = 1.8
alter Vp1 = 0.0
alter Vp2 = 1.8
alter Vp3 = 1.8
alter Vp0b = 0.0
alter Vp1b = 1.8
alter Vp2b = 0.0
alter Vp3b = 0.0
alter Vc0 = 1.8
alter Vc1 = 1.8
alter Vc2 = 1.8
alter Vc3 = 1.8
op
print i(VDD) >> dc_current.txt
alter Vp0 = 1.8
alter Vp1 = 0.0
alter Vp2 = 1.8
alter Vp3 = 1.8
alter Vp0b = 0.0
alter Vp1b = 1.8
alter Vp2b = 0.0
alter Vp3b = 0.0
alter Vc0 = 1.8
alter Vc1 = 1.8
alter Vc2 = 1.8
alter Vc3 = 0.0
op
print i(VDD) >> dc_current.txt
alter Vp0 = 1.8
alter Vp1 = 0.0
alter Vp2 = 1.8
alter Vp3 = 1.8
alter Vp0b = 0.0
alter Vp1b = 1.8
alter Vp2b = 0.0
alter Vp3b = 0.0
alter Vc0 = 1.8
alter Vc1 = 1.8
alter Vc2 = 0.0
alter Vc3 = 1.8
op
print i(VDD) >> dc_current.txt
alter Vp0 = 1.8
alter Vp1 = 0.0
alter Vp2 = 1.8
alter Vp3 = 1.8
alter Vp0b = 0.0
alter Vp1b = 1.8
alter Vp2b = 0.0
alter Vp3b = 0.0
alter Vc0 = 1.8
alter Vc1 = 1.8
alter Vc2 = 0.0
alter Vc3 = 0.0
op
print i(VDD) >> dc_current.txt
alter Vp0 = 1.8
alter Vp1 = 0.0
alter Vp2 = 1.8
alter Vp3 = 1.8
alter Vp0b = 0.0
alter Vp1b = 1.8
alter Vp2b = 0.0
alter Vp3b = 0.0
alter Vc0 = 1.8
alter Vc1 = 0.0
alter Vc2 = 1.8
alter Vc3 = 1.8
op
print i(VDD) >> dc_current.txt
alter Vp0 = 1.8
alter Vp1 = 0.0
alter Vp2 = 1.8
alter Vp3 = 1.8
alter Vp0b = 0.0
alter Vp1b = 1.8
alter Vp2b = 0.0
alter Vp3b = 0.0
alter Vc0 = 1.8
alter Vc1 = 0.0
alter Vc2 = 1.8
alter Vc3 = 0.0
op
print i(VDD) >> dc_current.txt
alter Vp0 = 1.8
alter Vp1 = 0.0
alter Vp2 = 1.8
alter Vp3 = 1.8
alter Vp0b = 0.0
alter Vp1b = 1.8
alter Vp2b = 0.0
alter Vp3b = 0.0
alter Vc0 = 1.8
alter Vc1 = 0.0
alter Vc2 = 0.0
alter Vc3 = 1.8
op
print i(VDD) >> dc_current.txt
alter Vp0 = 1.8
alter Vp1 = 0.0
alter Vp2 = 1.8
alter Vp3 = 1.8
alter Vp0b = 0.0
alter Vp1b = 1.8
alter Vp2b = 0.0
alter Vp3b = 0.0
alter Vc0 = 1.8
alter Vc1 = 0.0
alter Vc2 = 0.0
alter Vc3 = 0.0
op
print i(VDD) >> dc_current.txt
alter Vp0 = 1.8
alter Vp1 = 0.0
alter Vp2 = 1.8
alter Vp3 = 1.8
alter Vp0b = 0.0
alter Vp1b = 1.8
alter Vp2b = 0.0
alter Vp3b = 0.0
alter Vc0 = 0.0
alter Vc1 = 1.8
alter Vc2 = 1.8
alter Vc3 = 1.8
op
print i(VDD) >> dc_current.txt
alter Vp0 = 1.8
alter Vp1 = 0.0
alter Vp2 = 1.8
alter Vp3 = 1.8
alter Vp0b = 0.0
alter Vp1b = 1.8
alter Vp2b = 0.0
alter Vp3b = 0.0
alter Vc0 = 0.0
alter Vc1 = 1.8
alter Vc2 = 1.8
alter Vc3 = 0.0
op
print i(VDD) >> dc_current.txt
alter Vp0 = 1.8
alter Vp1 = 0.0
alter Vp2 = 1.8
alter Vp3 = 1.8
alter Vp0b = 0.0
alter Vp1b = 1.8
alter Vp2b = 0.0
alter Vp3b = 0.0
alter Vc0 = 0.0
alter Vc1 = 1.8
alter Vc2 = 0.0
alter Vc3 = 1.8
op
print i(VDD) >> dc_current.txt
alter Vp0 = 1.8
alter Vp1 = 0.0
alter Vp2 = 1.8
alter Vp3 = 1.8
alter Vp0b = 0.0
alter Vp1b = 1.8
alter Vp2b = 0.0
alter Vp3b = 0.0
alter Vc0 = 0.0
alter Vc1 = 1.8
alter Vc2 = 0.0
alter Vc3 = 0.0
op
print i(VDD) >> dc_current.txt
alter Vp0 = 1.8
alter Vp1 = 0.0
alter Vp2 = 1.8
alter Vp3 = 1.8
alter Vp0b = 0.0
alter Vp1b = 1.8
alter Vp2b = 0.0
alter Vp3b = 0.0
alter Vc0 = 0.0
alter Vc1 = 0.0
alter Vc2 = 1.8
alter Vc3 = 1.8
op
print i(VDD) >> dc_current.txt
alter Vp0 = 1.8
alter Vp1 = 0.0
alter Vp2 = 1.8
alter Vp3 = 1.8
alter Vp0b = 0.0
alter Vp1b = 1.8
alter Vp2b = 0.0
alter Vp3b = 0.0
alter Vc0 = 0.0
alter Vc1 = 0.0
alter Vc2 = 1.8
alter Vc3 = 0.0
op
print i(VDD) >> dc_current.txt
alter Vp0 = 1.8
alter Vp1 = 0.0
alter Vp2 = 1.8
alter Vp3 = 1.8
alter Vp0b = 0.0
alter Vp1b = 1.8
alter Vp2b = 0.0
alter Vp3b = 0.0
alter Vc0 = 0.0
alter Vc1 = 0.0
alter Vc2 = 0.0
alter Vc3 = 1.8
op
print i(VDD) >> dc_current.txt
alter Vp0 = 1.8
alter Vp1 = 0.0
alter Vp2 = 1.8
alter Vp3 = 1.8
alter Vp0b = 0.0
alter Vp1b = 1.8
alter Vp2b = 0.0
alter Vp3b = 0.0
alter Vc0 = 0.0
alter Vc1 = 0.0
alter Vc2 = 0.0
alter Vc3 = 0.0
op
print i(VDD) >> dc_current.txt
alter Vp0 = 1.8
alter Vp1 = 0.0
alter Vp2 = 1.8
alter Vp3 = 0.0
alter Vp0b = 0.0
alter Vp1b = 1.8
alter Vp2b = 0.0
alter Vp3b = 1.8
alter Vc0 = 1.8
alter Vc1 = 1.8
alter Vc2 = 1.8
alter Vc3 = 1.8
op
print i(VDD) >> dc_current.txt
alter Vp0 = 1.8
alter Vp1 = 0.0
alter Vp2 = 1.8
alter Vp3 = 0.0
alter Vp0b = 0.0
alter Vp1b = 1.8
alter Vp2b = 0.0
alter Vp3b = 1.8
alter Vc0 = 1.8
alter Vc1 = 1.8
alter Vc2 = 1.8
alter Vc3 = 0.0
op
print i(VDD) >> dc_current.txt
alter Vp0 = 1.8
alter Vp1 = 0.0
alter Vp2 = 1.8
alter Vp3 = 0.0
alter Vp0b = 0.0
alter Vp1b = 1.8
alter Vp2b = 0.0
alter Vp3b = 1.8
alter Vc0 = 1.8
alter Vc1 = 1.8
alter Vc2 = 0.0
alter Vc3 = 1.8
op
print i(VDD) >> dc_current.txt
alter Vp0 = 1.8
alter Vp1 = 0.0
alter Vp2 = 1.8
alter Vp3 = 0.0
alter Vp0b = 0.0
alter Vp1b = 1.8
alter Vp2b = 0.0
alter Vp3b = 1.8
alter Vc0 = 1.8
alter Vc1 = 1.8
alter Vc2 = 0.0
alter Vc3 = 0.0
op
print i(VDD) >> dc_current.txt
alter Vp0 = 1.8
alter Vp1 = 0.0
alter Vp2 = 1.8
alter Vp3 = 0.0
alter Vp0b = 0.0
alter Vp1b = 1.8
alter Vp2b = 0.0
alter Vp3b = 1.8
alter Vc0 = 1.8
alter Vc1 = 0.0
alter Vc2 = 1.8
alter Vc3 = 1.8
op
print i(VDD) >> dc_current.txt
alter Vp0 = 1.8
alter Vp1 = 0.0
alter Vp2 = 1.8
alter Vp3 = 0.0
alter Vp0b = 0.0
alter Vp1b = 1.8
alter Vp2b = 0.0
alter Vp3b = 1.8
alter Vc0 = 1.8
alter Vc1 = 0.0
alter Vc2 = 1.8
alter Vc3 = 0.0
op
print i(VDD) >> dc_current.txt
alter Vp0 = 1.8
alter Vp1 = 0.0
alter Vp2 = 1.8
alter Vp3 = 0.0
alter Vp0b = 0.0
alter Vp1b = 1.8
alter Vp2b = 0.0
alter Vp3b = 1.8
alter Vc0 = 1.8
alter Vc1 = 0.0
alter Vc2 = 0.0
alter Vc3 = 1.8
op
print i(VDD) >> dc_current.txt
alter Vp0 = 1.8
alter Vp1 = 0.0
alter Vp2 = 1.8
alter Vp3 = 0.0
alter Vp0b = 0.0
alter Vp1b = 1.8
alter Vp2b = 0.0
alter Vp3b = 1.8
alter Vc0 = 1.8
alter Vc1 = 0.0
alter Vc2 = 0.0
alter Vc3 = 0.0
op
print i(VDD) >> dc_current.txt
alter Vp0 = 1.8
alter Vp1 = 0.0
alter Vp2 = 1.8
alter Vp3 = 0.0
alter Vp0b = 0.0
alter Vp1b = 1.8
alter Vp2b = 0.0
alter Vp3b = 1.8
alter Vc0 = 0.0
alter Vc1 = 1.8
alter Vc2 = 1.8
alter Vc3 = 1.8
op
print i(VDD) >> dc_current.txt
alter Vp0 = 1.8
alter Vp1 = 0.0
alter Vp2 = 1.8
alter Vp3 = 0.0
alter Vp0b = 0.0
alter Vp1b = 1.8
alter Vp2b = 0.0
alter Vp3b = 1.8
alter Vc0 = 0.0
alter Vc1 = 1.8
alter Vc2 = 1.8
alter Vc3 = 0.0
op
print i(VDD) >> dc_current.txt
alter Vp0 = 1.8
alter Vp1 = 0.0
alter Vp2 = 1.8
alter Vp3 = 0.0
alter Vp0b = 0.0
alter Vp1b = 1.8
alter Vp2b = 0.0
alter Vp3b = 1.8
alter Vc0 = 0.0
alter Vc1 = 1.8
alter Vc2 = 0.0
alter Vc3 = 1.8
op
print i(VDD) >> dc_current.txt
alter Vp0 = 1.8
alter Vp1 = 0.0
alter Vp2 = 1.8
alter Vp3 = 0.0
alter Vp0b = 0.0
alter Vp1b = 1.8
alter Vp2b = 0.0
alter Vp3b = 1.8
alter Vc0 = 0.0
alter Vc1 = 1.8
alter Vc2 = 0.0
alter Vc3 = 0.0
op
print i(VDD) >> dc_current.txt
alter Vp0 = 1.8
alter Vp1 = 0.0
alter Vp2 = 1.8
alter Vp3 = 0.0
alter Vp0b = 0.0
alter Vp1b = 1.8
alter Vp2b = 0.0
alter Vp3b = 1.8
alter Vc0 = 0.0
alter Vc1 = 0.0
alter Vc2 = 1.8
alter Vc3 = 1.8
op
print i(VDD) >> dc_current.txt
alter Vp0 = 1.8
alter Vp1 = 0.0
alter Vp2 = 1.8
alter Vp3 = 0.0
alter Vp0b = 0.0
alter Vp1b = 1.8
alter Vp2b = 0.0
alter Vp3b = 1.8
alter Vc0 = 0.0
alter Vc1 = 0.0
alter Vc2 = 1.8
alter Vc3 = 0.0
op
print i(VDD) >> dc_current.txt
alter Vp0 = 1.8
alter Vp1 = 0.0
alter Vp2 = 1.8
alter Vp3 = 0.0
alter Vp0b = 0.0
alter Vp1b = 1.8
alter Vp2b = 0.0
alter Vp3b = 1.8
alter Vc0 = 0.0
alter Vc1 = 0.0
alter Vc2 = 0.0
alter Vc3 = 1.8
op
print i(VDD) >> dc_current.txt
alter Vp0 = 1.8
alter Vp1 = 0.0
alter Vp2 = 1.8
alter Vp3 = 0.0
alter Vp0b = 0.0
alter Vp1b = 1.8
alter Vp2b = 0.0
alter Vp3b = 1.8
alter Vc0 = 0.0
alter Vc1 = 0.0
alter Vc2 = 0.0
alter Vc3 = 0.0
op
print i(VDD) >> dc_current.txt
alter Vp0 = 1.8
alter Vp1 = 0.0
alter Vp2 = 0.0
alter Vp3 = 1.8
alter Vp0b = 0.0
alter Vp1b = 1.8
alter Vp2b = 1.8
alter Vp3b = 0.0
alter Vc0 = 1.8
alter Vc1 = 1.8
alter Vc2 = 1.8
alter Vc3 = 1.8
op
print i(VDD) >> dc_current.txt
alter Vp0 = 1.8
alter Vp1 = 0.0
alter Vp2 = 0.0
alter Vp3 = 1.8
alter Vp0b = 0.0
alter Vp1b = 1.8
alter Vp2b = 1.8
alter Vp3b = 0.0
alter Vc0 = 1.8
alter Vc1 = 1.8
alter Vc2 = 1.8
alter Vc3 = 0.0
op
print i(VDD) >> dc_current.txt
alter Vp0 = 1.8
alter Vp1 = 0.0
alter Vp2 = 0.0
alter Vp3 = 1.8
alter Vp0b = 0.0
alter Vp1b = 1.8
alter Vp2b = 1.8
alter Vp3b = 0.0
alter Vc0 = 1.8
alter Vc1 = 1.8
alter Vc2 = 0.0
alter Vc3 = 1.8
op
print i(VDD) >> dc_current.txt
alter Vp0 = 1.8
alter Vp1 = 0.0
alter Vp2 = 0.0
alter Vp3 = 1.8
alter Vp0b = 0.0
alter Vp1b = 1.8
alter Vp2b = 1.8
alter Vp3b = 0.0
alter Vc0 = 1.8
alter Vc1 = 1.8
alter Vc2 = 0.0
alter Vc3 = 0.0
op
print i(VDD) >> dc_current.txt
alter Vp0 = 1.8
alter Vp1 = 0.0
alter Vp2 = 0.0
alter Vp3 = 1.8
alter Vp0b = 0.0
alter Vp1b = 1.8
alter Vp2b = 1.8
alter Vp3b = 0.0
alter Vc0 = 1.8
alter Vc1 = 0.0
alter Vc2 = 1.8
alter Vc3 = 1.8
op
print i(VDD) >> dc_current.txt
alter Vp0 = 1.8
alter Vp1 = 0.0
alter Vp2 = 0.0
alter Vp3 = 1.8
alter Vp0b = 0.0
alter Vp1b = 1.8
alter Vp2b = 1.8
alter Vp3b = 0.0
alter Vc0 = 1.8
alter Vc1 = 0.0
alter Vc2 = 1.8
alter Vc3 = 0.0
op
print i(VDD) >> dc_current.txt
alter Vp0 = 1.8
alter Vp1 = 0.0
alter Vp2 = 0.0
alter Vp3 = 1.8
alter Vp0b = 0.0
alter Vp1b = 1.8
alter Vp2b = 1.8
alter Vp3b = 0.0
alter Vc0 = 1.8
alter Vc1 = 0.0
alter Vc2 = 0.0
alter Vc3 = 1.8
op
print i(VDD) >> dc_current.txt
alter Vp0 = 1.8
alter Vp1 = 0.0
alter Vp2 = 0.0
alter Vp3 = 1.8
alter Vp0b = 0.0
alter Vp1b = 1.8
alter Vp2b = 1.8
alter Vp3b = 0.0
alter Vc0 = 1.8
alter Vc1 = 0.0
alter Vc2 = 0.0
alter Vc3 = 0.0
op
print i(VDD) >> dc_current.txt
alter Vp0 = 1.8
alter Vp1 = 0.0
alter Vp2 = 0.0
alter Vp3 = 1.8
alter Vp0b = 0.0
alter Vp1b = 1.8
alter Vp2b = 1.8
alter Vp3b = 0.0
alter Vc0 = 0.0
alter Vc1 = 1.8
alter Vc2 = 1.8
alter Vc3 = 1.8
op
print i(VDD) >> dc_current.txt
alter Vp0 = 1.8
alter Vp1 = 0.0
alter Vp2 = 0.0
alter Vp3 = 1.8
alter Vp0b = 0.0
alter Vp1b = 1.8
alter Vp2b = 1.8
alter Vp3b = 0.0
alter Vc0 = 0.0
alter Vc1 = 1.8
alter Vc2 = 1.8
alter Vc3 = 0.0
op
print i(VDD) >> dc_current.txt
alter Vp0 = 1.8
alter Vp1 = 0.0
alter Vp2 = 0.0
alter Vp3 = 1.8
alter Vp0b = 0.0
alter Vp1b = 1.8
alter Vp2b = 1.8
alter Vp3b = 0.0
alter Vc0 = 0.0
alter Vc1 = 1.8
alter Vc2 = 0.0
alter Vc3 = 1.8
op
print i(VDD) >> dc_current.txt
alter Vp0 = 1.8
alter Vp1 = 0.0
alter Vp2 = 0.0
alter Vp3 = 1.8
alter Vp0b = 0.0
alter Vp1b = 1.8
alter Vp2b = 1.8
alter Vp3b = 0.0
alter Vc0 = 0.0
alter Vc1 = 1.8
alter Vc2 = 0.0
alter Vc3 = 0.0
op
print i(VDD) >> dc_current.txt
alter Vp0 = 1.8
alter Vp1 = 0.0
alter Vp2 = 0.0
alter Vp3 = 1.8
alter Vp0b = 0.0
alter Vp1b = 1.8
alter Vp2b = 1.8
alter Vp3b = 0.0
alter Vc0 = 0.0
alter Vc1 = 0.0
alter Vc2 = 1.8
alter Vc3 = 1.8
op
print i(VDD) >> dc_current.txt
alter Vp0 = 1.8
alter Vp1 = 0.0
alter Vp2 = 0.0
alter Vp3 = 1.8
alter Vp0b = 0.0
alter Vp1b = 1.8
alter Vp2b = 1.8
alter Vp3b = 0.0
alter Vc0 = 0.0
alter Vc1 = 0.0
alter Vc2 = 1.8
alter Vc3 = 0.0
op
print i(VDD) >> dc_current.txt
alter Vp0 = 1.8
alter Vp1 = 0.0
alter Vp2 = 0.0
alter Vp3 = 1.8
alter Vp0b = 0.0
alter Vp1b = 1.8
alter Vp2b = 1.8
alter Vp3b = 0.0
alter Vc0 = 0.0
alter Vc1 = 0.0
alter Vc2 = 0.0
alter Vc3 = 1.8
op
print i(VDD) >> dc_current.txt
alter Vp0 = 1.8
alter Vp1 = 0.0
alter Vp2 = 0.0
alter Vp3 = 1.8
alter Vp0b = 0.0
alter Vp1b = 1.8
alter Vp2b = 1.8
alter Vp3b = 0.0
alter Vc0 = 0.0
alter Vc1 = 0.0
alter Vc2 = 0.0
alter Vc3 = 0.0
op
print i(VDD) >> dc_current.txt
alter Vp0 = 1.8
alter Vp1 = 0.0
alter Vp2 = 0.0
alter Vp3 = 0.0
alter Vp0b = 0.0
alter Vp1b = 1.8
alter Vp2b = 1.8
alter Vp3b = 1.8
alter Vc0 = 1.8
alter Vc1 = 1.8
alter Vc2 = 1.8
alter Vc3 = 1.8
op
print i(VDD) >> dc_current.txt
alter Vp0 = 1.8
alter Vp1 = 0.0
alter Vp2 = 0.0
alter Vp3 = 0.0
alter Vp0b = 0.0
alter Vp1b = 1.8
alter Vp2b = 1.8
alter Vp3b = 1.8
alter Vc0 = 1.8
alter Vc1 = 1.8
alter Vc2 = 1.8
alter Vc3 = 0.0
op
print i(VDD) >> dc_current.txt
alter Vp0 = 1.8
alter Vp1 = 0.0
alter Vp2 = 0.0
alter Vp3 = 0.0
alter Vp0b = 0.0
alter Vp1b = 1.8
alter Vp2b = 1.8
alter Vp3b = 1.8
alter Vc0 = 1.8
alter Vc1 = 1.8
alter Vc2 = 0.0
alter Vc3 = 1.8
op
print i(VDD) >> dc_current.txt
alter Vp0 = 1.8
alter Vp1 = 0.0
alter Vp2 = 0.0
alter Vp3 = 0.0
alter Vp0b = 0.0
alter Vp1b = 1.8
alter Vp2b = 1.8
alter Vp3b = 1.8
alter Vc0 = 1.8
alter Vc1 = 1.8
alter Vc2 = 0.0
alter Vc3 = 0.0
op
print i(VDD) >> dc_current.txt
alter Vp0 = 1.8
alter Vp1 = 0.0
alter Vp2 = 0.0
alter Vp3 = 0.0
alter Vp0b = 0.0
alter Vp1b = 1.8
alter Vp2b = 1.8
alter Vp3b = 1.8
alter Vc0 = 1.8
alter Vc1 = 0.0
alter Vc2 = 1.8
alter Vc3 = 1.8
op
print i(VDD) >> dc_current.txt
alter Vp0 = 1.8
alter Vp1 = 0.0
alter Vp2 = 0.0
alter Vp3 = 0.0
alter Vp0b = 0.0
alter Vp1b = 1.8
alter Vp2b = 1.8
alter Vp3b = 1.8
alter Vc0 = 1.8
alter Vc1 = 0.0
alter Vc2 = 1.8
alter Vc3 = 0.0
op
print i(VDD) >> dc_current.txt
alter Vp0 = 1.8
alter Vp1 = 0.0
alter Vp2 = 0.0
alter Vp3 = 0.0
alter Vp0b = 0.0
alter Vp1b = 1.8
alter Vp2b = 1.8
alter Vp3b = 1.8
alter Vc0 = 1.8
alter Vc1 = 0.0
alter Vc2 = 0.0
alter Vc3 = 1.8
op
print i(VDD) >> dc_current.txt
alter Vp0 = 1.8
alter Vp1 = 0.0
alter Vp2 = 0.0
alter Vp3 = 0.0
alter Vp0b = 0.0
alter Vp1b = 1.8
alter Vp2b = 1.8
alter Vp3b = 1.8
alter Vc0 = 1.8
alter Vc1 = 0.0
alter Vc2 = 0.0
alter Vc3 = 0.0
op
print i(VDD) >> dc_current.txt
alter Vp0 = 1.8
alter Vp1 = 0.0
alter Vp2 = 0.0
alter Vp3 = 0.0
alter Vp0b = 0.0
alter Vp1b = 1.8
alter Vp2b = 1.8
alter Vp3b = 1.8
alter Vc0 = 0.0
alter Vc1 = 1.8
alter Vc2 = 1.8
alter Vc3 = 1.8
op
print i(VDD) >> dc_current.txt
alter Vp0 = 1.8
alter Vp1 = 0.0
alter Vp2 = 0.0
alter Vp3 = 0.0
alter Vp0b = 0.0
alter Vp1b = 1.8
alter Vp2b = 1.8
alter Vp3b = 1.8
alter Vc0 = 0.0
alter Vc1 = 1.8
alter Vc2 = 1.8
alter Vc3 = 0.0
op
print i(VDD) >> dc_current.txt
alter Vp0 = 1.8
alter Vp1 = 0.0
alter Vp2 = 0.0
alter Vp3 = 0.0
alter Vp0b = 0.0
alter Vp1b = 1.8
alter Vp2b = 1.8
alter Vp3b = 1.8
alter Vc0 = 0.0
alter Vc1 = 1.8
alter Vc2 = 0.0
alter Vc3 = 1.8
op
print i(VDD) >> dc_current.txt
alter Vp0 = 1.8
alter Vp1 = 0.0
alter Vp2 = 0.0
alter Vp3 = 0.0
alter Vp0b = 0.0
alter Vp1b = 1.8
alter Vp2b = 1.8
alter Vp3b = 1.8
alter Vc0 = 0.0
alter Vc1 = 1.8
alter Vc2 = 0.0
alter Vc3 = 0.0
op
print i(VDD) >> dc_current.txt
alter Vp0 = 1.8
alter Vp1 = 0.0
alter Vp2 = 0.0
alter Vp3 = 0.0
alter Vp0b = 0.0
alter Vp1b = 1.8
alter Vp2b = 1.8
alter Vp3b = 1.8
alter Vc0 = 0.0
alter Vc1 = 0.0
alter Vc2 = 1.8
alter Vc3 = 1.8
op
print i(VDD) >> dc_current.txt
alter Vp0 = 1.8
alter Vp1 = 0.0
alter Vp2 = 0.0
alter Vp3 = 0.0
alter Vp0b = 0.0
alter Vp1b = 1.8
alter Vp2b = 1.8
alter Vp3b = 1.8
alter Vc0 = 0.0
alter Vc1 = 0.0
alter Vc2 = 1.8
alter Vc3 = 0.0
op
print i(VDD) >> dc_current.txt
alter Vp0 = 1.8
alter Vp1 = 0.0
alter Vp2 = 0.0
alter Vp3 = 0.0
alter Vp0b = 0.0
alter Vp1b = 1.8
alter Vp2b = 1.8
alter Vp3b = 1.8
alter Vc0 = 0.0
alter Vc1 = 0.0
alter Vc2 = 0.0
alter Vc3 = 1.8
op
print i(VDD) >> dc_current.txt
alter Vp0 = 1.8
alter Vp1 = 0.0
alter Vp2 = 0.0
alter Vp3 = 0.0
alter Vp0b = 0.0
alter Vp1b = 1.8
alter Vp2b = 1.8
alter Vp3b = 1.8
alter Vc0 = 0.0
alter Vc1 = 0.0
alter Vc2 = 0.0
alter Vc3 = 0.0
op
print i(VDD) >> dc_current.txt
alter Vp0 = 0.0
alter Vp1 = 1.8
alter Vp2 = 1.8
alter Vp3 = 1.8
alter Vp0b = 1.8
alter Vp1b = 0.0
alter Vp2b = 0.0
alter Vp3b = 0.0
alter Vc0 = 1.8
alter Vc1 = 1.8
alter Vc2 = 1.8
alter Vc3 = 1.8
op
print i(VDD) >> dc_current.txt
alter Vp0 = 0.0
alter Vp1 = 1.8
alter Vp2 = 1.8
alter Vp3 = 1.8
alter Vp0b = 1.8
alter Vp1b = 0.0
alter Vp2b = 0.0
alter Vp3b = 0.0
alter Vc0 = 1.8
alter Vc1 = 1.8
alter Vc2 = 1.8
alter Vc3 = 0.0
op
print i(VDD) >> dc_current.txt
alter Vp0 = 0.0
alter Vp1 = 1.8
alter Vp2 = 1.8
alter Vp3 = 1.8
alter Vp0b = 1.8
alter Vp1b = 0.0
alter Vp2b = 0.0
alter Vp3b = 0.0
alter Vc0 = 1.8
alter Vc1 = 1.8
alter Vc2 = 0.0
alter Vc3 = 1.8
op
print i(VDD) >> dc_current.txt
alter Vp0 = 0.0
alter Vp1 = 1.8
alter Vp2 = 1.8
alter Vp3 = 1.8
alter Vp0b = 1.8
alter Vp1b = 0.0
alter Vp2b = 0.0
alter Vp3b = 0.0
alter Vc0 = 1.8
alter Vc1 = 1.8
alter Vc2 = 0.0
alter Vc3 = 0.0
op
print i(VDD) >> dc_current.txt
alter Vp0 = 0.0
alter Vp1 = 1.8
alter Vp2 = 1.8
alter Vp3 = 1.8
alter Vp0b = 1.8
alter Vp1b = 0.0
alter Vp2b = 0.0
alter Vp3b = 0.0
alter Vc0 = 1.8
alter Vc1 = 0.0
alter Vc2 = 1.8
alter Vc3 = 1.8
op
print i(VDD) >> dc_current.txt
alter Vp0 = 0.0
alter Vp1 = 1.8
alter Vp2 = 1.8
alter Vp3 = 1.8
alter Vp0b = 1.8
alter Vp1b = 0.0
alter Vp2b = 0.0
alter Vp3b = 0.0
alter Vc0 = 1.8
alter Vc1 = 0.0
alter Vc2 = 1.8
alter Vc3 = 0.0
op
print i(VDD) >> dc_current.txt
alter Vp0 = 0.0
alter Vp1 = 1.8
alter Vp2 = 1.8
alter Vp3 = 1.8
alter Vp0b = 1.8
alter Vp1b = 0.0
alter Vp2b = 0.0
alter Vp3b = 0.0
alter Vc0 = 1.8
alter Vc1 = 0.0
alter Vc2 = 0.0
alter Vc3 = 1.8
op
print i(VDD) >> dc_current.txt
alter Vp0 = 0.0
alter Vp1 = 1.8
alter Vp2 = 1.8
alter Vp3 = 1.8
alter Vp0b = 1.8
alter Vp1b = 0.0
alter Vp2b = 0.0
alter Vp3b = 0.0
alter Vc0 = 1.8
alter Vc1 = 0.0
alter Vc2 = 0.0
alter Vc3 = 0.0
op
print i(VDD) >> dc_current.txt
alter Vp0 = 0.0
alter Vp1 = 1.8
alter Vp2 = 1.8
alter Vp3 = 1.8
alter Vp0b = 1.8
alter Vp1b = 0.0
alter Vp2b = 0.0
alter Vp3b = 0.0
alter Vc0 = 0.0
alter Vc1 = 1.8
alter Vc2 = 1.8
alter Vc3 = 1.8
op
print i(VDD) >> dc_current.txt
alter Vp0 = 0.0
alter Vp1 = 1.8
alter Vp2 = 1.8
alter Vp3 = 1.8
alter Vp0b = 1.8
alter Vp1b = 0.0
alter Vp2b = 0.0
alter Vp3b = 0.0
alter Vc0 = 0.0
alter Vc1 = 1.8
alter Vc2 = 1.8
alter Vc3 = 0.0
op
print i(VDD) >> dc_current.txt
alter Vp0 = 0.0
alter Vp1 = 1.8
alter Vp2 = 1.8
alter Vp3 = 1.8
alter Vp0b = 1.8
alter Vp1b = 0.0
alter Vp2b = 0.0
alter Vp3b = 0.0
alter Vc0 = 0.0
alter Vc1 = 1.8
alter Vc2 = 0.0
alter Vc3 = 1.8
op
print i(VDD) >> dc_current.txt
alter Vp0 = 0.0
alter Vp1 = 1.8
alter Vp2 = 1.8
alter Vp3 = 1.8
alter Vp0b = 1.8
alter Vp1b = 0.0
alter Vp2b = 0.0
alter Vp3b = 0.0
alter Vc0 = 0.0
alter Vc1 = 1.8
alter Vc2 = 0.0
alter Vc3 = 0.0
op
print i(VDD) >> dc_current.txt
alter Vp0 = 0.0
alter Vp1 = 1.8
alter Vp2 = 1.8
alter Vp3 = 1.8
alter Vp0b = 1.8
alter Vp1b = 0.0
alter Vp2b = 0.0
alter Vp3b = 0.0
alter Vc0 = 0.0
alter Vc1 = 0.0
alter Vc2 = 1.8
alter Vc3 = 1.8
op
print i(VDD) >> dc_current.txt
alter Vp0 = 0.0
alter Vp1 = 1.8
alter Vp2 = 1.8
alter Vp3 = 1.8
alter Vp0b = 1.8
alter Vp1b = 0.0
alter Vp2b = 0.0
alter Vp3b = 0.0
alter Vc0 = 0.0
alter Vc1 = 0.0
alter Vc2 = 1.8
alter Vc3 = 0.0
op
print i(VDD) >> dc_current.txt
alter Vp0 = 0.0
alter Vp1 = 1.8
alter Vp2 = 1.8
alter Vp3 = 1.8
alter Vp0b = 1.8
alter Vp1b = 0.0
alter Vp2b = 0.0
alter Vp3b = 0.0
alter Vc0 = 0.0
alter Vc1 = 0.0
alter Vc2 = 0.0
alter Vc3 = 1.8
op
print i(VDD) >> dc_current.txt
alter Vp0 = 0.0
alter Vp1 = 1.8
alter Vp2 = 1.8
alter Vp3 = 1.8
alter Vp0b = 1.8
alter Vp1b = 0.0
alter Vp2b = 0.0
alter Vp3b = 0.0
alter Vc0 = 0.0
alter Vc1 = 0.0
alter Vc2 = 0.0
alter Vc3 = 0.0
op
print i(VDD) >> dc_current.txt
alter Vp0 = 0.0
alter Vp1 = 1.8
alter Vp2 = 1.8
alter Vp3 = 0.0
alter Vp0b = 1.8
alter Vp1b = 0.0
alter Vp2b = 0.0
alter Vp3b = 1.8
alter Vc0 = 1.8
alter Vc1 = 1.8
alter Vc2 = 1.8
alter Vc3 = 1.8
op
print i(VDD) >> dc_current.txt
alter Vp0 = 0.0
alter Vp1 = 1.8
alter Vp2 = 1.8
alter Vp3 = 0.0
alter Vp0b = 1.8
alter Vp1b = 0.0
alter Vp2b = 0.0
alter Vp3b = 1.8
alter Vc0 = 1.8
alter Vc1 = 1.8
alter Vc2 = 1.8
alter Vc3 = 0.0
op
print i(VDD) >> dc_current.txt
alter Vp0 = 0.0
alter Vp1 = 1.8
alter Vp2 = 1.8
alter Vp3 = 0.0
alter Vp0b = 1.8
alter Vp1b = 0.0
alter Vp2b = 0.0
alter Vp3b = 1.8
alter Vc0 = 1.8
alter Vc1 = 1.8
alter Vc2 = 0.0
alter Vc3 = 1.8
op
print i(VDD) >> dc_current.txt
alter Vp0 = 0.0
alter Vp1 = 1.8
alter Vp2 = 1.8
alter Vp3 = 0.0
alter Vp0b = 1.8
alter Vp1b = 0.0
alter Vp2b = 0.0
alter Vp3b = 1.8
alter Vc0 = 1.8
alter Vc1 = 1.8
alter Vc2 = 0.0
alter Vc3 = 0.0
op
print i(VDD) >> dc_current.txt
alter Vp0 = 0.0
alter Vp1 = 1.8
alter Vp2 = 1.8
alter Vp3 = 0.0
alter Vp0b = 1.8
alter Vp1b = 0.0
alter Vp2b = 0.0
alter Vp3b = 1.8
alter Vc0 = 1.8
alter Vc1 = 0.0
alter Vc2 = 1.8
alter Vc3 = 1.8
op
print i(VDD) >> dc_current.txt
alter Vp0 = 0.0
alter Vp1 = 1.8
alter Vp2 = 1.8
alter Vp3 = 0.0
alter Vp0b = 1.8
alter Vp1b = 0.0
alter Vp2b = 0.0
alter Vp3b = 1.8
alter Vc0 = 1.8
alter Vc1 = 0.0
alter Vc2 = 1.8
alter Vc3 = 0.0
op
print i(VDD) >> dc_current.txt
alter Vp0 = 0.0
alter Vp1 = 1.8
alter Vp2 = 1.8
alter Vp3 = 0.0
alter Vp0b = 1.8
alter Vp1b = 0.0
alter Vp2b = 0.0
alter Vp3b = 1.8
alter Vc0 = 1.8
alter Vc1 = 0.0
alter Vc2 = 0.0
alter Vc3 = 1.8
op
print i(VDD) >> dc_current.txt
alter Vp0 = 0.0
alter Vp1 = 1.8
alter Vp2 = 1.8
alter Vp3 = 0.0
alter Vp0b = 1.8
alter Vp1b = 0.0
alter Vp2b = 0.0
alter Vp3b = 1.8
alter Vc0 = 1.8
alter Vc1 = 0.0
alter Vc2 = 0.0
alter Vc3 = 0.0
op
print i(VDD) >> dc_current.txt
alter Vp0 = 0.0
alter Vp1 = 1.8
alter Vp2 = 1.8
alter Vp3 = 0.0
alter Vp0b = 1.8
alter Vp1b = 0.0
alter Vp2b = 0.0
alter Vp3b = 1.8
alter Vc0 = 0.0
alter Vc1 = 1.8
alter Vc2 = 1.8
alter Vc3 = 1.8
op
print i(VDD) >> dc_current.txt
alter Vp0 = 0.0
alter Vp1 = 1.8
alter Vp2 = 1.8
alter Vp3 = 0.0
alter Vp0b = 1.8
alter Vp1b = 0.0
alter Vp2b = 0.0
alter Vp3b = 1.8
alter Vc0 = 0.0
alter Vc1 = 1.8
alter Vc2 = 1.8
alter Vc3 = 0.0
op
print i(VDD) >> dc_current.txt
alter Vp0 = 0.0
alter Vp1 = 1.8
alter Vp2 = 1.8
alter Vp3 = 0.0
alter Vp0b = 1.8
alter Vp1b = 0.0
alter Vp2b = 0.0
alter Vp3b = 1.8
alter Vc0 = 0.0
alter Vc1 = 1.8
alter Vc2 = 0.0
alter Vc3 = 1.8
op
print i(VDD) >> dc_current.txt
alter Vp0 = 0.0
alter Vp1 = 1.8
alter Vp2 = 1.8
alter Vp3 = 0.0
alter Vp0b = 1.8
alter Vp1b = 0.0
alter Vp2b = 0.0
alter Vp3b = 1.8
alter Vc0 = 0.0
alter Vc1 = 1.8
alter Vc2 = 0.0
alter Vc3 = 0.0
op
print i(VDD) >> dc_current.txt
alter Vp0 = 0.0
alter Vp1 = 1.8
alter Vp2 = 1.8
alter Vp3 = 0.0
alter Vp0b = 1.8
alter Vp1b = 0.0
alter Vp2b = 0.0
alter Vp3b = 1.8
alter Vc0 = 0.0
alter Vc1 = 0.0
alter Vc2 = 1.8
alter Vc3 = 1.8
op
print i(VDD) >> dc_current.txt
alter Vp0 = 0.0
alter Vp1 = 1.8
alter Vp2 = 1.8
alter Vp3 = 0.0
alter Vp0b = 1.8
alter Vp1b = 0.0
alter Vp2b = 0.0
alter Vp3b = 1.8
alter Vc0 = 0.0
alter Vc1 = 0.0
alter Vc2 = 1.8
alter Vc3 = 0.0
op
print i(VDD) >> dc_current.txt
alter Vp0 = 0.0
alter Vp1 = 1.8
alter Vp2 = 1.8
alter Vp3 = 0.0
alter Vp0b = 1.8
alter Vp1b = 0.0
alter Vp2b = 0.0
alter Vp3b = 1.8
alter Vc0 = 0.0
alter Vc1 = 0.0
alter Vc2 = 0.0
alter Vc3 = 1.8
op
print i(VDD) >> dc_current.txt
alter Vp0 = 0.0
alter Vp1 = 1.8
alter Vp2 = 1.8
alter Vp3 = 0.0
alter Vp0b = 1.8
alter Vp1b = 0.0
alter Vp2b = 0.0
alter Vp3b = 1.8
alter Vc0 = 0.0
alter Vc1 = 0.0
alter Vc2 = 0.0
alter Vc3 = 0.0
op
print i(VDD) >> dc_current.txt
alter Vp0 = 0.0
alter Vp1 = 1.8
alter Vp2 = 0.0
alter Vp3 = 1.8
alter Vp0b = 1.8
alter Vp1b = 0.0
alter Vp2b = 1.8
alter Vp3b = 0.0
alter Vc0 = 1.8
alter Vc1 = 1.8
alter Vc2 = 1.8
alter Vc3 = 1.8
op
print i(VDD) >> dc_current.txt
alter Vp0 = 0.0
alter Vp1 = 1.8
alter Vp2 = 0.0
alter Vp3 = 1.8
alter Vp0b = 1.8
alter Vp1b = 0.0
alter Vp2b = 1.8
alter Vp3b = 0.0
alter Vc0 = 1.8
alter Vc1 = 1.8
alter Vc2 = 1.8
alter Vc3 = 0.0
op
print i(VDD) >> dc_current.txt
alter Vp0 = 0.0
alter Vp1 = 1.8
alter Vp2 = 0.0
alter Vp3 = 1.8
alter Vp0b = 1.8
alter Vp1b = 0.0
alter Vp2b = 1.8
alter Vp3b = 0.0
alter Vc0 = 1.8
alter Vc1 = 1.8
alter Vc2 = 0.0
alter Vc3 = 1.8
op
print i(VDD) >> dc_current.txt
alter Vp0 = 0.0
alter Vp1 = 1.8
alter Vp2 = 0.0
alter Vp3 = 1.8
alter Vp0b = 1.8
alter Vp1b = 0.0
alter Vp2b = 1.8
alter Vp3b = 0.0
alter Vc0 = 1.8
alter Vc1 = 1.8
alter Vc2 = 0.0
alter Vc3 = 0.0
op
print i(VDD) >> dc_current.txt
alter Vp0 = 0.0
alter Vp1 = 1.8
alter Vp2 = 0.0
alter Vp3 = 1.8
alter Vp0b = 1.8
alter Vp1b = 0.0
alter Vp2b = 1.8
alter Vp3b = 0.0
alter Vc0 = 1.8
alter Vc1 = 0.0
alter Vc2 = 1.8
alter Vc3 = 1.8
op
print i(VDD) >> dc_current.txt
alter Vp0 = 0.0
alter Vp1 = 1.8
alter Vp2 = 0.0
alter Vp3 = 1.8
alter Vp0b = 1.8
alter Vp1b = 0.0
alter Vp2b = 1.8
alter Vp3b = 0.0
alter Vc0 = 1.8
alter Vc1 = 0.0
alter Vc2 = 1.8
alter Vc3 = 0.0
op
print i(VDD) >> dc_current.txt
alter Vp0 = 0.0
alter Vp1 = 1.8
alter Vp2 = 0.0
alter Vp3 = 1.8
alter Vp0b = 1.8
alter Vp1b = 0.0
alter Vp2b = 1.8
alter Vp3b = 0.0
alter Vc0 = 1.8
alter Vc1 = 0.0
alter Vc2 = 0.0
alter Vc3 = 1.8
op
print i(VDD) >> dc_current.txt
alter Vp0 = 0.0
alter Vp1 = 1.8
alter Vp2 = 0.0
alter Vp3 = 1.8
alter Vp0b = 1.8
alter Vp1b = 0.0
alter Vp2b = 1.8
alter Vp3b = 0.0
alter Vc0 = 1.8
alter Vc1 = 0.0
alter Vc2 = 0.0
alter Vc3 = 0.0
op
print i(VDD) >> dc_current.txt
alter Vp0 = 0.0
alter Vp1 = 1.8
alter Vp2 = 0.0
alter Vp3 = 1.8
alter Vp0b = 1.8
alter Vp1b = 0.0
alter Vp2b = 1.8
alter Vp3b = 0.0
alter Vc0 = 0.0
alter Vc1 = 1.8
alter Vc2 = 1.8
alter Vc3 = 1.8
op
print i(VDD) >> dc_current.txt
alter Vp0 = 0.0
alter Vp1 = 1.8
alter Vp2 = 0.0
alter Vp3 = 1.8
alter Vp0b = 1.8
alter Vp1b = 0.0
alter Vp2b = 1.8
alter Vp3b = 0.0
alter Vc0 = 0.0
alter Vc1 = 1.8
alter Vc2 = 1.8
alter Vc3 = 0.0
op
print i(VDD) >> dc_current.txt
alter Vp0 = 0.0
alter Vp1 = 1.8
alter Vp2 = 0.0
alter Vp3 = 1.8
alter Vp0b = 1.8
alter Vp1b = 0.0
alter Vp2b = 1.8
alter Vp3b = 0.0
alter Vc0 = 0.0
alter Vc1 = 1.8
alter Vc2 = 0.0
alter Vc3 = 1.8
op
print i(VDD) >> dc_current.txt
alter Vp0 = 0.0
alter Vp1 = 1.8
alter Vp2 = 0.0
alter Vp3 = 1.8
alter Vp0b = 1.8
alter Vp1b = 0.0
alter Vp2b = 1.8
alter Vp3b = 0.0
alter Vc0 = 0.0
alter Vc1 = 1.8
alter Vc2 = 0.0
alter Vc3 = 0.0
op
print i(VDD) >> dc_current.txt
alter Vp0 = 0.0
alter Vp1 = 1.8
alter Vp2 = 0.0
alter Vp3 = 1.8
alter Vp0b = 1.8
alter Vp1b = 0.0
alter Vp2b = 1.8
alter Vp3b = 0.0
alter Vc0 = 0.0
alter Vc1 = 0.0
alter Vc2 = 1.8
alter Vc3 = 1.8
op
print i(VDD) >> dc_current.txt
alter Vp0 = 0.0
alter Vp1 = 1.8
alter Vp2 = 0.0
alter Vp3 = 1.8
alter Vp0b = 1.8
alter Vp1b = 0.0
alter Vp2b = 1.8
alter Vp3b = 0.0
alter Vc0 = 0.0
alter Vc1 = 0.0
alter Vc2 = 1.8
alter Vc3 = 0.0
op
print i(VDD) >> dc_current.txt
alter Vp0 = 0.0
alter Vp1 = 1.8
alter Vp2 = 0.0
alter Vp3 = 1.8
alter Vp0b = 1.8
alter Vp1b = 0.0
alter Vp2b = 1.8
alter Vp3b = 0.0
alter Vc0 = 0.0
alter Vc1 = 0.0
alter Vc2 = 0.0
alter Vc3 = 1.8
op
print i(VDD) >> dc_current.txt
alter Vp0 = 0.0
alter Vp1 = 1.8
alter Vp2 = 0.0
alter Vp3 = 1.8
alter Vp0b = 1.8
alter Vp1b = 0.0
alter Vp2b = 1.8
alter Vp3b = 0.0
alter Vc0 = 0.0
alter Vc1 = 0.0
alter Vc2 = 0.0
alter Vc3 = 0.0
op
print i(VDD) >> dc_current.txt
alter Vp0 = 0.0
alter Vp1 = 1.8
alter Vp2 = 0.0
alter Vp3 = 0.0
alter Vp0b = 1.8
alter Vp1b = 0.0
alter Vp2b = 1.8
alter Vp3b = 1.8
alter Vc0 = 1.8
alter Vc1 = 1.8
alter Vc2 = 1.8
alter Vc3 = 1.8
op
print i(VDD) >> dc_current.txt
alter Vp0 = 0.0
alter Vp1 = 1.8
alter Vp2 = 0.0
alter Vp3 = 0.0
alter Vp0b = 1.8
alter Vp1b = 0.0
alter Vp2b = 1.8
alter Vp3b = 1.8
alter Vc0 = 1.8
alter Vc1 = 1.8
alter Vc2 = 1.8
alter Vc3 = 0.0
op
print i(VDD) >> dc_current.txt
alter Vp0 = 0.0
alter Vp1 = 1.8
alter Vp2 = 0.0
alter Vp3 = 0.0
alter Vp0b = 1.8
alter Vp1b = 0.0
alter Vp2b = 1.8
alter Vp3b = 1.8
alter Vc0 = 1.8
alter Vc1 = 1.8
alter Vc2 = 0.0
alter Vc3 = 1.8
op
print i(VDD) >> dc_current.txt
alter Vp0 = 0.0
alter Vp1 = 1.8
alter Vp2 = 0.0
alter Vp3 = 0.0
alter Vp0b = 1.8
alter Vp1b = 0.0
alter Vp2b = 1.8
alter Vp3b = 1.8
alter Vc0 = 1.8
alter Vc1 = 1.8
alter Vc2 = 0.0
alter Vc3 = 0.0
op
print i(VDD) >> dc_current.txt
alter Vp0 = 0.0
alter Vp1 = 1.8
alter Vp2 = 0.0
alter Vp3 = 0.0
alter Vp0b = 1.8
alter Vp1b = 0.0
alter Vp2b = 1.8
alter Vp3b = 1.8
alter Vc0 = 1.8
alter Vc1 = 0.0
alter Vc2 = 1.8
alter Vc3 = 1.8
op
print i(VDD) >> dc_current.txt
alter Vp0 = 0.0
alter Vp1 = 1.8
alter Vp2 = 0.0
alter Vp3 = 0.0
alter Vp0b = 1.8
alter Vp1b = 0.0
alter Vp2b = 1.8
alter Vp3b = 1.8
alter Vc0 = 1.8
alter Vc1 = 0.0
alter Vc2 = 1.8
alter Vc3 = 0.0
op
print i(VDD) >> dc_current.txt
alter Vp0 = 0.0
alter Vp1 = 1.8
alter Vp2 = 0.0
alter Vp3 = 0.0
alter Vp0b = 1.8
alter Vp1b = 0.0
alter Vp2b = 1.8
alter Vp3b = 1.8
alter Vc0 = 1.8
alter Vc1 = 0.0
alter Vc2 = 0.0
alter Vc3 = 1.8
op
print i(VDD) >> dc_current.txt
alter Vp0 = 0.0
alter Vp1 = 1.8
alter Vp2 = 0.0
alter Vp3 = 0.0
alter Vp0b = 1.8
alter Vp1b = 0.0
alter Vp2b = 1.8
alter Vp3b = 1.8
alter Vc0 = 1.8
alter Vc1 = 0.0
alter Vc2 = 0.0
alter Vc3 = 0.0
op
print i(VDD) >> dc_current.txt
alter Vp0 = 0.0
alter Vp1 = 1.8
alter Vp2 = 0.0
alter Vp3 = 0.0
alter Vp0b = 1.8
alter Vp1b = 0.0
alter Vp2b = 1.8
alter Vp3b = 1.8
alter Vc0 = 0.0
alter Vc1 = 1.8
alter Vc2 = 1.8
alter Vc3 = 1.8
op
print i(VDD) >> dc_current.txt
alter Vp0 = 0.0
alter Vp1 = 1.8
alter Vp2 = 0.0
alter Vp3 = 0.0
alter Vp0b = 1.8
alter Vp1b = 0.0
alter Vp2b = 1.8
alter Vp3b = 1.8
alter Vc0 = 0.0
alter Vc1 = 1.8
alter Vc2 = 1.8
alter Vc3 = 0.0
op
print i(VDD) >> dc_current.txt
alter Vp0 = 0.0
alter Vp1 = 1.8
alter Vp2 = 0.0
alter Vp3 = 0.0
alter Vp0b = 1.8
alter Vp1b = 0.0
alter Vp2b = 1.8
alter Vp3b = 1.8
alter Vc0 = 0.0
alter Vc1 = 1.8
alter Vc2 = 0.0
alter Vc3 = 1.8
op
print i(VDD) >> dc_current.txt
alter Vp0 = 0.0
alter Vp1 = 1.8
alter Vp2 = 0.0
alter Vp3 = 0.0
alter Vp0b = 1.8
alter Vp1b = 0.0
alter Vp2b = 1.8
alter Vp3b = 1.8
alter Vc0 = 0.0
alter Vc1 = 1.8
alter Vc2 = 0.0
alter Vc3 = 0.0
op
print i(VDD) >> dc_current.txt
alter Vp0 = 0.0
alter Vp1 = 1.8
alter Vp2 = 0.0
alter Vp3 = 0.0
alter Vp0b = 1.8
alter Vp1b = 0.0
alter Vp2b = 1.8
alter Vp3b = 1.8
alter Vc0 = 0.0
alter Vc1 = 0.0
alter Vc2 = 1.8
alter Vc3 = 1.8
op
print i(VDD) >> dc_current.txt
alter Vp0 = 0.0
alter Vp1 = 1.8
alter Vp2 = 0.0
alter Vp3 = 0.0
alter Vp0b = 1.8
alter Vp1b = 0.0
alter Vp2b = 1.8
alter Vp3b = 1.8
alter Vc0 = 0.0
alter Vc1 = 0.0
alter Vc2 = 1.8
alter Vc3 = 0.0
op
print i(VDD) >> dc_current.txt
alter Vp0 = 0.0
alter Vp1 = 1.8
alter Vp2 = 0.0
alter Vp3 = 0.0
alter Vp0b = 1.8
alter Vp1b = 0.0
alter Vp2b = 1.8
alter Vp3b = 1.8
alter Vc0 = 0.0
alter Vc1 = 0.0
alter Vc2 = 0.0
alter Vc3 = 1.8
op
print i(VDD) >> dc_current.txt
alter Vp0 = 0.0
alter Vp1 = 1.8
alter Vp2 = 0.0
alter Vp3 = 0.0
alter Vp0b = 1.8
alter Vp1b = 0.0
alter Vp2b = 1.8
alter Vp3b = 1.8
alter Vc0 = 0.0
alter Vc1 = 0.0
alter Vc2 = 0.0
alter Vc3 = 0.0
op
print i(VDD) >> dc_current.txt
alter Vp0 = 0.0
alter Vp1 = 0.0
alter Vp2 = 1.8
alter Vp3 = 1.8
alter Vp0b = 1.8
alter Vp1b = 1.8
alter Vp2b = 0.0
alter Vp3b = 0.0
alter Vc0 = 1.8
alter Vc1 = 1.8
alter Vc2 = 1.8
alter Vc3 = 1.8
op
print i(VDD) >> dc_current.txt
alter Vp0 = 0.0
alter Vp1 = 0.0
alter Vp2 = 1.8
alter Vp3 = 1.8
alter Vp0b = 1.8
alter Vp1b = 1.8
alter Vp2b = 0.0
alter Vp3b = 0.0
alter Vc0 = 1.8
alter Vc1 = 1.8
alter Vc2 = 1.8
alter Vc3 = 0.0
op
print i(VDD) >> dc_current.txt
alter Vp0 = 0.0
alter Vp1 = 0.0
alter Vp2 = 1.8
alter Vp3 = 1.8
alter Vp0b = 1.8
alter Vp1b = 1.8
alter Vp2b = 0.0
alter Vp3b = 0.0
alter Vc0 = 1.8
alter Vc1 = 1.8
alter Vc2 = 0.0
alter Vc3 = 1.8
op
print i(VDD) >> dc_current.txt
alter Vp0 = 0.0
alter Vp1 = 0.0
alter Vp2 = 1.8
alter Vp3 = 1.8
alter Vp0b = 1.8
alter Vp1b = 1.8
alter Vp2b = 0.0
alter Vp3b = 0.0
alter Vc0 = 1.8
alter Vc1 = 1.8
alter Vc2 = 0.0
alter Vc3 = 0.0
op
print i(VDD) >> dc_current.txt
alter Vp0 = 0.0
alter Vp1 = 0.0
alter Vp2 = 1.8
alter Vp3 = 1.8
alter Vp0b = 1.8
alter Vp1b = 1.8
alter Vp2b = 0.0
alter Vp3b = 0.0
alter Vc0 = 1.8
alter Vc1 = 0.0
alter Vc2 = 1.8
alter Vc3 = 1.8
op
print i(VDD) >> dc_current.txt
alter Vp0 = 0.0
alter Vp1 = 0.0
alter Vp2 = 1.8
alter Vp3 = 1.8
alter Vp0b = 1.8
alter Vp1b = 1.8
alter Vp2b = 0.0
alter Vp3b = 0.0
alter Vc0 = 1.8
alter Vc1 = 0.0
alter Vc2 = 1.8
alter Vc3 = 0.0
op
print i(VDD) >> dc_current.txt
alter Vp0 = 0.0
alter Vp1 = 0.0
alter Vp2 = 1.8
alter Vp3 = 1.8
alter Vp0b = 1.8
alter Vp1b = 1.8
alter Vp2b = 0.0
alter Vp3b = 0.0
alter Vc0 = 1.8
alter Vc1 = 0.0
alter Vc2 = 0.0
alter Vc3 = 1.8
op
print i(VDD) >> dc_current.txt
alter Vp0 = 0.0
alter Vp1 = 0.0
alter Vp2 = 1.8
alter Vp3 = 1.8
alter Vp0b = 1.8
alter Vp1b = 1.8
alter Vp2b = 0.0
alter Vp3b = 0.0
alter Vc0 = 1.8
alter Vc1 = 0.0
alter Vc2 = 0.0
alter Vc3 = 0.0
op
print i(VDD) >> dc_current.txt
alter Vp0 = 0.0
alter Vp1 = 0.0
alter Vp2 = 1.8
alter Vp3 = 1.8
alter Vp0b = 1.8
alter Vp1b = 1.8
alter Vp2b = 0.0
alter Vp3b = 0.0
alter Vc0 = 0.0
alter Vc1 = 1.8
alter Vc2 = 1.8
alter Vc3 = 1.8
op
print i(VDD) >> dc_current.txt
alter Vp0 = 0.0
alter Vp1 = 0.0
alter Vp2 = 1.8
alter Vp3 = 1.8
alter Vp0b = 1.8
alter Vp1b = 1.8
alter Vp2b = 0.0
alter Vp3b = 0.0
alter Vc0 = 0.0
alter Vc1 = 1.8
alter Vc2 = 1.8
alter Vc3 = 0.0
op
print i(VDD) >> dc_current.txt
alter Vp0 = 0.0
alter Vp1 = 0.0
alter Vp2 = 1.8
alter Vp3 = 1.8
alter Vp0b = 1.8
alter Vp1b = 1.8
alter Vp2b = 0.0
alter Vp3b = 0.0
alter Vc0 = 0.0
alter Vc1 = 1.8
alter Vc2 = 0.0
alter Vc3 = 1.8
op
print i(VDD) >> dc_current.txt
alter Vp0 = 0.0
alter Vp1 = 0.0
alter Vp2 = 1.8
alter Vp3 = 1.8
alter Vp0b = 1.8
alter Vp1b = 1.8
alter Vp2b = 0.0
alter Vp3b = 0.0
alter Vc0 = 0.0
alter Vc1 = 1.8
alter Vc2 = 0.0
alter Vc3 = 0.0
op
print i(VDD) >> dc_current.txt
alter Vp0 = 0.0
alter Vp1 = 0.0
alter Vp2 = 1.8
alter Vp3 = 1.8
alter Vp0b = 1.8
alter Vp1b = 1.8
alter Vp2b = 0.0
alter Vp3b = 0.0
alter Vc0 = 0.0
alter Vc1 = 0.0
alter Vc2 = 1.8
alter Vc3 = 1.8
op
print i(VDD) >> dc_current.txt
alter Vp0 = 0.0
alter Vp1 = 0.0
alter Vp2 = 1.8
alter Vp3 = 1.8
alter Vp0b = 1.8
alter Vp1b = 1.8
alter Vp2b = 0.0
alter Vp3b = 0.0
alter Vc0 = 0.0
alter Vc1 = 0.0
alter Vc2 = 1.8
alter Vc3 = 0.0
op
print i(VDD) >> dc_current.txt
alter Vp0 = 0.0
alter Vp1 = 0.0
alter Vp2 = 1.8
alter Vp3 = 1.8
alter Vp0b = 1.8
alter Vp1b = 1.8
alter Vp2b = 0.0
alter Vp3b = 0.0
alter Vc0 = 0.0
alter Vc1 = 0.0
alter Vc2 = 0.0
alter Vc3 = 1.8
op
print i(VDD) >> dc_current.txt
alter Vp0 = 0.0
alter Vp1 = 0.0
alter Vp2 = 1.8
alter Vp3 = 1.8
alter Vp0b = 1.8
alter Vp1b = 1.8
alter Vp2b = 0.0
alter Vp3b = 0.0
alter Vc0 = 0.0
alter Vc1 = 0.0
alter Vc2 = 0.0
alter Vc3 = 0.0
op
print i(VDD) >> dc_current.txt
alter Vp0 = 0.0
alter Vp1 = 0.0
alter Vp2 = 1.8
alter Vp3 = 0.0
alter Vp0b = 1.8
alter Vp1b = 1.8
alter Vp2b = 0.0
alter Vp3b = 1.8
alter Vc0 = 1.8
alter Vc1 = 1.8
alter Vc2 = 1.8
alter Vc3 = 1.8
op
print i(VDD) >> dc_current.txt
alter Vp0 = 0.0
alter Vp1 = 0.0
alter Vp2 = 1.8
alter Vp3 = 0.0
alter Vp0b = 1.8
alter Vp1b = 1.8
alter Vp2b = 0.0
alter Vp3b = 1.8
alter Vc0 = 1.8
alter Vc1 = 1.8
alter Vc2 = 1.8
alter Vc3 = 0.0
op
print i(VDD) >> dc_current.txt
alter Vp0 = 0.0
alter Vp1 = 0.0
alter Vp2 = 1.8
alter Vp3 = 0.0
alter Vp0b = 1.8
alter Vp1b = 1.8
alter Vp2b = 0.0
alter Vp3b = 1.8
alter Vc0 = 1.8
alter Vc1 = 1.8
alter Vc2 = 0.0
alter Vc3 = 1.8
op
print i(VDD) >> dc_current.txt
alter Vp0 = 0.0
alter Vp1 = 0.0
alter Vp2 = 1.8
alter Vp3 = 0.0
alter Vp0b = 1.8
alter Vp1b = 1.8
alter Vp2b = 0.0
alter Vp3b = 1.8
alter Vc0 = 1.8
alter Vc1 = 1.8
alter Vc2 = 0.0
alter Vc3 = 0.0
op
print i(VDD) >> dc_current.txt
alter Vp0 = 0.0
alter Vp1 = 0.0
alter Vp2 = 1.8
alter Vp3 = 0.0
alter Vp0b = 1.8
alter Vp1b = 1.8
alter Vp2b = 0.0
alter Vp3b = 1.8
alter Vc0 = 1.8
alter Vc1 = 0.0
alter Vc2 = 1.8
alter Vc3 = 1.8
op
print i(VDD) >> dc_current.txt
alter Vp0 = 0.0
alter Vp1 = 0.0
alter Vp2 = 1.8
alter Vp3 = 0.0
alter Vp0b = 1.8
alter Vp1b = 1.8
alter Vp2b = 0.0
alter Vp3b = 1.8
alter Vc0 = 1.8
alter Vc1 = 0.0
alter Vc2 = 1.8
alter Vc3 = 0.0
op
print i(VDD) >> dc_current.txt
alter Vp0 = 0.0
alter Vp1 = 0.0
alter Vp2 = 1.8
alter Vp3 = 0.0
alter Vp0b = 1.8
alter Vp1b = 1.8
alter Vp2b = 0.0
alter Vp3b = 1.8
alter Vc0 = 1.8
alter Vc1 = 0.0
alter Vc2 = 0.0
alter Vc3 = 1.8
op
print i(VDD) >> dc_current.txt
alter Vp0 = 0.0
alter Vp1 = 0.0
alter Vp2 = 1.8
alter Vp3 = 0.0
alter Vp0b = 1.8
alter Vp1b = 1.8
alter Vp2b = 0.0
alter Vp3b = 1.8
alter Vc0 = 1.8
alter Vc1 = 0.0
alter Vc2 = 0.0
alter Vc3 = 0.0
op
print i(VDD) >> dc_current.txt
alter Vp0 = 0.0
alter Vp1 = 0.0
alter Vp2 = 1.8
alter Vp3 = 0.0
alter Vp0b = 1.8
alter Vp1b = 1.8
alter Vp2b = 0.0
alter Vp3b = 1.8
alter Vc0 = 0.0
alter Vc1 = 1.8
alter Vc2 = 1.8
alter Vc3 = 1.8
op
print i(VDD) >> dc_current.txt
alter Vp0 = 0.0
alter Vp1 = 0.0
alter Vp2 = 1.8
alter Vp3 = 0.0
alter Vp0b = 1.8
alter Vp1b = 1.8
alter Vp2b = 0.0
alter Vp3b = 1.8
alter Vc0 = 0.0
alter Vc1 = 1.8
alter Vc2 = 1.8
alter Vc3 = 0.0
op
print i(VDD) >> dc_current.txt
alter Vp0 = 0.0
alter Vp1 = 0.0
alter Vp2 = 1.8
alter Vp3 = 0.0
alter Vp0b = 1.8
alter Vp1b = 1.8
alter Vp2b = 0.0
alter Vp3b = 1.8
alter Vc0 = 0.0
alter Vc1 = 1.8
alter Vc2 = 0.0
alter Vc3 = 1.8
op
print i(VDD) >> dc_current.txt
alter Vp0 = 0.0
alter Vp1 = 0.0
alter Vp2 = 1.8
alter Vp3 = 0.0
alter Vp0b = 1.8
alter Vp1b = 1.8
alter Vp2b = 0.0
alter Vp3b = 1.8
alter Vc0 = 0.0
alter Vc1 = 1.8
alter Vc2 = 0.0
alter Vc3 = 0.0
op
print i(VDD) >> dc_current.txt
alter Vp0 = 0.0
alter Vp1 = 0.0
alter Vp2 = 1.8
alter Vp3 = 0.0
alter Vp0b = 1.8
alter Vp1b = 1.8
alter Vp2b = 0.0
alter Vp3b = 1.8
alter Vc0 = 0.0
alter Vc1 = 0.0
alter Vc2 = 1.8
alter Vc3 = 1.8
op
print i(VDD) >> dc_current.txt
alter Vp0 = 0.0
alter Vp1 = 0.0
alter Vp2 = 1.8
alter Vp3 = 0.0
alter Vp0b = 1.8
alter Vp1b = 1.8
alter Vp2b = 0.0
alter Vp3b = 1.8
alter Vc0 = 0.0
alter Vc1 = 0.0
alter Vc2 = 1.8
alter Vc3 = 0.0
op
print i(VDD) >> dc_current.txt
alter Vp0 = 0.0
alter Vp1 = 0.0
alter Vp2 = 1.8
alter Vp3 = 0.0
alter Vp0b = 1.8
alter Vp1b = 1.8
alter Vp2b = 0.0
alter Vp3b = 1.8
alter Vc0 = 0.0
alter Vc1 = 0.0
alter Vc2 = 0.0
alter Vc3 = 1.8
op
print i(VDD) >> dc_current.txt
alter Vp0 = 0.0
alter Vp1 = 0.0
alter Vp2 = 1.8
alter Vp3 = 0.0
alter Vp0b = 1.8
alter Vp1b = 1.8
alter Vp2b = 0.0
alter Vp3b = 1.8
alter Vc0 = 0.0
alter Vc1 = 0.0
alter Vc2 = 0.0
alter Vc3 = 0.0
op
print i(VDD) >> dc_current.txt
alter Vp0 = 0.0
alter Vp1 = 0.0
alter Vp2 = 0.0
alter Vp3 = 1.8
alter Vp0b = 1.8
alter Vp1b = 1.8
alter Vp2b = 1.8
alter Vp3b = 0.0
alter Vc0 = 1.8
alter Vc1 = 1.8
alter Vc2 = 1.8
alter Vc3 = 1.8
op
print i(VDD) >> dc_current.txt
alter Vp0 = 0.0
alter Vp1 = 0.0
alter Vp2 = 0.0
alter Vp3 = 1.8
alter Vp0b = 1.8
alter Vp1b = 1.8
alter Vp2b = 1.8
alter Vp3b = 0.0
alter Vc0 = 1.8
alter Vc1 = 1.8
alter Vc2 = 1.8
alter Vc3 = 0.0
op
print i(VDD) >> dc_current.txt
alter Vp0 = 0.0
alter Vp1 = 0.0
alter Vp2 = 0.0
alter Vp3 = 1.8
alter Vp0b = 1.8
alter Vp1b = 1.8
alter Vp2b = 1.8
alter Vp3b = 0.0
alter Vc0 = 1.8
alter Vc1 = 1.8
alter Vc2 = 0.0
alter Vc3 = 1.8
op
print i(VDD) >> dc_current.txt
alter Vp0 = 0.0
alter Vp1 = 0.0
alter Vp2 = 0.0
alter Vp3 = 1.8
alter Vp0b = 1.8
alter Vp1b = 1.8
alter Vp2b = 1.8
alter Vp3b = 0.0
alter Vc0 = 1.8
alter Vc1 = 1.8
alter Vc2 = 0.0
alter Vc3 = 0.0
op
print i(VDD) >> dc_current.txt
alter Vp0 = 0.0
alter Vp1 = 0.0
alter Vp2 = 0.0
alter Vp3 = 1.8
alter Vp0b = 1.8
alter Vp1b = 1.8
alter Vp2b = 1.8
alter Vp3b = 0.0
alter Vc0 = 1.8
alter Vc1 = 0.0
alter Vc2 = 1.8
alter Vc3 = 1.8
op
print i(VDD) >> dc_current.txt
alter Vp0 = 0.0
alter Vp1 = 0.0
alter Vp2 = 0.0
alter Vp3 = 1.8
alter Vp0b = 1.8
alter Vp1b = 1.8
alter Vp2b = 1.8
alter Vp3b = 0.0
alter Vc0 = 1.8
alter Vc1 = 0.0
alter Vc2 = 1.8
alter Vc3 = 0.0
op
print i(VDD) >> dc_current.txt
alter Vp0 = 0.0
alter Vp1 = 0.0
alter Vp2 = 0.0
alter Vp3 = 1.8
alter Vp0b = 1.8
alter Vp1b = 1.8
alter Vp2b = 1.8
alter Vp3b = 0.0
alter Vc0 = 1.8
alter Vc1 = 0.0
alter Vc2 = 0.0
alter Vc3 = 1.8
op
print i(VDD) >> dc_current.txt
alter Vp0 = 0.0
alter Vp1 = 0.0
alter Vp2 = 0.0
alter Vp3 = 1.8
alter Vp0b = 1.8
alter Vp1b = 1.8
alter Vp2b = 1.8
alter Vp3b = 0.0
alter Vc0 = 1.8
alter Vc1 = 0.0
alter Vc2 = 0.0
alter Vc3 = 0.0
op
print i(VDD) >> dc_current.txt
alter Vp0 = 0.0
alter Vp1 = 0.0
alter Vp2 = 0.0
alter Vp3 = 1.8
alter Vp0b = 1.8
alter Vp1b = 1.8
alter Vp2b = 1.8
alter Vp3b = 0.0
alter Vc0 = 0.0
alter Vc1 = 1.8
alter Vc2 = 1.8
alter Vc3 = 1.8
op
print i(VDD) >> dc_current.txt
alter Vp0 = 0.0
alter Vp1 = 0.0
alter Vp2 = 0.0
alter Vp3 = 1.8
alter Vp0b = 1.8
alter Vp1b = 1.8
alter Vp2b = 1.8
alter Vp3b = 0.0
alter Vc0 = 0.0
alter Vc1 = 1.8
alter Vc2 = 1.8
alter Vc3 = 0.0
op
print i(VDD) >> dc_current.txt
alter Vp0 = 0.0
alter Vp1 = 0.0
alter Vp2 = 0.0
alter Vp3 = 1.8
alter Vp0b = 1.8
alter Vp1b = 1.8
alter Vp2b = 1.8
alter Vp3b = 0.0
alter Vc0 = 0.0
alter Vc1 = 1.8
alter Vc2 = 0.0
alter Vc3 = 1.8
op
print i(VDD) >> dc_current.txt
alter Vp0 = 0.0
alter Vp1 = 0.0
alter Vp2 = 0.0
alter Vp3 = 1.8
alter Vp0b = 1.8
alter Vp1b = 1.8
alter Vp2b = 1.8
alter Vp3b = 0.0
alter Vc0 = 0.0
alter Vc1 = 1.8
alter Vc2 = 0.0
alter Vc3 = 0.0
op
print i(VDD) >> dc_current.txt
alter Vp0 = 0.0
alter Vp1 = 0.0
alter Vp2 = 0.0
alter Vp3 = 1.8
alter Vp0b = 1.8
alter Vp1b = 1.8
alter Vp2b = 1.8
alter Vp3b = 0.0
alter Vc0 = 0.0
alter Vc1 = 0.0
alter Vc2 = 1.8
alter Vc3 = 1.8
op
print i(VDD) >> dc_current.txt
alter Vp0 = 0.0
alter Vp1 = 0.0
alter Vp2 = 0.0
alter Vp3 = 1.8
alter Vp0b = 1.8
alter Vp1b = 1.8
alter Vp2b = 1.8
alter Vp3b = 0.0
alter Vc0 = 0.0
alter Vc1 = 0.0
alter Vc2 = 1.8
alter Vc3 = 0.0
op
print i(VDD) >> dc_current.txt
alter Vp0 = 0.0
alter Vp1 = 0.0
alter Vp2 = 0.0
alter Vp3 = 1.8
alter Vp0b = 1.8
alter Vp1b = 1.8
alter Vp2b = 1.8
alter Vp3b = 0.0
alter Vc0 = 0.0
alter Vc1 = 0.0
alter Vc2 = 0.0
alter Vc3 = 1.8
op
print i(VDD) >> dc_current.txt
alter Vp0 = 0.0
alter Vp1 = 0.0
alter Vp2 = 0.0
alter Vp3 = 1.8
alter Vp0b = 1.8
alter Vp1b = 1.8
alter Vp2b = 1.8
alter Vp3b = 0.0
alter Vc0 = 0.0
alter Vc1 = 0.0
alter Vc2 = 0.0
alter Vc3 = 0.0
op
print i(VDD) >> dc_current.txt
alter Vp0 = 0.0
alter Vp1 = 0.0
alter Vp2 = 0.0
alter Vp3 = 0.0
alter Vp0b = 1.8
alter Vp1b = 1.8
alter Vp2b = 1.8
alter Vp3b = 1.8
alter Vc0 = 1.8
alter Vc1 = 1.8
alter Vc2 = 1.8
alter Vc3 = 1.8
op
print i(VDD) >> dc_current.txt
alter Vp0 = 0.0
alter Vp1 = 0.0
alter Vp2 = 0.0
alter Vp3 = 0.0
alter Vp0b = 1.8
alter Vp1b = 1.8
alter Vp2b = 1.8
alter Vp3b = 1.8
alter Vc0 = 1.8
alter Vc1 = 1.8
alter Vc2 = 1.8
alter Vc3 = 0.0
op
print i(VDD) >> dc_current.txt
alter Vp0 = 0.0
alter Vp1 = 0.0
alter Vp2 = 0.0
alter Vp3 = 0.0
alter Vp0b = 1.8
alter Vp1b = 1.8
alter Vp2b = 1.8
alter Vp3b = 1.8
alter Vc0 = 1.8
alter Vc1 = 1.8
alter Vc2 = 0.0
alter Vc3 = 1.8
op
print i(VDD) >> dc_current.txt
alter Vp0 = 0.0
alter Vp1 = 0.0
alter Vp2 = 0.0
alter Vp3 = 0.0
alter Vp0b = 1.8
alter Vp1b = 1.8
alter Vp2b = 1.8
alter Vp3b = 1.8
alter Vc0 = 1.8
alter Vc1 = 1.8
alter Vc2 = 0.0
alter Vc3 = 0.0
op
print i(VDD) >> dc_current.txt
alter Vp0 = 0.0
alter Vp1 = 0.0
alter Vp2 = 0.0
alter Vp3 = 0.0
alter Vp0b = 1.8
alter Vp1b = 1.8
alter Vp2b = 1.8
alter Vp3b = 1.8
alter Vc0 = 1.8
alter Vc1 = 0.0
alter Vc2 = 1.8
alter Vc3 = 1.8
op
print i(VDD) >> dc_current.txt
alter Vp0 = 0.0
alter Vp1 = 0.0
alter Vp2 = 0.0
alter Vp3 = 0.0
alter Vp0b = 1.8
alter Vp1b = 1.8
alter Vp2b = 1.8
alter Vp3b = 1.8
alter Vc0 = 1.8
alter Vc1 = 0.0
alter Vc2 = 1.8
alter Vc3 = 0.0
op
print i(VDD) >> dc_current.txt
alter Vp0 = 0.0
alter Vp1 = 0.0
alter Vp2 = 0.0
alter Vp3 = 0.0
alter Vp0b = 1.8
alter Vp1b = 1.8
alter Vp2b = 1.8
alter Vp3b = 1.8
alter Vc0 = 1.8
alter Vc1 = 0.0
alter Vc2 = 0.0
alter Vc3 = 1.8
op
print i(VDD) >> dc_current.txt
alter Vp0 = 0.0
alter Vp1 = 0.0
alter Vp2 = 0.0
alter Vp3 = 0.0
alter Vp0b = 1.8
alter Vp1b = 1.8
alter Vp2b = 1.8
alter Vp3b = 1.8
alter Vc0 = 1.8
alter Vc1 = 0.0
alter Vc2 = 0.0
alter Vc3 = 0.0
op
print i(VDD) >> dc_current.txt
alter Vp0 = 0.0
alter Vp1 = 0.0
alter Vp2 = 0.0
alter Vp3 = 0.0
alter Vp0b = 1.8
alter Vp1b = 1.8
alter Vp2b = 1.8
alter Vp3b = 1.8
alter Vc0 = 0.0
alter Vc1 = 1.8
alter Vc2 = 1.8
alter Vc3 = 1.8
op
print i(VDD) >> dc_current.txt
alter Vp0 = 0.0
alter Vp1 = 0.0
alter Vp2 = 0.0
alter Vp3 = 0.0
alter Vp0b = 1.8
alter Vp1b = 1.8
alter Vp2b = 1.8
alter Vp3b = 1.8
alter Vc0 = 0.0
alter Vc1 = 1.8
alter Vc2 = 1.8
alter Vc3 = 0.0
op
print i(VDD) >> dc_current.txt
alter Vp0 = 0.0
alter Vp1 = 0.0
alter Vp2 = 0.0
alter Vp3 = 0.0
alter Vp0b = 1.8
alter Vp1b = 1.8
alter Vp2b = 1.8
alter Vp3b = 1.8
alter Vc0 = 0.0
alter Vc1 = 1.8
alter Vc2 = 0.0
alter Vc3 = 1.8
op
print i(VDD) >> dc_current.txt
alter Vp0 = 0.0
alter Vp1 = 0.0
alter Vp2 = 0.0
alter Vp3 = 0.0
alter Vp0b = 1.8
alter Vp1b = 1.8
alter Vp2b = 1.8
alter Vp3b = 1.8
alter Vc0 = 0.0
alter Vc1 = 1.8
alter Vc2 = 0.0
alter Vc3 = 0.0
op
print i(VDD) >> dc_current.txt
alter Vp0 = 0.0
alter Vp1 = 0.0
alter Vp2 = 0.0
alter Vp3 = 0.0
alter Vp0b = 1.8
alter Vp1b = 1.8
alter Vp2b = 1.8
alter Vp3b = 1.8
alter Vc0 = 0.0
alter Vc1 = 0.0
alter Vc2 = 1.8
alter Vc3 = 1.8
op
print i(VDD) >> dc_current.txt
alter Vp0 = 0.0
alter Vp1 = 0.0
alter Vp2 = 0.0
alter Vp3 = 0.0
alter Vp0b = 1.8
alter Vp1b = 1.8
alter Vp2b = 1.8
alter Vp3b = 1.8
alter Vc0 = 0.0
alter Vc1 = 0.0
alter Vc2 = 1.8
alter Vc3 = 0.0
op
print i(VDD) >> dc_current.txt
alter Vp0 = 0.0
alter Vp1 = 0.0
alter Vp2 = 0.0
alter Vp3 = 0.0
alter Vp0b = 1.8
alter Vp1b = 1.8
alter Vp2b = 1.8
alter Vp3b = 1.8
alter Vc0 = 0.0
alter Vc1 = 0.0
alter Vc2 = 0.0
alter Vc3 = 1.8
op
print i(VDD) >> dc_current.txt
alter Vp0 = 0.0
alter Vp1 = 0.0
alter Vp2 = 0.0
alter Vp3 = 0.0
alter Vp0b = 1.8
alter Vp1b = 1.8
alter Vp2b = 1.8
alter Vp3b = 1.8
alter Vc0 = 0.0
alter Vc1 = 0.0
alter Vc2 = 0.0
alter Vc3 = 0.0
op
print i(VDD) >> dc_current.txt
quit
.endc
.end
