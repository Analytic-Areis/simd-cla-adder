* DC supply current of xor_tg_x1
.include ../../../../spice/models/TSMC_180nm.txt
VDD vdd gnd 1.8
* xor_tg_x1: transmission-gate mux XOR with output inverter
* GENERATED from part1/cells/library.py. Do not edit by hand.
.subckt xor_tg_x1 p pb c s vdd gnd
Ms0p1 cb c vdd vdd CMOSP W=1.8000e-06 L=1.8000e-07 AS=9.7200e-13 PS=4.6800e-06 AD=9.7200e-13 PD=4.6800e-06
Ms0n1 cb c gnd gnd CMOSN W=9.0000e-07 L=1.8000e-07 AS=4.8600e-13 PS=2.8800e-06 AD=4.8600e-13 PD=2.8800e-06
Ms1n p c m gnd CMOSN W=9.0000e-07 L=1.8000e-07 AS=4.8600e-13 PS=2.8800e-06 AD=4.8600e-13 PD=2.8800e-06
Ms1p p cb m vdd CMOSP W=1.8000e-06 L=1.8000e-07 AS=9.7200e-13 PS=4.6800e-06 AD=9.7200e-13 PD=4.6800e-06
Ms2n pb cb m gnd CMOSN W=9.0000e-07 L=1.8000e-07 AS=4.8600e-13 PS=2.8800e-06 AD=4.8600e-13 PD=2.8800e-06
Ms2p pb c m vdd CMOSP W=1.8000e-06 L=1.8000e-07 AS=9.7200e-13 PS=4.6800e-06 AD=9.7200e-13 PD=4.6800e-06
Ms3p1 s m vdd vdd CMOSP W=1.8000e-06 L=1.8000e-07 AS=9.7200e-13 PS=4.6800e-06 AD=9.7200e-13 PD=4.6800e-06
Ms3n1 s m gnd gnd CMOSN W=9.0000e-07 L=1.8000e-07 AS=4.8600e-13 PS=2.8800e-06 AD=4.8600e-13 PD=2.8800e-06
.ends xor_tg_x1
.subckt tb_inv a y vdd gnd
mp y a vdd vdd CMOSP W=1.8e-06 L=1.8e-07 AS=9.72e-13 PS=4.68e-06 AD=9.72e-13 PD=4.68e-06
mn y a gnd gnd CMOSN W=9.0e-07 L=1.8e-07 AS=4.86e-13 PS=2.88e-06 AD=4.86e-13 PD=2.88e-06
.ends
Vp src_p gnd 1.8
Xd_p src_p p vdd gnd tb_inv
Vpb src_pb gnd 0.0
Xd_pb src_pb pb vdd gnd tb_inv
Vc src_c gnd 1.8
Xd_c src_c c vdd gnd tb_inv
Xl_s s lo_s vdd gnd tb_inv
X0 p pb c s vdd gnd xor_tg_x1
.control
alter Vp = 1.8
alter Vpb = 0.0
alter Vc = 1.8
op
print i(VDD) >> dc_current.txt
alter Vp = 1.8
alter Vpb = 0.0
alter Vc = 0.0
op
print i(VDD) >> dc_current.txt
alter Vp = 0.0
alter Vpb = 1.8
alter Vc = 1.8
op
print i(VDD) >> dc_current.txt
alter Vp = 0.0
alter Vpb = 1.8
alter Vc = 0.0
op
print i(VDD) >> dc_current.txt
quit
.endc
.end
