* DC supply current of mcc_bit_x1
.include ../../../../spice/models/TSMC_180nm.txt
VDD vdd gnd 1.8
* mcc_bit_x1: Manchester carry stage, transmission-gate mux
* GENERATED from part1/cells/library.py. Do not edit by hand.
.subckt mcc_bit_x1 ci a p pb co vdd gnd
Ms0n ci p co gnd CMOSN W=9.0000e-07 L=1.8000e-07 AS=4.8600e-13 PS=2.8800e-06 AD=4.8600e-13 PD=2.8800e-06
Ms0p ci pb co vdd CMOSP W=1.8000e-06 L=1.8000e-07 AS=9.7200e-13 PS=4.6800e-06 AD=9.7200e-13 PD=4.6800e-06
Ms1n a pb co gnd CMOSN W=9.0000e-07 L=1.8000e-07 AS=4.8600e-13 PS=2.8800e-06 AD=4.8600e-13 PD=2.8800e-06
Ms1p a p co vdd CMOSP W=1.8000e-06 L=1.8000e-07 AS=9.7200e-13 PS=4.6800e-06 AD=9.7200e-13 PD=4.6800e-06
.ends mcc_bit_x1
.subckt tb_inv a y vdd gnd
mp y a vdd vdd CMOSP W=1.8e-06 L=1.8e-07 AS=9.72e-13 PS=4.68e-06 AD=9.72e-13 PD=4.68e-06
mn y a gnd gnd CMOSN W=9.0e-07 L=1.8e-07 AS=4.86e-13 PS=2.88e-06 AD=4.86e-13 PD=2.88e-06
.ends
Vci src_ci gnd 1.8
Xd_ci src_ci ci vdd gnd tb_inv
Va src_a gnd 1.8
Xd_a src_a a vdd gnd tb_inv
Vp src_p gnd 1.8
Xd_p src_p p vdd gnd tb_inv
Vpb src_pb gnd 0.0
Xd_pb src_pb pb vdd gnd tb_inv
Xl_co co lo_co vdd gnd tb_inv
X0 ci a p pb co vdd gnd mcc_bit_x1
.control
alter Vci = 1.8
alter Va = 1.8
alter Vp = 1.8
alter Vpb = 0.0
op
print i(VDD) >> dc_current.txt
alter Vci = 1.8
alter Va = 1.8
alter Vp = 0.0
alter Vpb = 1.8
op
print i(VDD) >> dc_current.txt
alter Vci = 1.8
alter Va = 0.0
alter Vp = 1.8
alter Vpb = 0.0
op
print i(VDD) >> dc_current.txt
alter Vci = 1.8
alter Va = 0.0
alter Vp = 0.0
alter Vpb = 1.8
op
print i(VDD) >> dc_current.txt
alter Vci = 0.0
alter Va = 1.8
alter Vp = 1.8
alter Vpb = 0.0
op
print i(VDD) >> dc_current.txt
alter Vci = 0.0
alter Va = 1.8
alter Vp = 0.0
alter Vpb = 1.8
op
print i(VDD) >> dc_current.txt
alter Vci = 0.0
alter Va = 0.0
alter Vp = 1.8
alter Vpb = 0.0
op
print i(VDD) >> dc_current.txt
alter Vci = 0.0
alter Va = 0.0
alter Vp = 0.0
alter Vpb = 1.8
op
print i(VDD) >> dc_current.txt
quit
.endc
.end
