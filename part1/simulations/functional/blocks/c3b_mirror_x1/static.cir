* DC supply current of c3b_mirror_x1
.include ../../../../spice/models/TSMC_180nm.txt
VDD vdd gnd 1.8
* c3b_mirror_x1: C3-bar mirror gate, stack 2
* GENERATED from part1/cells/library.py. Do not edit by hand.
.subckt c3b_mirror_x1 a2 b2 c2 c3b vdd gnd
Mp1 xp1 b2 vdd vdd CMOSP W=3.6000e-06 L=1.8000e-07 AS=1.9440e-12 PS=8.2800e-06 AD=9.7200e-13 PD=7.7400e-06
Mp2 c3b a2 xp1 vdd CMOSP W=3.6000e-06 L=1.8000e-07 AS=9.7200e-13 PS=7.7400e-06 AD=1.9440e-12 PD=8.2800e-06
Mp3 xp2 a2 vdd vdd CMOSP W=3.6000e-06 L=1.8000e-07 AS=1.9440e-12 PS=8.2800e-06 AD=1.9440e-12 PD=8.2800e-06
Mp4 xp2 b2 vdd vdd CMOSP W=3.6000e-06 L=1.8000e-07 AS=1.9440e-12 PS=8.2800e-06 AD=1.9440e-12 PD=8.2800e-06
Mp5 c3b c2 xp2 vdd CMOSP W=3.6000e-06 L=1.8000e-07 AS=1.9440e-12 PS=8.2800e-06 AD=1.9440e-12 PD=8.2800e-06
Mn1 c3b a2 xn1 gnd CMOSN W=1.8000e-06 L=1.8000e-07 AS=4.8600e-13 PS=4.1400e-06 AD=9.7200e-13 PD=4.6800e-06
Mn2 xn1 b2 gnd gnd CMOSN W=1.8000e-06 L=1.8000e-07 AS=9.7200e-13 PS=4.6800e-06 AD=4.8600e-13 PD=4.1400e-06
Mn3 c3b c2 xn2 gnd CMOSN W=1.8000e-06 L=1.8000e-07 AS=9.7200e-13 PS=4.6800e-06 AD=9.7200e-13 PD=4.6800e-06
Mn4 xn2 a2 gnd gnd CMOSN W=1.8000e-06 L=1.8000e-07 AS=9.7200e-13 PS=4.6800e-06 AD=9.7200e-13 PD=4.6800e-06
Mn5 xn2 b2 gnd gnd CMOSN W=1.8000e-06 L=1.8000e-07 AS=9.7200e-13 PS=4.6800e-06 AD=9.7200e-13 PD=4.6800e-06
.ends c3b_mirror_x1
.subckt tb_inv a y vdd gnd
mp y a vdd vdd CMOSP W=1.8e-06 L=1.8e-07 AS=9.72e-13 PS=4.68e-06 AD=9.72e-13 PD=4.68e-06
mn y a gnd gnd CMOSN W=9.0e-07 L=1.8e-07 AS=4.86e-13 PS=2.88e-06 AD=4.86e-13 PD=2.88e-06
.ends
Va2 src_a2 gnd 1.8
Xd_a2 src_a2 a2 vdd gnd tb_inv
Vb2 src_b2 gnd 1.8
Xd_b2 src_b2 b2 vdd gnd tb_inv
Vc2 src_c2 gnd 1.8
Xd_c2 src_c2 c2 vdd gnd tb_inv
Xl_c3b c3b lo_c3b vdd gnd tb_inv
X0 a2 b2 c2 c3b vdd gnd c3b_mirror_x1
.control
alter Va2 = 1.8
alter Vb2 = 1.8
alter Vc2 = 1.8
op
print i(VDD) >> dc_current.txt
alter Va2 = 1.8
alter Vb2 = 1.8
alter Vc2 = 0.0
op
print i(VDD) >> dc_current.txt
alter Va2 = 1.8
alter Vb2 = 0.0
alter Vc2 = 1.8
op
print i(VDD) >> dc_current.txt
alter Va2 = 1.8
alter Vb2 = 0.0
alter Vc2 = 0.0
op
print i(VDD) >> dc_current.txt
alter Va2 = 0.0
alter Vb2 = 1.8
alter Vc2 = 1.8
op
print i(VDD) >> dc_current.txt
alter Va2 = 0.0
alter Vb2 = 1.8
alter Vc2 = 0.0
op
print i(VDD) >> dc_current.txt
alter Va2 = 0.0
alter Vb2 = 0.0
alter Vc2 = 1.8
op
print i(VDD) >> dc_current.txt
alter Va2 = 0.0
alter Vb2 = 0.0
alter Vc2 = 0.0
op
print i(VDD) >> dc_current.txt
quit
.endc
.end
