* NGSPICE file created from carry_r_x1.ext - technology: scmos

.global Vdd Gnd

.subckt carry_r_x1 a2 a3 b2 b3 c0 c1 c2 c3 c4 g0b g1b g2b t0b t1b t2b vdd gnd
M1000 a_206_30# a2 a_268_199# vdd pfet w=5.4u l=0.18u
+  ad=1.701p pd=6.03u as=1.215p ps=5.85u
M1001 c2 g1b a_62_20# Gnd nfet w=2.7u l=0.18u
+  ad=1.215p pd=6.3u as=1.458p ps=6.48u
M1002 a_232_20# a2 a_284_20# Gnd nfet w=2.7u l=0.18u
+  ad=0.8505p pd=3.33u as=0.8505p ps=3.33u
M1003 a_178_10# g0b a_142_20# Gnd nfet w=3.6u l=0.18u
+  ad=1.134p pd=4.23u as=1.944p ps=8.28u
M1004 vdd g1b c2 vdd pfet w=1.8u l=0.18u
+  ad=2.916p pd=6.84u as=0.972p ps=4.68u
M1005 a_125_199# g1b c3 vdd pfet w=3.6u l=0.18u
+  ad=2.106p pd=7.83u as=1.053p ps=4.23u
M1006 a_223_199# a2 a_284_199# vdd pfet w=5.4u l=0.18u
+  ad=1.701p pd=6.03u as=1.701p ps=6.03u
M1007 vdd a_206_30# c4 vdd pfet w=1.8u l=0.18u
+  ad=0.81p pd=4.5u as=0.972p ps=4.68u
M1008 a_62_20# t1b gnd Gnd nfet w=1.8u l=0.18u
+  ad=0.81p pd=3.33u as=0.972p ps=4.68u
M1009 a_284_20# b2 a_232_20# Gnd nfet w=2.7u l=0.18u
+  ad=1.215p pd=6.3u as=0.8505p ps=3.33u
M1010 a_88_199# t1b vdd vdd pfet w=5.4u l=0.18u
+  ad=1.539p pd=6.03u as=2.916p ps=6.84u
M1011 gnd a_8_199# a_178_10# Gnd nfet w=3.6u l=0.18u
+  ad=1.134p pd=4.23u as=1.134p ps=4.23u
M1012 a_214_30# a3 a_206_30# Gnd nfet w=1.8u l=0.18u
+  ad=0.567p pd=2.43u as=0.972p ps=4.68u
M1013 a_106_199# a_8_199# c2 vdd pfet w=5.4u l=0.18u
+  ad=1.701p pd=6.03u as=1.62p ps=6.03u
M1014 a_268_20# b2 a_232_20# Gnd nfet w=2.7u l=0.18u
+  ad=0.6075p pd=3.15u as=1.458p ps=6.48u
M1015 vdd b3 a_206_199# vdd pfet w=3.6u l=0.18u
+  ad=1.62p pd=6.03u as=1.944p ps=8.28u
M1016 a_43_199# t0b vdd vdd pfet w=3.6u l=0.18u
+  ad=1.134p pd=4.23u as=1.053p ps=4.23u
M1017 a_34_30# g0b c1 Gnd nfet w=1.8u l=0.18u
+  ad=0.567p pd=2.43u as=0.972p ps=4.68u
M1018 a_142_20# t1b gnd Gnd nfet w=2.7u l=0.18u
+  ad=1.0935p pd=4.23u as=0.81p ps=3.33u
M1019 a_125_30# g1b a_142_20# Gnd nfet w=3.6u l=0.18u
+  ad=1.134p pd=4.23u as=1.0935p ps=4.23u
M1020 a_187_199# a_8_199# c3 vdd pfet w=7.2u l=0.18u
+  ad=2.268p pd=7.83u as=2.187p ps=7.83u
M1021 a_178_10# t0b gnd Gnd nfet w=3.6u l=0.18u
+  ad=1.62p pd=8.1u as=1.134p ps=4.23u
M1022 gnd b3 a_214_30# Gnd nfet w=1.8u l=0.18u
+  ad=0.81p pd=3.33u as=0.567p ps=2.43u
M1023 gnd a_206_30# c4 Gnd nfet w=0.9u l=0.18u
+  ad=0.405p pd=2.7u as=0.486p ps=2.88u
M1024 vdd b3 a_223_199# vdd pfet w=5.4u l=0.18u
+  ad=2.43p pd=11.7u as=1.701p ps=6.03u
M1025 c3 g2b vdd vdd pfet w=1.8u l=0.18u
+  ad=1.053p pd=4.23u as=1.782p ps=7.83u
M1026 gnd a_8_199# a_97_20# Gnd nfet w=2.7u l=0.18u
+  ad=0.8505p pd=3.33u as=0.8505p ps=3.33u
M1027 a_284_199# c2 a_206_30# vdd pfet w=5.4u l=0.18u
+  ad=1.701p pd=6.03u as=1.701p ps=6.03u
M1028 a_206_30# a2 a_268_20# Gnd nfet w=2.7u l=0.18u
+  ad=0.8505p pd=3.33u as=0.6075p ps=3.15u
M1029 gnd t0b a_34_30# Gnd nfet w=1.8u l=0.18u
+  ad=0.567p pd=2.43u as=0.567p ps=2.43u
M1030 c3 g2b a_125_30# Gnd nfet w=3.6u l=0.18u
+  ad=1.62p pd=8.1u as=1.134p ps=4.23u
M1031 a_8_199# c0 gnd Gnd nfet w=0.9u l=0.18u
+  ad=0.405p pd=2.7u as=0.486p ps=2.88u
M1032 a_97_20# g0b a_62_20# Gnd nfet w=2.7u l=0.18u
+  ad=0.8505p pd=3.33u as=0.81p ps=3.33u
M1033 vdd c0 a_8_199# vdd pfet w=1.8u l=0.18u
+  ad=0.81p pd=4.5u as=0.972p ps=4.68u
M1034 a_206_199# a3 a_206_30# vdd pfet w=3.6u l=0.18u
+  ad=1.62p pd=8.1u as=1.944p ps=8.28u
M1035 a_160_199# t1b a_125_199# vdd pfet w=7.2u l=0.18u
+  ad=4.698p pd=8.64u as=2.106p ps=7.83u
M1036 a_97_20# t0b gnd Gnd nfet w=2.7u l=0.18u
+  ad=1.215p pd=6.3u as=0.8505p ps=3.33u
M1037 a_268_199# b2 a_223_199# vdd pfet w=5.4u l=0.18u
+  ad=1.215p pd=5.85u as=2.916p ps=11.88u
M1038 a_34_30# a_8_199# gnd Gnd nfet w=1.8u l=0.18u
+  ad=0.81p pd=4.5u as=0.567p ps=2.43u
M1039 a_284_20# c2 a_206_30# Gnd nfet w=2.7u l=0.18u
+  ad=0.8505p pd=3.33u as=0.8505p ps=3.33u
M1040 vdd g0b c1 vdd pfet w=1.8u l=0.18u
+  ad=1.053p pd=4.23u as=0.972p ps=4.68u
M1041 c2 g0b a_88_199# vdd pfet w=3.6u l=0.18u
+  ad=1.62p pd=6.03u as=1.539p ps=6.03u
M1042 a_88_199# t0b a_106_199# vdd pfet w=5.4u l=0.18u
+  ad=2.43p pd=11.7u as=1.701p ps=6.03u
M1043 c3 g0b a_160_199# vdd pfet w=5.4u l=0.18u
+  ad=2.187p pd=7.83u as=4.698p ps=8.64u
M1044 gnd a3 a_232_20# Gnd nfet w=2.7u l=0.18u
+  ad=1.215p pd=6.3u as=1.944p ps=4.14u
M1045 gnd t2b a_125_30# Gnd nfet w=1.8u l=0.18u
+  ad=0.81p pd=3.33u as=0.972p ps=4.68u
M1046 a_223_199# a3 vdd vdd pfet w=5.4u l=0.18u
+  ad=1.701p pd=6.03u as=1.62p ps=6.03u
M1047 c1 a_8_199# a_43_199# vdd pfet w=3.6u l=0.18u
+  ad=1.62p pd=8.1u as=1.134p ps=4.23u
M1048 a_284_199# b2 a_223_199# vdd pfet w=5.4u l=0.18u
+  ad=2.43p pd=11.7u as=1.701p ps=6.03u
M1049 a_232_20# b3 gnd Gnd nfet w=2.7u l=0.18u
+  ad=1.944p pd=4.14u as=0.81p ps=3.33u
M1050 vdd t2b a_125_199# vdd pfet w=7.2u l=0.18u
+  ad=1.782p pd=7.83u as=3.888p ps=15.48u
M1051 a_160_199# t0b a_187_199# vdd pfet w=7.2u l=0.18u
+  ad=3.24p pd=15.3u as=2.268p ps=7.83u
C0 a_284_199# vdd 0.02598f
C1 a_142_20# a_178_10# 0.49516f
C2 a_106_199# c2 0.00136f
C3 a_125_199# g1b 0.01429f
C4 g2b a2 0.03575f
C5 g1b gnd 0.00105f
C6 a3 b3 0.99956f
C7 a_206_30# a_284_20# 0.59685f
C8 a_223_199# vdd 1.03185f
C9 a_8_199# c2 0.10322f
C10 a_160_199# t0b 0.017f
C11 c0 gnd 0.00153f
C12 g2b a3 0.03832f
C13 c2 b3 0.01787f
C14 a_8_199# g0b 1.04023f
C15 a_160_199# vdd 0.11418f
C16 a_88_199# t0b 0.01558f
C17 a_206_30# a_214_30# 0
C18 a_125_199# t2b 0.01748f
C19 a_62_20# a_97_20# 0.43601f
C20 c0 b2 1.01861f
C21 c2 g2b 0.02802f
C22 g1b c3 0.01387f
C23 t2b gnd 0.00234f
C24 a_88_199# vdd 0.02924f
C25 a_8_199# t1b 0.0277f
C26 c1 c2 0.42383f
C27 t2b b2 0.01779f
C28 vdd a2 0.03688f
C29 a_284_20# c4 0.41221f
C30 c0 c3 0.00903f
C31 g0b g2b 0.02778f
C32 vdd a3 0.04329f
C33 a_178_10# gnd 0.74374f
C34 t2b c3 0.00941f
C35 t1b g2b 0.34357f
C36 t0b c2 0.02864f
C37 c0 g1b 0.01787f
C38 g0b c1 0.01708f
C39 a_232_20# a2 0.02105f
C40 a_223_199# a_268_199# 0.00136f
C41 t2b g1b 0.25543f
C42 t0b g0b 0.534f
C43 vdd c2 0.04453f
C44 a_232_20# a3 0.27675f
C45 a_284_20# g2b 0.23789f
C46 a_97_20# gnd 0.49588f
C47 a_8_199# a_125_30# 0.15571f
C48 a_206_199# a_223_199# 0.88078f
C49 a_232_20# c2 0.00874f
C50 t2b c0 0.00894f
C51 t1b t0b 0.02758f
C52 vdd g0b 0.05889f
C53 a_8_199# a_34_30# 0.16799f
C54 a_160_199# a_206_199# 0.42401f
C55 vdd t1b 0.04414f
C56 a_284_199# b2 0.01511f
C57 a_125_30# g2b 0.00664f
C58 a_206_30# c4 0.06868f
C59 a_142_20# c2 0.3495f
C60 a_125_199# a_160_199# 0.00181f
C61 a_178_10# c0 0.01991f
C62 a_97_20# g1b 0.25595f
C63 a_62_20# c2 0.83579f
C64 a_142_20# g0b 0.02573f
C65 a_223_199# b2 0.02408f
C66 a_206_30# b3 0.03249f
C67 a_88_199# a_125_199# 0.70641f
C68 a_142_20# t1b 0.00657f
C69 a_232_20# a_284_20# 0.92764f
C70 a_206_199# a3 0.02286f
C71 a_206_30# g2b 0.06068f
C72 a_178_10# t2b 0.23789f
C73 a_97_20# c0 0.01883f
C74 a_34_30# c1 0.58042f
C75 a_125_30# t0b 0.34912f
C76 a_62_20# g0b 0.02467f
C77 a_34_30# t0b 0.01188f
C78 a_206_199# c2 0.51624f
C79 a_62_20# t1b 0.01287f
C80 a_160_199# c3 0.08013f
C81 b2 a2 1.2475f
C82 a3 gnd 0.00315f
C83 g2b c4 0.02075f
C84 c2 gnd 0.24743f
C85 a3 b2 0.86048f
C86 a_125_30# a_142_20# 0.57467f
C87 a_8_199# g2b 0.0277f
C88 a_206_30# vdd 0.37727f
C89 g0b gnd 0.00105f
C90 g2b b3 0.03832f
C91 c2 b2 0.01759f
C92 a_8_199# c1 0.26765f
C93 a_187_199# vdd 0
C94 a_206_30# a_232_20# 0.64229f
C95 a_125_199# t1b 0.03727f
C96 c0 a2 0.01707f
C97 c2 c3 0.0098f
C98 t1b gnd 0.00549f
C99 a_8_199# t0b 1.56689f
C100 a_34_30# a_62_20# 0.32953f
C101 vdd c4 0.17673f
C102 g1b c2 0.04839f
C103 c0 a3 1.39107f
C104 t2b a2 0.01707f
C105 g0b c3 0.02581f
C106 a_8_199# vdd 0.23454f
C107 t2b a3 1.29808f
C108 vdd b3 0.04725f
C109 a_214_30# gnd 0
C110 t0b g2b 0.0281f
C111 t1b c3 0.01149f
C112 c0 c2 0.01815f
C113 g0b g1b 0.91499f
C114 a_284_20# b2 0.03125f
C115 a_223_199# a_284_199# 1.2822f
C116 a_206_30# a_268_199# 0.0017f
C117 t2b c2 0.01799f
C118 t1b g1b 0.53311f
C119 c0 g0b 1.56417f
C120 t0b c1 0.21791f
C121 a_232_20# b3 0.00502f
C122 vdd g2b 0.0211f
C123 a_125_30# gnd 0.2066f
C124 a_206_199# a_206_30# 0.57467f
C125 a_8_199# a_142_20# 0.15571f
C126 a_34_30# gnd 0.33059f
C127 vdd c1 0.35495f
C128 t2b g0b 0.0182f
C129 t1b c0 0.01767f
C130 a_8_199# a_62_20# 0.15571f
C131 t2b t1b 0.41828f
C132 a_125_30# c3 0.56563f
C133 a_284_199# a2 0.01511f
C134 a_142_20# g2b 0.00926f
C135 a_284_20# c0 0.01806f
C136 a_206_30# gnd 0.00153f
C137 vdd t0b 0.06136f
C138 a_178_10# g0b 0.01932f
C139 a_284_20# t2b 0.01845f
C140 a_125_30# g1b 0.02578f
C141 a_223_199# a2 0.3032f
C142 a_206_30# b2 0.03667f
C143 a_223_199# a3 0.01774f
C144 a_206_199# b3 0.02288f
C145 a_125_30# c0 0.01845f
C146 a_142_20# t0b 0.01921f
C147 a_62_20# c1 0.0608f
C148 a_97_20# g0b 0.02462f
C149 a_284_199# c2 0.00819f
C150 c4 gnd 0.08265f
C151 a_34_30# c0 0.01883f
C152 a_62_20# t0b 0.3495f
C153 a_223_199# c2 0.00906f
C154 a_125_30# t2b 0.02253f
C155 a_187_199# c3 0.00181f
C156 a_8_199# gnd 0.09315f
C157 a_206_199# g2b 0.04073f
C158 b2 c4 0.00941f
C159 b3 gnd 0.00549f
C160 a_125_199# g2b 0.01271f
C161 a_206_30# c0 0.02874f
C162 g2b gnd 0.00105f
C163 a3 a2 0.03478f
C164 a_8_199# c3 0.0875f
C165 a_206_30# t2b 0.02944f
C166 a_160_199# g0b 0.01575f
C167 a_88_199# c2 1.07067f
C168 g2b b2 0.03655f
C169 c2 a2 1.17644f
C170 a_160_199# t1b 0.00822f
C171 a_88_199# g0b 0.01469f
C172 a_206_30# a_268_20# 0
C173 a_223_199# a_284_20# 0.23586f
C174 a_97_20# a_125_30# 0.35302f
C175 a_43_199# c1 0.00113f
C176 a_206_199# vdd 0.35477f
C177 a_8_199# g1b 0.02725f
C178 c0 c4 0.00941f
C179 t0b gnd 0.0105f
C180 g2b c3 0.3273f
C181 c2 a3 0.03567f
C182 a_8_199# c0 1.85946f
C183 a_206_30# a_178_10# 0.32953f
C184 a_125_199# vdd 0.773f
C185 a_88_199# t1b 0.04134f
C186 c0 b3 0.25676f
C187 g1b g2b 0.46796f
C188 t2b c4 0.06106f
C189 a_43_199# vdd 0
C190 a_8_199# t2b 0.01799f
C191 t0b c3 0.00941f
C192 c0 g2b 0.00894f
C193 g0b c2 0.0339f
C194 a_284_20# a2 0.03273f
C195 t2b b3 0.01884f
C196 vdd b2 0.03726f
C197 a_232_20# gnd 0.24896f
C198 a_206_30# a_284_199# 0.63697f
C199 a_125_199# a_142_20# 0.1451f
C200 vdd c3 0.39977f
C201 t2b g2b 0.08682f
C202 a_142_20# gnd 0.41298f
C203 t0b g1b 0.02713f
C204 c0 c1 0.0098f
C205 t1b c2 0.0415f
C206 a_284_20# a3 0.17339f
C207 a_232_20# b2 0.02882f
C208 a_8_199# a_178_10# 0.09161f
C209 a_223_199# a_206_30# 0.0196f
C210 a_62_20# gnd 0.24777f
C211 t0b c0 0.02725f
C212 vdd g1b 0.03987f
C213 t1b g0b 0.51442f
C214 a_284_20# c2 0.00831f
C215 a_8_199# a_97_20# 0.16881f
C216 a_142_20# c3 0.62135f
C217 a_284_199# c4 0.30604f
C218 t2b t0b 0.71956f
C219 vdd c0 0.02136f
C220 a_160_199# a_187_199# 0.00227f
C221 a_125_30# c2 0.33067f
C222 a_142_20# g1b 0.023f
C223 vdd t2b 0.02713f
C224 a_206_30# a2 0.04712f
C225 a_232_20# c0 0.0294f
C226 a_223_199# b3 0.01572f
C227 a_206_30# a3 0.1339f
C228 a_178_10# t0b 0.01385f
C229 a_284_199# g2b 0.49383f
C230 a_232_20# t2b 0.65751f
C231 a_62_20# g1b 0.03663f
C232 a_142_20# c0 0.01845f
C233 a_125_30# g0b 0.01875f
C234 a_8_199# a_160_199# 0.00906f
C235 a_88_199# a_106_199# 0.0017f
C236 a_62_20# c0 0.01845f
C237 a_97_20# t0b 0.25091f
C238 a_34_30# g0b 0.2874f
C239 a_142_20# t2b 0.01921f
C240 a_206_30# c2 0.86433f
C241 a_125_30# t1b 0.00874f
C242 a_232_20# a_268_20# 0
C243 a_223_199# g2b 0.06071f
C244 a2 c4 0.01018f
C245 a_8_199# a_88_199# 0.00906f
C246 a_160_199# g2b 0.37191f
C247 a_125_199# c3 0.70976f
C248 a3 c4 0.08746f
C249 c3 gnd 0.04126f
.ends
