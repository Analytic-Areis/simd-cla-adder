* Truth table of cla_r_nand4: inputs through unit inverters, outputs load 20L/10L inverter
.include ../../../../spice/models/TSMC_180nm.txt
.options reltol=1e-3
VDD vdd gnd 1.8
* nand2_x1: 2-input NAND
* GENERATED from part1/cells/library.py. Do not edit by hand.
.subckt nand2_x1 i0 i1 y vdd gnd
Mp1 y i0 vdd vdd CMOSP W=1.8000e-06 L=1.8000e-07 AS=9.7200e-13 PS=4.6800e-06 AD=9.7200e-13 PD=4.6800e-06
Mp2 y i1 vdd vdd CMOSP W=1.8000e-06 L=1.8000e-07 AS=9.7200e-13 PS=4.6800e-06 AD=9.7200e-13 PD=4.6800e-06
Mn1 y i0 xn1 gnd CMOSN W=1.8000e-06 L=1.8000e-07 AS=4.8600e-13 PS=4.1400e-06 AD=9.7200e-13 PD=4.6800e-06
Mn2 xn1 i1 gnd gnd CMOSN W=1.8000e-06 L=1.8000e-07 AS=9.7200e-13 PS=4.6800e-06 AD=4.8600e-13 PD=4.1400e-06
.ends nand2_x1
* nor2_x1: 2-input NOR
* GENERATED from part1/cells/library.py. Do not edit by hand.
.subckt nor2_x1 i0 i1 y vdd gnd
Mp1 xp1 i0 vdd vdd CMOSP W=3.6000e-06 L=1.8000e-07 AS=1.9440e-12 PS=8.2800e-06 AD=9.7200e-13 PD=7.7400e-06
Mp2 y i1 xp1 vdd CMOSP W=3.6000e-06 L=1.8000e-07 AS=9.7200e-13 PS=7.7400e-06 AD=1.9440e-12 PD=8.2800e-06
Mn1 y i0 gnd gnd CMOSN W=9.0000e-07 L=1.8000e-07 AS=4.8600e-13 PS=2.8800e-06 AD=4.8600e-13 PD=2.8800e-06
Mn2 y i1 gnd gnd CMOSN W=9.0000e-07 L=1.8000e-07 AS=4.8600e-13 PS=2.8800e-06 AD=4.8600e-13 PD=2.8800e-06
.ends nor2_x1
* aoi21_x1: NOT(a b + c)
* GENERATED from part1/cells/library.py. Do not edit by hand.
.subckt aoi21_x1 a b c y vdd gnd
Mp1 xp1 a vdd vdd CMOSP W=3.6000e-06 L=1.8000e-07 AS=1.9440e-12 PS=8.2800e-06 AD=1.9440e-12 PD=8.2800e-06
Mp2 xp1 b vdd vdd CMOSP W=3.6000e-06 L=1.8000e-07 AS=1.9440e-12 PS=8.2800e-06 AD=1.9440e-12 PD=8.2800e-06
Mp3 y c xp1 vdd CMOSP W=3.6000e-06 L=1.8000e-07 AS=1.9440e-12 PS=8.2800e-06 AD=1.9440e-12 PD=8.2800e-06
Mn1 y a xn1 gnd CMOSN W=1.8000e-06 L=1.8000e-07 AS=4.8600e-13 PS=4.1400e-06 AD=9.7200e-13 PD=4.6800e-06
Mn2 xn1 b gnd gnd CMOSN W=1.8000e-06 L=1.8000e-07 AS=9.7200e-13 PS=4.6800e-06 AD=4.8600e-13 PD=4.1400e-06
Mn3 y c gnd gnd CMOSN W=9.0000e-07 L=1.8000e-07 AS=4.8600e-13 PS=2.8800e-06 AD=4.8600e-13 PD=2.8800e-06
.ends aoi21_x1
* oai21_x1: NOT((a + b) c)
* GENERATED from part1/cells/library.py. Do not edit by hand.
.subckt oai21_x1 a b c y vdd gnd
Mp1 xp1 a vdd vdd CMOSP W=3.6000e-06 L=1.8000e-07 AS=1.9440e-12 PS=8.2800e-06 AD=9.7200e-13 PD=7.7400e-06
Mp2 y b xp1 vdd CMOSP W=3.6000e-06 L=1.8000e-07 AS=9.7200e-13 PS=7.7400e-06 AD=1.9440e-12 PD=8.2800e-06
Mp3 y c vdd vdd CMOSP W=1.8000e-06 L=1.8000e-07 AS=9.7200e-13 PS=4.6800e-06 AD=9.7200e-13 PD=4.6800e-06
Mn1 y a xn1 gnd CMOSN W=1.8000e-06 L=1.8000e-07 AS=9.7200e-13 PS=4.6800e-06 AD=9.7200e-13 PD=4.6800e-06
Mn2 y b xn1 gnd CMOSN W=1.8000e-06 L=1.8000e-07 AS=9.7200e-13 PS=4.6800e-06 AD=9.7200e-13 PD=4.6800e-06
Mn3 xn1 c gnd gnd CMOSN W=1.8000e-06 L=1.8000e-07 AS=9.7200e-13 PS=4.6800e-06 AD=9.7200e-13 PD=4.6800e-06
.ends oai21_x1
* inv_x1: inverter
* GENERATED from part1/cells/library.py. Do not edit by hand.
.subckt inv_x1 a y vdd gnd
Mp1 y a vdd vdd CMOSP W=1.8000e-06 L=1.8000e-07 AS=9.7200e-13 PS=4.6800e-06 AD=9.7200e-13 PD=4.6800e-06
Mn1 y a gnd gnd CMOSN W=9.0000e-07 L=1.8000e-07 AS=4.8600e-13 PS=2.8800e-06 AD=4.8600e-13 PD=2.8800e-06
.ends inv_x1
* c1_x1: C1 complex gate, stack 2
* GENERATED from part1/cells/library.py. Do not edit by hand.
.subckt c1_x1 g0b t0b c0b c1 vdd gnd
Mp1 c1 g0b vdd vdd CMOSP W=1.8000e-06 L=1.8000e-07 AS=9.7200e-13 PS=4.6800e-06 AD=9.7200e-13 PD=4.6800e-06
Mp2 xp1 t0b vdd vdd CMOSP W=3.6000e-06 L=1.8000e-07 AS=1.9440e-12 PS=8.2800e-06 AD=9.7200e-13 PD=7.7400e-06
Mp3 c1 c0b xp1 vdd CMOSP W=3.6000e-06 L=1.8000e-07 AS=9.7200e-13 PS=7.7400e-06 AD=1.9440e-12 PD=8.2800e-06
Mn1 c1 g0b xn1 gnd CMOSN W=1.8000e-06 L=1.8000e-07 AS=9.7200e-13 PS=4.6800e-06 AD=9.7200e-13 PD=4.6800e-06
Mn2 xn1 t0b gnd gnd CMOSN W=1.8000e-06 L=1.8000e-07 AS=9.7200e-13 PS=4.6800e-06 AD=9.7200e-13 PD=4.6800e-06
Mn3 xn1 c0b gnd gnd CMOSN W=1.8000e-06 L=1.8000e-07 AS=9.7200e-13 PS=4.6800e-06 AD=9.7200e-13 PD=4.6800e-06
.ends c1_x1
* c2_x1: C2 complex gate, stack 3
* GENERATED from part1/cells/library.py. Do not edit by hand.
.subckt c2_x1 g0b t0b g1b t1b c0b c2 vdd gnd
Mp1 c2 g1b vdd vdd CMOSP W=1.8000e-06 L=1.8000e-07 AS=9.7200e-13 PS=4.6800e-06 AD=9.7200e-13 PD=4.6800e-06
Mp2 xp1 t1b vdd vdd CMOSP W=5.4000e-06 L=1.8000e-07 AS=2.9160e-12 PS=1.1880e-05 AD=2.9160e-12 PD=1.1880e-05
Mp3 c2 g0b xp1 vdd CMOSP W=3.6000e-06 L=1.8000e-07 AS=1.9440e-12 PS=8.2800e-06 AD=1.9440e-12 PD=8.2800e-06
Mp4 xp2 t0b xp1 vdd CMOSP W=5.4000e-06 L=1.8000e-07 AS=2.9160e-12 PS=1.1880e-05 AD=1.4580e-12 PD=1.1340e-05
Mp5 c2 c0b xp2 vdd CMOSP W=5.4000e-06 L=1.8000e-07 AS=1.4580e-12 PS=1.1340e-05 AD=2.9160e-12 PD=1.1880e-05
Mn1 c2 g1b xn1 gnd CMOSN W=2.7000e-06 L=1.8000e-07 AS=1.4580e-12 PS=6.4800e-06 AD=1.4580e-12 PD=6.4800e-06
Mn2 xn1 t1b gnd gnd CMOSN W=1.8000e-06 L=1.8000e-07 AS=9.7200e-13 PS=4.6800e-06 AD=9.7200e-13 PD=4.6800e-06
Mn3 xn1 g0b xn2 gnd CMOSN W=2.7000e-06 L=1.8000e-07 AS=1.4580e-12 PS=6.4800e-06 AD=1.4580e-12 PD=6.4800e-06
Mn4 xn2 t0b gnd gnd CMOSN W=2.7000e-06 L=1.8000e-07 AS=1.4580e-12 PS=6.4800e-06 AD=1.4580e-12 PD=6.4800e-06
Mn5 xn2 c0b gnd gnd CMOSN W=2.7000e-06 L=1.8000e-07 AS=1.4580e-12 PS=6.4800e-06 AD=1.4580e-12 PD=6.4800e-06
.ends c2_x1
* c3_x1: C3 complex gate, stack 4
* GENERATED from part1/cells/library.py. Do not edit by hand.
.subckt c3_x1 g0b t0b g1b t1b g2b t2b c0b c3 vdd gnd
Mp1 c3 g2b vdd vdd CMOSP W=1.8000e-06 L=1.8000e-07 AS=9.7200e-13 PS=4.6800e-06 AD=9.7200e-13 PD=4.6800e-06
Mp2 xp1 t2b vdd vdd CMOSP W=7.2000e-06 L=1.8000e-07 AS=3.8880e-12 PS=1.5480e-05 AD=3.8880e-12 PD=1.5480e-05
Mp3 c3 g1b xp1 vdd CMOSP W=3.6000e-06 L=1.8000e-07 AS=1.9440e-12 PS=8.2800e-06 AD=1.9440e-12 PD=8.2800e-06
Mp4 xp2 t1b xp1 vdd CMOSP W=7.2000e-06 L=1.8000e-07 AS=3.8880e-12 PS=1.5480e-05 AD=3.8880e-12 PD=1.5480e-05
Mp5 c3 g0b xp2 vdd CMOSP W=5.4000e-06 L=1.8000e-07 AS=2.9160e-12 PS=1.1880e-05 AD=2.9160e-12 PD=1.1880e-05
Mp6 xp3 t0b xp2 vdd CMOSP W=7.2000e-06 L=1.8000e-07 AS=3.8880e-12 PS=1.5480e-05 AD=1.9440e-12 PD=1.4940e-05
Mp7 c3 c0b xp3 vdd CMOSP W=7.2000e-06 L=1.8000e-07 AS=1.9440e-12 PS=1.4940e-05 AD=3.8880e-12 PD=1.5480e-05
Mn1 c3 g2b xn1 gnd CMOSN W=3.6000e-06 L=1.8000e-07 AS=1.9440e-12 PS=8.2800e-06 AD=1.9440e-12 PD=8.2800e-06
Mn2 xn1 t2b gnd gnd CMOSN W=1.8000e-06 L=1.8000e-07 AS=9.7200e-13 PS=4.6800e-06 AD=9.7200e-13 PD=4.6800e-06
Mn3 xn1 g1b xn2 gnd CMOSN W=3.6000e-06 L=1.8000e-07 AS=1.9440e-12 PS=8.2800e-06 AD=1.9440e-12 PD=8.2800e-06
Mn4 xn2 t1b gnd gnd CMOSN W=2.7000e-06 L=1.8000e-07 AS=1.4580e-12 PS=6.4800e-06 AD=1.4580e-12 PD=6.4800e-06
Mn5 xn2 g0b xn3 gnd CMOSN W=3.6000e-06 L=1.8000e-07 AS=1.9440e-12 PS=8.2800e-06 AD=1.9440e-12 PD=8.2800e-06
Mn6 xn3 t0b gnd gnd CMOSN W=3.6000e-06 L=1.8000e-07 AS=1.9440e-12 PS=8.2800e-06 AD=1.9440e-12 PD=8.2800e-06
Mn7 xn3 c0b gnd gnd CMOSN W=3.6000e-06 L=1.8000e-07 AS=1.9440e-12 PS=8.2800e-06 AD=1.9440e-12 PD=8.2800e-06
.ends c3_x1
* c4b_mirror_x1: C4-bar mirror gate, stack 3
* GENERATED from part1/cells/library.py. Do not edit by hand.
.subckt c4b_mirror_x1 a3 b3 a2 b2 c2 c4b vdd gnd
Mp1 xp1 b3 vdd vdd CMOSP W=3.6000e-06 L=1.8000e-07 AS=1.9440e-12 PS=8.2800e-06 AD=9.7200e-13 PD=7.7400e-06
Mp2 c4b a3 xp1 vdd CMOSP W=3.6000e-06 L=1.8000e-07 AS=9.7200e-13 PS=7.7400e-06 AD=1.9440e-12 PD=8.2800e-06
Mp3 xp2 a3 vdd vdd CMOSP W=5.4000e-06 L=1.8000e-07 AS=2.9160e-12 PS=1.1880e-05 AD=2.9160e-12 PD=1.1880e-05
Mp4 xp2 b3 vdd vdd CMOSP W=5.4000e-06 L=1.8000e-07 AS=2.9160e-12 PS=1.1880e-05 AD=2.9160e-12 PD=1.1880e-05
Mp5 xp3 b2 xp2 vdd CMOSP W=5.4000e-06 L=1.8000e-07 AS=2.9160e-12 PS=1.1880e-05 AD=1.4580e-12 PD=1.1340e-05
Mp6 c4b a2 xp3 vdd CMOSP W=5.4000e-06 L=1.8000e-07 AS=1.4580e-12 PS=1.1340e-05 AD=2.9160e-12 PD=1.1880e-05
Mp7 xp4 a2 xp2 vdd CMOSP W=5.4000e-06 L=1.8000e-07 AS=2.9160e-12 PS=1.1880e-05 AD=2.9160e-12 PD=1.1880e-05
Mp8 xp4 b2 xp2 vdd CMOSP W=5.4000e-06 L=1.8000e-07 AS=2.9160e-12 PS=1.1880e-05 AD=2.9160e-12 PD=1.1880e-05
Mp9 c4b c2 xp4 vdd CMOSP W=5.4000e-06 L=1.8000e-07 AS=2.9160e-12 PS=1.1880e-05 AD=2.9160e-12 PD=1.1880e-05
Mn1 c4b a3 xn1 gnd CMOSN W=1.8000e-06 L=1.8000e-07 AS=4.8600e-13 PS=4.1400e-06 AD=9.7200e-13 PD=4.6800e-06
Mn2 xn1 b3 gnd gnd CMOSN W=1.8000e-06 L=1.8000e-07 AS=9.7200e-13 PS=4.6800e-06 AD=4.8600e-13 PD=4.1400e-06
Mn3 c4b a2 xn3 gnd CMOSN W=2.7000e-06 L=1.8000e-07 AS=7.2900e-13 PS=5.9400e-06 AD=1.4580e-12 PD=6.4800e-06
Mn4 xn3 b2 xn2 gnd CMOSN W=2.7000e-06 L=1.8000e-07 AS=1.4580e-12 PS=6.4800e-06 AD=7.2900e-13 PD=5.9400e-06
Mn5 c4b c2 xn4 gnd CMOSN W=2.7000e-06 L=1.8000e-07 AS=1.4580e-12 PS=6.4800e-06 AD=1.4580e-12 PD=6.4800e-06
Mn6 xn4 a2 xn2 gnd CMOSN W=2.7000e-06 L=1.8000e-07 AS=1.4580e-12 PS=6.4800e-06 AD=1.4580e-12 PD=6.4800e-06
Mn7 xn4 b2 xn2 gnd CMOSN W=2.7000e-06 L=1.8000e-07 AS=1.4580e-12 PS=6.4800e-06 AD=1.4580e-12 PD=6.4800e-06
Mn8 xn2 a3 gnd gnd CMOSN W=2.7000e-06 L=1.8000e-07 AS=1.4580e-12 PS=6.4800e-06 AD=1.4580e-12 PD=6.4800e-06
Mn9 xn2 b3 gnd gnd CMOSN W=2.7000e-06 L=1.8000e-07 AS=1.4580e-12 PS=6.4800e-06 AD=1.4580e-12 PD=6.4800e-06
.ends c4b_mirror_x1
* xor_nand4_x1: four-NAND XOR baseline
* GENERATED from part1/cells/library.py. Do not edit by hand.
.subckt xor_nand4_x1 p c s vdd gnd
Ms0p1 n1 p vdd vdd CMOSP W=1.8000e-06 L=1.8000e-07 AS=9.7200e-13 PS=4.6800e-06 AD=9.7200e-13 PD=4.6800e-06
Ms0p2 n1 c vdd vdd CMOSP W=1.8000e-06 L=1.8000e-07 AS=9.7200e-13 PS=4.6800e-06 AD=9.7200e-13 PD=4.6800e-06
Ms0n1 n1 p s0xn1 gnd CMOSN W=1.8000e-06 L=1.8000e-07 AS=4.8600e-13 PS=4.1400e-06 AD=9.7200e-13 PD=4.6800e-06
Ms0n2 s0xn1 c gnd gnd CMOSN W=1.8000e-06 L=1.8000e-07 AS=9.7200e-13 PS=4.6800e-06 AD=4.8600e-13 PD=4.1400e-06
Ms1p1 n2 p vdd vdd CMOSP W=1.8000e-06 L=1.8000e-07 AS=9.7200e-13 PS=4.6800e-06 AD=9.7200e-13 PD=4.6800e-06
Ms1p2 n2 n1 vdd vdd CMOSP W=1.8000e-06 L=1.8000e-07 AS=9.7200e-13 PS=4.6800e-06 AD=9.7200e-13 PD=4.6800e-06
Ms1n1 n2 p s1xn1 gnd CMOSN W=1.8000e-06 L=1.8000e-07 AS=4.8600e-13 PS=4.1400e-06 AD=9.7200e-13 PD=4.6800e-06
Ms1n2 s1xn1 n1 gnd gnd CMOSN W=1.8000e-06 L=1.8000e-07 AS=9.7200e-13 PS=4.6800e-06 AD=4.8600e-13 PD=4.1400e-06
Ms2p1 n3 c vdd vdd CMOSP W=1.8000e-06 L=1.8000e-07 AS=9.7200e-13 PS=4.6800e-06 AD=9.7200e-13 PD=4.6800e-06
Ms2p2 n3 n1 vdd vdd CMOSP W=1.8000e-06 L=1.8000e-07 AS=9.7200e-13 PS=4.6800e-06 AD=9.7200e-13 PD=4.6800e-06
Ms2n1 n3 c s2xn1 gnd CMOSN W=1.8000e-06 L=1.8000e-07 AS=4.8600e-13 PS=4.1400e-06 AD=9.7200e-13 PD=4.6800e-06
Ms2n2 s2xn1 n1 gnd gnd CMOSN W=1.8000e-06 L=1.8000e-07 AS=9.7200e-13 PS=4.6800e-06 AD=4.8600e-13 PD=4.1400e-06
Ms3p1 s n2 vdd vdd CMOSP W=1.8000e-06 L=1.8000e-07 AS=9.7200e-13 PS=4.6800e-06 AD=9.7200e-13 PD=4.6800e-06
Ms3p2 s n3 vdd vdd CMOSP W=1.8000e-06 L=1.8000e-07 AS=9.7200e-13 PS=4.6800e-06 AD=9.7200e-13 PD=4.6800e-06
Ms3n1 s n2 s3xn1 gnd CMOSN W=1.8000e-06 L=1.8000e-07 AS=4.8600e-13 PS=4.1400e-06 AD=9.7200e-13 PD=4.6800e-06
Ms3n2 s3xn1 n3 gnd gnd CMOSN W=1.8000e-06 L=1.8000e-07 AS=9.7200e-13 PS=4.6800e-06 AD=4.8600e-13 PD=4.1400e-06
.ends xor_nand4_x1
* cla_r_nand4: Candidate R: flat C1 to C3, mirror C4 over C2
* GENERATED from part1/cells/library.py. Do not edit by hand.
.subckt cla_r_nand4 a0 a1 a2 a3 b0 b1 b2 b3 c0 s0 s1 s2 s3 c4 vdd gnd
Xnand0 a0 b0 g0b vdd gnd nand2_x1
Xnor0 a0 b0 t0b vdd gnd nor2_x1
Xaoi0 a0 b0 t0b p0 vdd gnd aoi21_x1
Xoai0 a0 b0 g0b p0b vdd gnd oai21_x1
Xnand1 a1 b1 g1b vdd gnd nand2_x1
Xnor1 a1 b1 t1b vdd gnd nor2_x1
Xaoi1 a1 b1 t1b p1 vdd gnd aoi21_x1
Xoai1 a1 b1 g1b p1b vdd gnd oai21_x1
Xnand2 a2 b2 g2b vdd gnd nand2_x1
Xnor2 a2 b2 t2b vdd gnd nor2_x1
Xaoi2 a2 b2 t2b p2 vdd gnd aoi21_x1
Xoai2 a2 b2 g2b p2b vdd gnd oai21_x1
Xnand3 a3 b3 g3b vdd gnd nand2_x1
Xnor3 a3 b3 t3b vdd gnd nor2_x1
Xaoi3 a3 b3 t3b p3 vdd gnd aoi21_x1
Xoai3 a3 b3 g3b p3b vdd gnd oai21_x1
Xinvc0 c0 c0b vdd gnd inv_x1
Xc1 g0b t0b c0b c1 vdd gnd c1_x1
Xc2 g0b t0b g1b t1b c0b c2 vdd gnd c2_x1
Xc3 g0b t0b g1b t1b g2b t2b c0b c3 vdd gnd c3_x1
Xc4m a3 b3 a2 b2 c2 c4b vdd gnd c4b_mirror_x1
Xinvc4 c4b c4 vdd gnd inv_x1
Xx0 p0 c0 s0 vdd gnd xor_nand4_x1
Xx1 p1 c1 s1 vdd gnd xor_nand4_x1
Xx2 p2 c2 s2 vdd gnd xor_nand4_x1
Xx3 p3 c3 s3 vdd gnd xor_nand4_x1
.ends cla_r_nand4
.subckt tb_inv a y vdd gnd
mp y a vdd vdd CMOSP W=1.8e-06 L=1.8e-07 AS=9.72e-13 PS=4.68e-06 AD=9.72e-13 PD=4.68e-06
mn y a gnd gnd CMOSN W=9.0e-07 L=1.8e-07 AS=4.86e-13 PS=2.88e-06 AD=4.86e-13 PD=2.88e-06
.ends
Va0 src_a0 gnd PWL(
+ 0.00000e+00 1.800 7.68000e-07 1.800 7.68050e-07 0.000 1.54200e-06 0.000 1.54205e-06 1.800 1.54500e-06 1.800
+ 1.54505e-06 0.000 1.54800e-06 0.000 1.54805e-06 1.800 1.55400e-06 1.800 1.55405e-06 0.000 1.56600e-06 0.000
+ 1.56605e-06 1.800 1.56900e-06 1.800 1.56905e-06 0.000 1.57200e-06 0.000 1.57205e-06 1.800 1.58100e-06 1.800
+ 1.58105e-06 0.000 1.58400e-06 0.000 1.58405e-06 1.800 1.59000e-06 1.800 1.59005e-06 0.000 1.59300e-06 0.000
+ 1.59305e-06 1.800 1.60800e-06 1.800 1.60805e-06 0.000 1.61100e-06 0.000 1.61105e-06 1.800 1.61700e-06 1.800
+ 1.61705e-06 0.000 1.62300e-06 0.000 1.62305e-06 1.800 1.62600e-06 1.800 1.62605e-06 0.000 1.63200e-06 0.000
+ 1.63205e-06 1.800 1.63500e-06 1.800 1.63505e-06 0.000 1.63800e-06 0.000 1.63805e-06 1.800 1.64100e-06 1.800
+ 1.64105e-06 0.000 1.64700e-06 0.000 1.64705e-06 1.800 1.65000e-06 1.800 1.65005e-06 0.000 1.65600e-06 0.000
+ 1.65605e-06 1.800 1.65900e-06 1.800 1.65905e-06 0.000 1.66200e-06 0.000 1.66205e-06 1.800 1.68600e-06 1.800
+ 1.68605e-06 0.000 1.68900e-06 0.000 1.68905e-06 1.800 1.69200e-06 1.800 1.69205e-06 0.000 1.69500e-06 0.000
+ 1.69505e-06 1.800 1.71000e-06 1.800 1.71005e-06 0.000 1.71300e-06 0.000 1.71305e-06 1.800 1.71600e-06 1.800
+ 1.71605e-06 0.000 1.72200e-06 0.000 1.72205e-06 1.800 1.72800e-06 1.800 1.72805e-06 0.000 1.73100e-06 0.000
+ 1.73105e-06 1.800 1.73700e-06 1.800 1.73705e-06 0.000 1.74000e-06 0.000 1.74005e-06 1.800 1.74300e-06 1.800
+ 1.74305e-06 0.000 1.74600e-06 0.000 1.74605e-06 1.800 1.74900e-06 1.800 1.74905e-06 0.000 1.75200e-06 0.000
+ 1.75205e-06 1.800 1.75500e-06 1.800 1.75505e-06 0.000 1.76700e-06 0.000 1.76705e-06 1.800 1.77000e-06 1.800
+ 1.77005e-06 0.000 1.77300e-06 0.000 1.77305e-06 1.800 1.77600e-06 1.800 1.77605e-06 0.000 1.78200e-06 0.000
+ 1.78205e-06 1.800 1.78500e-06 1.800 1.78505e-06 0.000 1.79100e-06 0.000 1.79105e-06 1.800 1.79400e-06 1.800
+ 1.79405e-06 0.000 1.79700e-06 0.000 1.79705e-06 1.800 1.80300e-06 1.800 1.80305e-06 0.000 1.80900e-06 0.000
+ 1.80905e-06 1.800 1.82100e-06 1.800 1.82105e-06 0.000 1.82400e-06 0.000 1.82405e-06 1.800 1.82700e-06 1.800
+ 1.82705e-06 0.000 1.83000e-06 0.000 1.83005e-06 1.800 1.83300e-06 1.800 1.83305e-06 0.000 1.83600e-06 0.000
+ 1.83605e-06 1.800 1.84800e-06 1.800 1.84805e-06 0.000 1.85400e-06 0.000 1.85405e-06 1.800 1.85700e-06 1.800
+ 1.85705e-06 0.000 1.86000e-06 0.000 1.86005e-06 1.800 1.86300e-06 1.800 1.86305e-06 0.000 1.87200e-06 0.000
+ 1.87205e-06 1.800 1.88100e-06 1.800 1.88105e-06 0.000 1.89900e-06 0.000 1.89905e-06 1.800 1.90200e-06 1.800
+ 1.90205e-06 0.000 1.90500e-06 0.000 1.90505e-06 1.800 1.90800e-06 1.800 1.90805e-06 0.000 1.91100e-06 0.000
+ 1.91105e-06 1.800 1.91400e-06 1.800 1.91405e-06 0.000 1.91700e-06 0.000 1.91705e-06 1.800 1.92000e-06 1.800
+ 1.92005e-06 0.000 1.93200e-06 0.000 1.93205e-06 1.800 1.93500e-06 1.800 1.93505e-06 0.000 1.93800e-06 0.000
+ 1.93805e-06 1.800 1.95000e-06 1.800 1.95005e-06 0.000 1.95300e-06 0.000 1.95305e-06 1.800 1.96200e-06 1.800
+ 1.96205e-06 0.000 1.96800e-06 0.000 1.96805e-06 1.800 1.98000e-06 1.800 1.98005e-06 0.000 1.98300e-06 0.000
+ 1.98305e-06 1.800 1.98600e-06 1.800 1.98605e-06 0.000 1.99200e-06 0.000 1.99205e-06 1.800 1.99800e-06 1.800
+ 1.99805e-06 0.000 2.00100e-06 0.000 2.00105e-06 1.800 2.00700e-06 1.800 2.00705e-06 0.000 2.01000e-06 0.000
+ 2.01005e-06 1.800 2.01300e-06 1.800 2.01305e-06 0.000 2.01900e-06 0.000 2.01905e-06 1.800 2.02200e-06 1.800
+ 2.02205e-06 0.000 2.02800e-06 0.000 2.02805e-06 1.800 2.03400e-06 1.800 2.03405e-06 0.000 2.03700e-06 0.000
+ 2.03705e-06 1.800 2.04900e-06 1.800 2.04905e-06 0.000 2.05200e-06 0.000 2.05205e-06 1.800 2.05500e-06 1.800
+ 2.05505e-06 0.000 2.06400e-06 0.000 2.06405e-06 1.800 2.06700e-06 1.800 2.06705e-06 0.000 2.07000e-06 0.000
+ 2.07005e-06 1.800 2.07300e-06 1.800 2.07305e-06 0.000 2.07600e-06 0.000 2.07605e-06 1.800 2.07900e-06 1.800
+ 2.07905e-06 0.000 2.09100e-06 0.000 2.09105e-06 1.800 2.09700e-06 1.800 2.09705e-06 0.000 2.10000e-06 0.000
+ 2.10005e-06 1.800 2.10300e-06 1.800 2.10305e-06 0.000 2.10900e-06 0.000 2.10905e-06 1.800 2.11200e-06 1.800
+ 2.11205e-06 0.000 2.12400e-06 0.000 2.12405e-06 1.800 2.12700e-06 1.800 2.12705e-06 0.000 2.13300e-06 0.000
+ 2.13305e-06 1.800 2.14500e-06 1.800 2.14505e-06 0.000 2.14800e-06 0.000 2.14805e-06 1.800 2.15700e-06 1.800
+ 2.15705e-06 0.000 2.16600e-06 0.000 2.16605e-06 1.800 2.16900e-06 1.800 2.16905e-06 0.000 2.17200e-06 0.000
+ 2.17205e-06 1.800 2.17500e-06 1.800 2.17505e-06 0.000 2.19300e-06 0.000 2.19305e-06 1.800 2.19900e-06 1.800
+ 2.19905e-06 0.000 2.20200e-06 0.000 2.20205e-06 1.800 2.21100e-06 1.800 2.21105e-06 0.000 2.21700e-06 0.000
+ 2.21705e-06 1.800 2.22300e-06 1.800 2.22305e-06 0.000 2.22600e-06 0.000 2.22605e-06 1.800 2.22900e-06 1.800
+ 2.22905e-06 0.000 2.25600e-06 0.000 2.25605e-06 1.800 2.25900e-06 1.800 2.25905e-06 0.000 2.26200e-06 0.000
+ 2.26205e-06 1.800 2.26500e-06 1.800 2.26505e-06 0.000 2.27700e-06 0.000 2.27705e-06 1.800 2.28000e-06 1.800
+ 2.28005e-06 0.000 2.28600e-06 0.000 2.28605e-06 1.800 2.28900e-06 1.800 2.28905e-06 0.000 2.29800e-06 0.000
+ 2.29805e-06 1.800 2.30100e-06 1.800 2.30105e-06 0.000 2.31300e-06 0.000 2.31305e-06 1.800 2.31900e-06 1.800
+ 2.31905e-06 0.000 2.32200e-06 0.000 2.32205e-06 1.800 2.34000e-06 1.800 2.34005e-06 0.000 2.34600e-06 0.000
+ 2.34605e-06 1.800 2.34900e-06 1.800 2.34905e-06 0.000 2.35500e-06 0.000 2.35505e-06 1.800 2.35800e-06 1.800
+ 2.35805e-06 0.000 2.37600e-06 0.000 2.37605e-06 1.800 2.39700e-06 1.800 2.39705e-06 0.000 2.40600e-06 0.000
+ 2.40605e-06 1.800 2.40900e-06 1.800 2.40905e-06 0.000 2.41200e-06 0.000 2.41205e-06 1.800 2.45400e-06 1.800
+ 2.45405e-06 0.000 2.46300e-06 0.000 2.46305e-06 1.800 2.47200e-06 1.800 2.47205e-06 0.000 2.47800e-06 0.000
+ 2.47805e-06 1.800 2.48400e-06 1.800 2.48405e-06 0.000 2.48700e-06 0.000 2.48705e-06 1.800 2.51100e-06 1.800
+ 2.51105e-06 0.000 2.51700e-06 0.000 2.51705e-06 1.800 2.52300e-06 1.800 2.52305e-06 0.000 2.52900e-06 0.000
+ 2.52905e-06 1.800 2.53200e-06 1.800 2.53205e-06 0.000 2.54400e-06 0.000 2.54405e-06 1.800 2.55000e-06 1.800
+ 2.55005e-06 0.000 2.56200e-06 0.000 2.56205e-06 1.800 2.56800e-06 1.800 2.56805e-06 0.000 2.57100e-06 0.000
+ 2.57105e-06 1.800 2.58000e-06 1.800 2.58005e-06 0.000 2.59200e-06 0.000 2.59205e-06 1.800 2.60700e-06 1.800
+ 2.60705e-06 0.000 2.61300e-06 0.000 2.61305e-06 1.800 2.61600e-06 1.800 2.61605e-06 0.000 2.61900e-06 0.000
+ 2.61905e-06 1.800 2.62500e-06 1.800 2.62505e-06 0.000 2.64000e-06 0.000 2.64005e-06 1.800 2.64300e-06 1.800
+ 2.64305e-06 0.000 2.65200e-06 0.000 2.65205e-06 1.800 2.65500e-06 1.800 2.65505e-06 0.000 2.66400e-06 0.000
+ 2.66405e-06 1.800 2.67300e-06 1.800 2.67305e-06 0.000 2.67600e-06 0.000 2.67605e-06 1.800 2.68200e-06 1.800
+ 2.68205e-06 0.000 2.70000e-06 0.000 2.70005e-06 1.800 2.70900e-06 1.800 2.70905e-06 0.000 2.71500e-06 0.000
+ 2.71505e-06 1.800 2.72100e-06 1.800 2.72105e-06 0.000 2.72700e-06 0.000 2.72705e-06 1.800 2.73000e-06 1.800
+ 2.73005e-06 0.000 2.73300e-06 0.000 2.73305e-06 1.800 2.73600e-06 1.800 2.73605e-06 0.000 2.74500e-06 0.000
+ 2.74505e-06 1.800 2.75100e-06 1.800 2.75105e-06 0.000 2.76600e-06 0.000 2.76605e-06 1.800 2.77200e-06 1.800
+ 2.77205e-06 0.000 2.77500e-06 0.000 2.77505e-06 1.800 2.78100e-06 1.800 2.78105e-06 0.000 2.78700e-06 0.000
+ 2.78705e-06 1.800 2.79600e-06 1.800 2.79605e-06 0.000 2.79900e-06 0.000 2.79905e-06 1.800 2.80200e-06 1.800
+ 2.80205e-06 0.000 2.80500e-06 0.000 2.80505e-06 1.800 2.80800e-06 1.800 2.80805e-06 0.000 2.81100e-06 0.000
+ 2.81105e-06 1.800 2.82000e-06 1.800 2.82005e-06 0.000 2.84100e-06 0.000 2.84105e-06 1.800 2.84400e-06 1.800
+ 2.84405e-06 0.000 2.84700e-06 0.000 2.84705e-06 1.800 2.85300e-06 1.800 2.85305e-06 0.000 2.85900e-06 0.000
+ 2.85905e-06 1.800 2.86500e-06 1.800 2.86505e-06 0.000 2.87400e-06 0.000 2.87405e-06 1.800 2.87700e-06 1.800
+ 2.87705e-06 0.000 2.88000e-06 0.000 2.88005e-06 1.800 2.88600e-06 1.800 2.88605e-06 0.000 2.88900e-06 0.000
+ 2.88905e-06 1.800 2.89200e-06 1.800 2.89205e-06 0.000 2.89500e-06 0.000 2.89505e-06 1.800 2.90400e-06 1.800
+ 2.90405e-06 0.000 2.91000e-06 0.000 2.91005e-06 1.800 2.91300e-06 1.800 2.91305e-06 0.000 2.91600e-06 0.000
+ 2.91605e-06 1.800 2.91900e-06 1.800 2.91905e-06 0.000 2.92800e-06 0.000 2.92805e-06 1.800 2.93400e-06 1.800
+ 2.93405e-06 0.000 2.93700e-06 0.000 2.93705e-06 1.800 2.94000e-06 1.800 2.94005e-06 0.000 2.94300e-06 0.000
+ 2.94305e-06 1.800 2.94600e-06 1.800 2.94605e-06 0.000 2.95200e-06 0.000 2.95205e-06 1.800 2.96400e-06 1.800
+ 2.96405e-06 0.000 2.96700e-06 0.000 2.96705e-06 1.800 2.97000e-06 1.800 2.97005e-06 0.000 2.97300e-06 0.000
+ 2.97305e-06 1.800 2.97600e-06 1.800 2.97605e-06 0.000 2.98200e-06 0.000 2.98205e-06 1.800 2.98800e-06 1.800
+ 2.98805e-06 0.000 2.99100e-06 0.000 2.99105e-06 1.800 2.99400e-06 1.800 2.99405e-06 0.000 3.00300e-06 0.000
+ 3.00305e-06 1.800 3.00900e-06 1.800 3.00905e-06 0.000 3.01500e-06 0.000 3.01505e-06 1.800 3.02700e-06 1.800
+ 3.02705e-06 0.000 3.03000e-06 0.000 3.03005e-06 1.800 3.03300e-06 1.800 3.03305e-06 0.000 3.03600e-06 0.000
+ 3.03605e-06 1.800 3.04200e-06 1.800 3.04205e-06 0.000 3.04500e-06 0.000 3.04505e-06 1.800 3.05700e-06 1.800
+ 3.05705e-06 0.000 3.06900e-06 0.000 3.06905e-06 1.800 3.07200e-06 1.800
+ )
Xd_a0 src_a0 a0 vdd gnd tb_inv
Va1 src_a1 gnd PWL(
+ 0.00000e+00 1.800 3.84000e-07 1.800 3.84050e-07 0.000 7.68000e-07 0.000 7.68050e-07 1.800 1.15200e-06 1.800
+ 1.15205e-06 0.000 1.53600e-06 0.000 1.53605e-06 1.800 1.54200e-06 1.800 1.54205e-06 0.000 1.54800e-06 0.000
+ 1.54805e-06 1.800 1.55400e-06 1.800 1.55405e-06 0.000 1.55700e-06 0.000 1.55705e-06 1.800 1.56000e-06 1.800
+ 1.56005e-06 0.000 1.56300e-06 0.000 1.56305e-06 1.800 1.57500e-06 1.800 1.57505e-06 0.000 1.57800e-06 0.000
+ 1.57805e-06 1.800 1.59000e-06 1.800 1.59005e-06 0.000 1.59300e-06 0.000 1.59305e-06 1.800 1.59600e-06 1.800
+ 1.59605e-06 0.000 1.60200e-06 0.000 1.60205e-06 1.800 1.60500e-06 1.800 1.60505e-06 0.000 1.61100e-06 0.000
+ 1.61105e-06 1.800 1.62600e-06 1.800 1.62605e-06 0.000 1.63500e-06 0.000 1.63505e-06 1.800 1.63800e-06 1.800
+ 1.63805e-06 0.000 1.64100e-06 0.000 1.64105e-06 1.800 1.65000e-06 1.800 1.65005e-06 0.000 1.65600e-06 0.000
+ 1.65605e-06 1.800 1.65900e-06 1.800 1.65905e-06 0.000 1.67100e-06 0.000 1.67105e-06 1.800 1.67700e-06 1.800
+ 1.67705e-06 0.000 1.69200e-06 0.000 1.69205e-06 1.800 1.70100e-06 1.800 1.70105e-06 0.000 1.70700e-06 0.000
+ 1.70705e-06 1.800 1.71000e-06 1.800 1.71005e-06 0.000 1.71300e-06 0.000 1.71305e-06 1.800 1.71600e-06 1.800
+ 1.71605e-06 0.000 1.71900e-06 0.000 1.71905e-06 1.800 1.72200e-06 1.800 1.72205e-06 0.000 1.72800e-06 0.000
+ 1.72805e-06 1.800 1.73100e-06 1.800 1.73105e-06 0.000 1.74300e-06 0.000 1.74305e-06 1.800 1.74600e-06 1.800
+ 1.74605e-06 0.000 1.74900e-06 0.000 1.74905e-06 1.800 1.75500e-06 1.800 1.75505e-06 0.000 1.76400e-06 0.000
+ 1.76405e-06 1.800 1.76700e-06 1.800 1.76705e-06 0.000 1.77300e-06 0.000 1.77305e-06 1.800 1.77900e-06 1.800
+ 1.77905e-06 0.000 1.78200e-06 0.000 1.78205e-06 1.800 1.79100e-06 1.800 1.79105e-06 0.000 1.79400e-06 0.000
+ 1.79405e-06 1.800 1.79700e-06 1.800 1.79705e-06 0.000 1.80300e-06 0.000 1.80305e-06 1.800 1.80900e-06 1.800
+ 1.80905e-06 0.000 1.81200e-06 0.000 1.81205e-06 1.800 1.81800e-06 1.800 1.81805e-06 0.000 1.82400e-06 0.000
+ 1.82405e-06 1.800 1.82700e-06 1.800 1.82705e-06 0.000 1.83000e-06 0.000 1.83005e-06 1.800 1.83300e-06 1.800
+ 1.83305e-06 0.000 1.83900e-06 0.000 1.83905e-06 1.800 1.84500e-06 1.800 1.84505e-06 0.000 1.84800e-06 0.000
+ 1.84805e-06 1.800 1.85400e-06 1.800 1.85405e-06 0.000 1.86000e-06 0.000 1.86005e-06 1.800 1.86300e-06 1.800
+ 1.86305e-06 0.000 1.86600e-06 0.000 1.86605e-06 1.800 1.87200e-06 1.800 1.87205e-06 0.000 1.87500e-06 0.000
+ 1.87505e-06 1.800 1.89000e-06 1.800 1.89005e-06 0.000 1.89300e-06 0.000 1.89305e-06 1.800 1.89600e-06 1.800
+ 1.89605e-06 0.000 1.90200e-06 0.000 1.90205e-06 1.800 1.90500e-06 1.800 1.90505e-06 0.000 1.90800e-06 0.000
+ 1.90805e-06 1.800 1.91100e-06 1.800 1.91105e-06 0.000 1.91400e-06 0.000 1.91405e-06 1.800 1.92300e-06 1.800
+ 1.92305e-06 0.000 1.93800e-06 0.000 1.93805e-06 1.800 1.94100e-06 1.800 1.94105e-06 0.000 1.94400e-06 0.000
+ 1.94405e-06 1.800 1.94700e-06 1.800 1.94705e-06 0.000 1.95300e-06 0.000 1.95305e-06 1.800 1.95900e-06 1.800
+ 1.95905e-06 0.000 1.97100e-06 0.000 1.97105e-06 1.800 1.97400e-06 1.800 1.97405e-06 0.000 1.97700e-06 0.000
+ 1.97705e-06 1.800 1.98000e-06 1.800 1.98005e-06 0.000 1.98300e-06 0.000 1.98305e-06 1.800 1.99500e-06 1.800
+ 1.99505e-06 0.000 1.99800e-06 0.000 1.99805e-06 1.800 2.00100e-06 1.800 2.00105e-06 0.000 2.01000e-06 0.000
+ 2.01005e-06 1.800 2.01300e-06 1.800 2.01305e-06 0.000 2.01600e-06 0.000 2.01605e-06 1.800 2.02200e-06 1.800
+ 2.02205e-06 0.000 2.03400e-06 0.000 2.03405e-06 1.800 2.03700e-06 1.800 2.03705e-06 0.000 2.04000e-06 0.000
+ 2.04005e-06 1.800 2.04300e-06 1.800 2.04305e-06 0.000 2.04900e-06 0.000 2.04905e-06 1.800 2.06100e-06 1.800
+ 2.06105e-06 0.000 2.06400e-06 0.000 2.06405e-06 1.800 2.07000e-06 1.800 2.07005e-06 0.000 2.07300e-06 0.000
+ 2.07305e-06 1.800 2.07600e-06 1.800 2.07605e-06 0.000 2.07900e-06 0.000 2.07905e-06 1.800 2.08500e-06 1.800
+ 2.08505e-06 0.000 2.09400e-06 0.000 2.09405e-06 1.800 2.10000e-06 1.800 2.10005e-06 0.000 2.10300e-06 0.000
+ 2.10305e-06 1.800 2.10600e-06 1.800 2.10605e-06 0.000 2.12100e-06 0.000 2.12105e-06 1.800 2.12400e-06 1.800
+ 2.12405e-06 0.000 2.13600e-06 0.000 2.13605e-06 1.800 2.15100e-06 1.800 2.15105e-06 0.000 2.15700e-06 0.000
+ 2.15705e-06 1.800 2.16300e-06 1.800 2.16305e-06 0.000 2.16600e-06 0.000 2.16605e-06 1.800 2.16900e-06 1.800
+ 2.16905e-06 0.000 2.17200e-06 0.000 2.17205e-06 1.800 2.17800e-06 1.800 2.17805e-06 0.000 2.18700e-06 0.000
+ 2.18705e-06 1.800 2.19000e-06 1.800 2.19005e-06 0.000 2.19300e-06 0.000 2.19305e-06 1.800 2.19900e-06 1.800
+ 2.19905e-06 0.000 2.20200e-06 0.000 2.20205e-06 1.800 2.21100e-06 1.800 2.21105e-06 0.000 2.22600e-06 0.000
+ 2.22605e-06 1.800 2.22900e-06 1.800 2.22905e-06 0.000 2.23500e-06 0.000 2.23505e-06 1.800 2.23800e-06 1.800
+ 2.23805e-06 0.000 2.24100e-06 0.000 2.24105e-06 1.800 2.25000e-06 1.800 2.25005e-06 0.000 2.25900e-06 0.000
+ 2.25905e-06 1.800 2.26500e-06 1.800 2.26505e-06 0.000 2.27100e-06 0.000 2.27105e-06 1.800 2.27400e-06 1.800
+ 2.27405e-06 0.000 2.29200e-06 0.000 2.29205e-06 1.800 2.30400e-06 1.800 2.30405e-06 0.000 2.30700e-06 0.000
+ 2.30705e-06 1.800 2.31000e-06 1.800 2.31005e-06 0.000 2.31600e-06 0.000 2.31605e-06 1.800 2.32200e-06 1.800
+ 2.32205e-06 0.000 2.32500e-06 0.000 2.32505e-06 1.800 2.33400e-06 1.800 2.33405e-06 0.000 2.33700e-06 0.000
+ 2.33705e-06 1.800 2.34000e-06 1.800 2.34005e-06 0.000 2.35200e-06 0.000 2.35205e-06 1.800 2.35800e-06 1.800
+ 2.35805e-06 0.000 2.36100e-06 0.000 2.36105e-06 1.800 2.36400e-06 1.800 2.36405e-06 0.000 2.36700e-06 0.000
+ 2.36705e-06 1.800 2.37000e-06 1.800 2.37005e-06 0.000 2.37600e-06 0.000 2.37605e-06 1.800 2.38500e-06 1.800
+ 2.38505e-06 0.000 2.38800e-06 0.000 2.38805e-06 1.800 2.39700e-06 1.800 2.39705e-06 0.000 2.40300e-06 0.000
+ 2.40305e-06 1.800 2.40600e-06 1.800 2.40605e-06 0.000 2.41500e-06 0.000 2.41505e-06 1.800 2.41800e-06 1.800
+ 2.41805e-06 0.000 2.43000e-06 0.000 2.43005e-06 1.800 2.43600e-06 1.800 2.43605e-06 0.000 2.46300e-06 0.000
+ 2.46305e-06 1.800 2.47200e-06 1.800 2.47205e-06 0.000 2.47800e-06 0.000 2.47805e-06 1.800 2.49000e-06 1.800
+ 2.49005e-06 0.000 2.49300e-06 0.000 2.49305e-06 1.800 2.49600e-06 1.800 2.49605e-06 0.000 2.49900e-06 0.000
+ 2.49905e-06 1.800 2.51100e-06 1.800 2.51105e-06 0.000 2.51400e-06 0.000 2.51405e-06 1.800 2.53500e-06 1.800
+ 2.53505e-06 0.000 2.54100e-06 0.000 2.54105e-06 1.800 2.54400e-06 1.800 2.54405e-06 0.000 2.55000e-06 0.000
+ 2.55005e-06 1.800 2.55600e-06 1.800 2.55605e-06 0.000 2.55900e-06 0.000 2.55905e-06 1.800 2.56500e-06 1.800
+ 2.56505e-06 0.000 2.58300e-06 0.000 2.58305e-06 1.800 2.58600e-06 1.800 2.58605e-06 0.000 2.59800e-06 0.000
+ 2.59805e-06 1.800 2.60100e-06 1.800 2.60105e-06 0.000 2.60400e-06 0.000 2.60405e-06 1.800 2.61900e-06 1.800
+ 2.61905e-06 0.000 2.62200e-06 0.000 2.62205e-06 1.800 2.62500e-06 1.800 2.62505e-06 0.000 2.62800e-06 0.000
+ 2.62805e-06 1.800 2.63400e-06 1.800 2.63405e-06 0.000 2.64300e-06 0.000 2.64305e-06 1.800 2.64600e-06 1.800
+ 2.64605e-06 0.000 2.64900e-06 0.000 2.64905e-06 1.800 2.65200e-06 1.800 2.65205e-06 0.000 2.66100e-06 0.000
+ 2.66105e-06 1.800 2.68500e-06 1.800 2.68505e-06 0.000 2.68800e-06 0.000 2.68805e-06 1.800 2.70000e-06 1.800
+ 2.70005e-06 0.000 2.70300e-06 0.000 2.70305e-06 1.800 2.70600e-06 1.800 2.70605e-06 0.000 2.71200e-06 0.000
+ 2.71205e-06 1.800 2.71500e-06 1.800 2.71505e-06 0.000 2.72400e-06 0.000 2.72405e-06 1.800 2.73000e-06 1.800
+ 2.73005e-06 0.000 2.73300e-06 0.000 2.73305e-06 1.800 2.74200e-06 1.800 2.74205e-06 0.000 2.74500e-06 0.000
+ 2.74505e-06 1.800 2.74800e-06 1.800 2.74805e-06 0.000 2.75100e-06 0.000 2.75105e-06 1.800 2.75700e-06 1.800
+ 2.75705e-06 0.000 2.76000e-06 0.000 2.76005e-06 1.800 2.76600e-06 1.800 2.76605e-06 0.000 2.76900e-06 0.000
+ 2.76905e-06 1.800 2.77500e-06 1.800 2.77505e-06 0.000 2.78700e-06 0.000 2.78705e-06 1.800 2.79000e-06 1.800
+ 2.79005e-06 0.000 2.79300e-06 0.000 2.79305e-06 1.800 2.79900e-06 1.800 2.79905e-06 0.000 2.80200e-06 0.000
+ 2.80205e-06 1.800 2.80500e-06 1.800 2.80505e-06 0.000 2.80800e-06 0.000 2.80805e-06 1.800 2.81100e-06 1.800
+ 2.81105e-06 0.000 2.81700e-06 0.000 2.81705e-06 1.800 2.82300e-06 1.800 2.82305e-06 0.000 2.82600e-06 0.000
+ 2.82605e-06 1.800 2.82900e-06 1.800 2.82905e-06 0.000 2.83200e-06 0.000 2.83205e-06 1.800 2.83800e-06 1.800
+ 2.83805e-06 0.000 2.84400e-06 0.000 2.84405e-06 1.800 2.85000e-06 1.800 2.85005e-06 0.000 2.85300e-06 0.000
+ 2.85305e-06 1.800 2.87100e-06 1.800 2.87105e-06 0.000 2.88900e-06 0.000 2.88905e-06 1.800 2.89800e-06 1.800
+ 2.89805e-06 0.000 2.90100e-06 0.000 2.90105e-06 1.800 2.90700e-06 1.800 2.90705e-06 0.000 2.91600e-06 0.000
+ 2.91605e-06 1.800 2.92200e-06 1.800 2.92205e-06 0.000 2.92500e-06 0.000 2.92505e-06 1.800 2.92800e-06 1.800
+ 2.92805e-06 0.000 2.93100e-06 0.000 2.93105e-06 1.800 2.93700e-06 1.800 2.93705e-06 0.000 2.94300e-06 0.000
+ 2.94305e-06 1.800 2.96100e-06 1.800 2.96105e-06 0.000 2.96700e-06 0.000 2.96705e-06 1.800 2.97600e-06 1.800
+ 2.97605e-06 0.000 2.97900e-06 0.000 2.97905e-06 1.800 2.98200e-06 1.800 2.98205e-06 0.000 2.98800e-06 0.000
+ 2.98805e-06 1.800 2.99400e-06 1.800 2.99405e-06 0.000 3.00000e-06 0.000 3.00005e-06 1.800 3.00300e-06 1.800
+ 3.00305e-06 0.000 3.01500e-06 0.000 3.01505e-06 1.800 3.01800e-06 1.800 3.01805e-06 0.000 3.02100e-06 0.000
+ 3.02105e-06 1.800 3.02700e-06 1.800 3.02705e-06 0.000 3.03300e-06 0.000 3.03305e-06 1.800 3.03600e-06 1.800
+ 3.03605e-06 0.000 3.04800e-06 0.000 3.04805e-06 1.800 3.05100e-06 1.800 3.05105e-06 0.000 3.05400e-06 0.000
+ 3.05405e-06 1.800 3.05700e-06 1.800 3.05705e-06 0.000 3.06600e-06 0.000 3.06605e-06 1.800 3.06900e-06 1.800
+ 3.06905e-06 0.000 3.07200e-06 0.000
+ )
Xd_a1 src_a1 a1 vdd gnd tb_inv
Va2 src_a2 gnd PWL(
+ 0.00000e+00 1.800 1.92000e-07 1.800 1.92050e-07 0.000 3.84000e-07 0.000 3.84050e-07 1.800 5.76000e-07 1.800
+ 5.76050e-07 0.000 7.68000e-07 0.000 7.68050e-07 1.800 9.60000e-07 1.800 9.60050e-07 0.000 1.15200e-06 0.000
+ 1.15205e-06 1.800 1.34400e-06 1.800 1.34405e-06 0.000 1.53900e-06 0.000 1.53905e-06 1.800 1.54800e-06 1.800
+ 1.54805e-06 0.000 1.55100e-06 0.000 1.55105e-06 1.800 1.55400e-06 1.800 1.55405e-06 0.000 1.57500e-06 0.000
+ 1.57505e-06 1.800 1.58100e-06 1.800 1.58105e-06 0.000 1.59000e-06 0.000 1.59005e-06 1.800 1.59300e-06 1.800
+ 1.59305e-06 0.000 1.59600e-06 0.000 1.59605e-06 1.800 1.59900e-06 1.800 1.59905e-06 0.000 1.60800e-06 0.000
+ 1.60805e-06 1.800 1.61100e-06 1.800 1.61105e-06 0.000 1.61400e-06 0.000 1.61405e-06 1.800 1.61700e-06 1.800
+ 1.61705e-06 0.000 1.62000e-06 0.000 1.62005e-06 1.800 1.62300e-06 1.800 1.62305e-06 0.000 1.62600e-06 0.000
+ 1.62605e-06 1.800 1.62900e-06 1.800 1.62905e-06 0.000 1.63200e-06 0.000 1.63205e-06 1.800 1.63500e-06 1.800
+ 1.63505e-06 0.000 1.63800e-06 0.000 1.63805e-06 1.800 1.64700e-06 1.800 1.64705e-06 0.000 1.65000e-06 0.000
+ 1.65005e-06 1.800 1.65300e-06 1.800 1.65305e-06 0.000 1.66500e-06 0.000 1.66505e-06 1.800 1.66800e-06 1.800
+ 1.66805e-06 0.000 1.67400e-06 0.000 1.67405e-06 1.800 1.68900e-06 1.800 1.68905e-06 0.000 1.69200e-06 0.000
+ 1.69205e-06 1.800 1.69800e-06 1.800 1.69805e-06 0.000 1.70100e-06 0.000 1.70105e-06 1.800 1.70400e-06 1.800
+ 1.70405e-06 0.000 1.70700e-06 0.000 1.70705e-06 1.800 1.71300e-06 1.800 1.71305e-06 0.000 1.72200e-06 0.000
+ 1.72205e-06 1.800 1.72500e-06 1.800 1.72505e-06 0.000 1.72800e-06 0.000 1.72805e-06 1.800 1.73400e-06 1.800
+ 1.73405e-06 0.000 1.74000e-06 0.000 1.74005e-06 1.800 1.74300e-06 1.800 1.74305e-06 0.000 1.74600e-06 0.000
+ 1.74605e-06 1.800 1.74900e-06 1.800 1.74905e-06 0.000 1.75200e-06 0.000 1.75205e-06 1.800 1.76400e-06 1.800
+ 1.76405e-06 0.000 1.76700e-06 0.000 1.76705e-06 1.800 1.77600e-06 1.800 1.77605e-06 0.000 1.78500e-06 0.000
+ 1.78505e-06 1.800 1.78800e-06 1.800 1.78805e-06 0.000 1.79700e-06 0.000 1.79705e-06 1.800 1.80000e-06 1.800
+ 1.80005e-06 0.000 1.81500e-06 0.000 1.81505e-06 1.800 1.82400e-06 1.800 1.82405e-06 0.000 1.82700e-06 0.000
+ 1.82705e-06 1.800 1.83000e-06 1.800 1.83005e-06 0.000 1.83600e-06 0.000 1.83605e-06 1.800 1.84200e-06 1.800
+ 1.84205e-06 0.000 1.84800e-06 0.000 1.84805e-06 1.800 1.85400e-06 1.800 1.85405e-06 0.000 1.85700e-06 0.000
+ 1.85705e-06 1.800 1.86000e-06 1.800 1.86005e-06 0.000 1.86300e-06 0.000 1.86305e-06 1.800 1.86600e-06 1.800
+ 1.86605e-06 0.000 1.86900e-06 0.000 1.86905e-06 1.800 1.87500e-06 1.800 1.87505e-06 0.000 1.89600e-06 0.000
+ 1.89605e-06 1.800 1.90500e-06 1.800 1.90505e-06 0.000 1.91100e-06 0.000 1.91105e-06 1.800 1.91400e-06 1.800
+ 1.91405e-06 0.000 1.91700e-06 0.000 1.91705e-06 1.800 1.92600e-06 1.800 1.92605e-06 0.000 1.93200e-06 0.000
+ 1.93205e-06 1.800 1.93500e-06 1.800 1.93505e-06 0.000 1.93800e-06 0.000 1.93805e-06 1.800 1.94100e-06 1.800
+ 1.94105e-06 0.000 1.94400e-06 0.000 1.94405e-06 1.800 1.95600e-06 1.800 1.95605e-06 0.000 1.96200e-06 0.000
+ 1.96205e-06 1.800 1.96800e-06 1.800 1.96805e-06 0.000 1.97700e-06 0.000 1.97705e-06 1.800 1.98600e-06 1.800
+ 1.98605e-06 0.000 1.98900e-06 0.000 1.98905e-06 1.800 1.99500e-06 1.800 1.99505e-06 0.000 1.99800e-06 0.000
+ 1.99805e-06 1.800 2.00100e-06 1.800 2.00105e-06 0.000 2.00400e-06 0.000 2.00405e-06 1.800 2.00700e-06 1.800
+ 2.00705e-06 0.000 2.01000e-06 0.000 2.01005e-06 1.800 2.01600e-06 1.800 2.01605e-06 0.000 2.03100e-06 0.000
+ 2.03105e-06 1.800 2.04000e-06 1.800 2.04005e-06 0.000 2.04300e-06 0.000 2.04305e-06 1.800 2.04900e-06 1.800
+ 2.04905e-06 0.000 2.05200e-06 0.000 2.05205e-06 1.800 2.05500e-06 1.800 2.05505e-06 0.000 2.06100e-06 0.000
+ 2.06105e-06 1.800 2.06400e-06 1.800 2.06405e-06 0.000 2.06700e-06 0.000 2.06705e-06 1.800 2.07600e-06 1.800
+ 2.07605e-06 0.000 2.08200e-06 0.000 2.08205e-06 1.800 2.09100e-06 1.800 2.09105e-06 0.000 2.09400e-06 0.000
+ 2.09405e-06 1.800 2.10300e-06 1.800 2.10305e-06 0.000 2.11200e-06 0.000 2.11205e-06 1.800 2.11500e-06 1.800
+ 2.11505e-06 0.000 2.11800e-06 0.000 2.11805e-06 1.800 2.12100e-06 1.800 2.12105e-06 0.000 2.12400e-06 0.000
+ 2.12405e-06 1.800 2.12700e-06 1.800 2.12705e-06 0.000 2.13900e-06 0.000 2.13905e-06 1.800 2.14200e-06 1.800
+ 2.14205e-06 0.000 2.14500e-06 0.000 2.14505e-06 1.800 2.15100e-06 1.800 2.15105e-06 0.000 2.15400e-06 0.000
+ 2.15405e-06 1.800 2.15700e-06 1.800 2.15705e-06 0.000 2.16000e-06 0.000 2.16005e-06 1.800 2.17200e-06 1.800
+ 2.17205e-06 0.000 2.17800e-06 0.000 2.17805e-06 1.800 2.18400e-06 1.800 2.18405e-06 0.000 2.18700e-06 0.000
+ 2.18705e-06 1.800 2.19300e-06 1.800 2.19305e-06 0.000 2.19900e-06 0.000 2.19905e-06 1.800 2.20500e-06 1.800
+ 2.20505e-06 0.000 2.20800e-06 0.000 2.20805e-06 1.800 2.21100e-06 1.800 2.21105e-06 0.000 2.21700e-06 0.000
+ 2.21705e-06 1.800 2.22300e-06 1.800 2.22305e-06 0.000 2.22600e-06 0.000 2.22605e-06 1.800 2.23800e-06 1.800
+ 2.23805e-06 0.000 2.24100e-06 0.000 2.24105e-06 1.800 2.24700e-06 1.800 2.24705e-06 0.000 2.26200e-06 0.000
+ 2.26205e-06 1.800 2.26500e-06 1.800 2.26505e-06 0.000 2.26800e-06 0.000 2.26805e-06 1.800 2.27400e-06 1.800
+ 2.27405e-06 0.000 2.28000e-06 0.000 2.28005e-06 1.800 2.28600e-06 1.800 2.28605e-06 0.000 2.28900e-06 0.000
+ 2.28905e-06 1.800 2.29500e-06 1.800 2.29505e-06 0.000 2.29800e-06 0.000 2.29805e-06 1.800 2.31900e-06 1.800
+ 2.31905e-06 0.000 2.32200e-06 0.000 2.32205e-06 1.800 2.32800e-06 1.800 2.32805e-06 0.000 2.33400e-06 0.000
+ 2.33405e-06 1.800 2.34000e-06 1.800 2.34005e-06 0.000 2.35200e-06 0.000 2.35205e-06 1.800 2.35500e-06 1.800
+ 2.35505e-06 0.000 2.36100e-06 0.000 2.36105e-06 1.800 2.36400e-06 1.800 2.36405e-06 0.000 2.37000e-06 0.000
+ 2.37005e-06 1.800 2.37300e-06 1.800 2.37305e-06 0.000 2.37900e-06 0.000 2.37905e-06 1.800 2.38200e-06 1.800
+ 2.38205e-06 0.000 2.38800e-06 0.000 2.38805e-06 1.800 2.39100e-06 1.800 2.39105e-06 0.000 2.39400e-06 0.000
+ 2.39405e-06 1.800 2.39700e-06 1.800 2.39705e-06 0.000 2.40300e-06 0.000 2.40305e-06 1.800 2.41500e-06 1.800
+ 2.41505e-06 0.000 2.42100e-06 0.000 2.42105e-06 1.800 2.42400e-06 1.800 2.42405e-06 0.000 2.42700e-06 0.000
+ 2.42705e-06 1.800 2.43600e-06 1.800 2.43605e-06 0.000 2.44200e-06 0.000 2.44205e-06 1.800 2.44500e-06 1.800
+ 2.44505e-06 0.000 2.44800e-06 0.000 2.44805e-06 1.800 2.45700e-06 1.800 2.45705e-06 0.000 2.46900e-06 0.000
+ 2.46905e-06 1.800 2.47200e-06 1.800 2.47205e-06 0.000 2.47500e-06 0.000 2.47505e-06 1.800 2.47800e-06 1.800
+ 2.47805e-06 0.000 2.48100e-06 0.000 2.48105e-06 1.800 2.48400e-06 1.800 2.48405e-06 0.000 2.49000e-06 0.000
+ 2.49005e-06 1.800 2.49600e-06 1.800 2.49605e-06 0.000 2.49900e-06 0.000 2.49905e-06 1.800 2.51100e-06 1.800
+ 2.51105e-06 0.000 2.51400e-06 0.000 2.51405e-06 1.800 2.52000e-06 1.800 2.52005e-06 0.000 2.52300e-06 0.000
+ 2.52305e-06 1.800 2.52900e-06 1.800 2.52905e-06 0.000 2.54100e-06 0.000 2.54105e-06 1.800 2.54400e-06 1.800
+ 2.54405e-06 0.000 2.54700e-06 0.000 2.54705e-06 1.800 2.55600e-06 1.800 2.55605e-06 0.000 2.55900e-06 0.000
+ 2.55905e-06 1.800 2.57400e-06 1.800 2.57405e-06 0.000 2.58000e-06 0.000 2.58005e-06 1.800 2.58300e-06 1.800
+ 2.58305e-06 0.000 2.59200e-06 0.000 2.59205e-06 1.800 2.59500e-06 1.800 2.59505e-06 0.000 2.59800e-06 0.000
+ 2.59805e-06 1.800 2.60100e-06 1.800 2.60105e-06 0.000 2.60700e-06 0.000 2.60705e-06 1.800 2.61300e-06 1.800
+ 2.61305e-06 0.000 2.61600e-06 0.000 2.61605e-06 1.800 2.61900e-06 1.800 2.61905e-06 0.000 2.62200e-06 0.000
+ 2.62205e-06 1.800 2.62500e-06 1.800 2.62505e-06 0.000 2.64000e-06 0.000 2.64005e-06 1.800 2.64600e-06 1.800
+ 2.64605e-06 0.000 2.64900e-06 0.000 2.64905e-06 1.800 2.65200e-06 1.800 2.65205e-06 0.000 2.65800e-06 0.000
+ 2.65805e-06 1.800 2.66400e-06 1.800 2.66405e-06 0.000 2.66700e-06 0.000 2.66705e-06 1.800 2.67000e-06 1.800
+ 2.67005e-06 0.000 2.67300e-06 0.000 2.67305e-06 1.800 2.67600e-06 1.800 2.67605e-06 0.000 2.68500e-06 0.000
+ 2.68505e-06 1.800 2.69700e-06 1.800 2.69705e-06 0.000 2.70000e-06 0.000 2.70005e-06 1.800 2.70600e-06 1.800
+ 2.70605e-06 0.000 2.71800e-06 0.000 2.71805e-06 1.800 2.72700e-06 1.800 2.72705e-06 0.000 2.73000e-06 0.000
+ 2.73005e-06 1.800 2.73900e-06 1.800 2.73905e-06 0.000 2.74500e-06 0.000 2.74505e-06 1.800 2.75100e-06 1.800
+ 2.75105e-06 0.000 2.75700e-06 0.000 2.75705e-06 1.800 2.76000e-06 1.800 2.76005e-06 0.000 2.76300e-06 0.000
+ 2.76305e-06 1.800 2.76900e-06 1.800 2.76905e-06 0.000 2.78100e-06 0.000 2.78105e-06 1.800 2.78700e-06 1.800
+ 2.78705e-06 0.000 2.79300e-06 0.000 2.79305e-06 1.800 2.79900e-06 1.800 2.79905e-06 0.000 2.80200e-06 0.000
+ 2.80205e-06 1.800 2.80500e-06 1.800 2.80505e-06 0.000 2.80800e-06 0.000 2.80805e-06 1.800 2.81700e-06 1.800
+ 2.81705e-06 0.000 2.82300e-06 0.000 2.82305e-06 1.800 2.82900e-06 1.800 2.82905e-06 0.000 2.83200e-06 0.000
+ 2.83205e-06 1.800 2.83500e-06 1.800 2.83505e-06 0.000 2.84100e-06 0.000 2.84105e-06 1.800 2.84400e-06 1.800
+ 2.84405e-06 0.000 2.84700e-06 0.000 2.84705e-06 1.800 2.85300e-06 1.800 2.85305e-06 0.000 2.86200e-06 0.000
+ 2.86205e-06 1.800 2.86500e-06 1.800 2.86505e-06 0.000 2.86800e-06 0.000 2.86805e-06 1.800 2.87400e-06 1.800
+ 2.87405e-06 0.000 2.88000e-06 0.000 2.88005e-06 1.800 2.88300e-06 1.800 2.88305e-06 0.000 2.89800e-06 0.000
+ 2.89805e-06 1.800 2.90100e-06 1.800 2.90105e-06 0.000 2.90400e-06 0.000 2.90405e-06 1.800 2.90700e-06 1.800
+ 2.90705e-06 0.000 2.91900e-06 0.000 2.91905e-06 1.800 2.92200e-06 1.800 2.92205e-06 0.000 2.94300e-06 0.000
+ 2.94305e-06 1.800 2.94900e-06 1.800 2.94905e-06 0.000 2.95200e-06 0.000 2.95205e-06 1.800 2.96400e-06 1.800
+ 2.96405e-06 0.000 2.96700e-06 0.000 2.96705e-06 1.800 2.97300e-06 1.800 2.97305e-06 0.000 2.98200e-06 0.000
+ 2.98205e-06 1.800 2.98500e-06 1.800 2.98505e-06 0.000 2.99100e-06 0.000 2.99105e-06 1.800 3.00300e-06 1.800
+ 3.00305e-06 0.000 3.00900e-06 0.000 3.00905e-06 1.800 3.01200e-06 1.800 3.01205e-06 0.000 3.01500e-06 0.000
+ 3.01505e-06 1.800 3.01800e-06 1.800 3.01805e-06 0.000 3.02100e-06 0.000 3.02105e-06 1.800 3.02400e-06 1.800
+ 3.02405e-06 0.000 3.02700e-06 0.000 3.02705e-06 1.800 3.03000e-06 1.800 3.03005e-06 0.000 3.04200e-06 0.000
+ 3.04205e-06 1.800 3.04500e-06 1.800 3.04505e-06 0.000 3.04800e-06 0.000 3.04805e-06 1.800 3.07200e-06 1.800
+ )
Xd_a2 src_a2 a2 vdd gnd tb_inv
Va3 src_a3 gnd PWL(
+ 0.00000e+00 1.800 9.60000e-08 1.800 9.60500e-08 0.000 1.92000e-07 0.000 1.92050e-07 1.800 2.88000e-07 1.800
+ 2.88050e-07 0.000 3.84000e-07 0.000 3.84050e-07 1.800 4.80000e-07 1.800 4.80050e-07 0.000 5.76000e-07 0.000
+ 5.76050e-07 1.800 6.72000e-07 1.800 6.72050e-07 0.000 7.68000e-07 0.000 7.68050e-07 1.800 8.64000e-07 1.800
+ 8.64050e-07 0.000 9.60000e-07 0.000 9.60050e-07 1.800 1.05600e-06 1.800 1.05605e-06 0.000 1.15200e-06 0.000
+ 1.15205e-06 1.800 1.24800e-06 1.800 1.24805e-06 0.000 1.34400e-06 0.000 1.34405e-06 1.800 1.44000e-06 1.800
+ 1.44005e-06 0.000 1.53600e-06 0.000 1.53605e-06 1.800 1.53900e-06 1.800 1.53905e-06 0.000 1.54200e-06 0.000
+ 1.54205e-06 1.800 1.55100e-06 1.800 1.55105e-06 0.000 1.55400e-06 0.000 1.55405e-06 1.800 1.55700e-06 1.800
+ 1.55705e-06 0.000 1.56000e-06 0.000 1.56005e-06 1.800 1.56900e-06 1.800 1.56905e-06 0.000 1.57200e-06 0.000
+ 1.57205e-06 1.800 1.57500e-06 1.800 1.57505e-06 0.000 1.58100e-06 0.000 1.58105e-06 1.800 1.59600e-06 1.800
+ 1.59605e-06 0.000 1.59900e-06 0.000 1.59905e-06 1.800 1.60500e-06 1.800 1.60505e-06 0.000 1.60800e-06 0.000
+ 1.60805e-06 1.800 1.61100e-06 1.800 1.61105e-06 0.000 1.62000e-06 0.000 1.62005e-06 1.800 1.62300e-06 1.800
+ 1.62305e-06 0.000 1.62600e-06 0.000 1.62605e-06 1.800 1.63200e-06 1.800 1.63205e-06 0.000 1.63500e-06 0.000
+ 1.63505e-06 1.800 1.63800e-06 1.800 1.63805e-06 0.000 1.64400e-06 0.000 1.64405e-06 1.800 1.64700e-06 1.800
+ 1.64705e-06 0.000 1.65600e-06 0.000 1.65605e-06 1.800 1.65900e-06 1.800 1.65905e-06 0.000 1.66200e-06 0.000
+ 1.66205e-06 1.800 1.66500e-06 1.800 1.66505e-06 0.000 1.68600e-06 0.000 1.68605e-06 1.800 1.69500e-06 1.800
+ 1.69505e-06 0.000 1.71000e-06 0.000 1.71005e-06 1.800 1.71300e-06 1.800 1.71305e-06 0.000 1.71900e-06 0.000
+ 1.71905e-06 1.800 1.72500e-06 1.800 1.72505e-06 0.000 1.74000e-06 0.000 1.74005e-06 1.800 1.74300e-06 1.800
+ 1.74305e-06 0.000 1.74600e-06 0.000 1.74605e-06 1.800 1.75500e-06 1.800 1.75505e-06 0.000 1.75800e-06 0.000
+ 1.75805e-06 1.800 1.76400e-06 1.800 1.76405e-06 0.000 1.76700e-06 0.000 1.76705e-06 1.800 1.77000e-06 1.800
+ 1.77005e-06 0.000 1.77900e-06 0.000 1.77905e-06 1.800 1.78500e-06 1.800 1.78505e-06 0.000 1.78800e-06 0.000
+ 1.78805e-06 1.800 1.79700e-06 1.800 1.79705e-06 0.000 1.80600e-06 0.000 1.80605e-06 1.800 1.80900e-06 1.800
+ 1.80905e-06 0.000 1.82400e-06 0.000 1.82405e-06 1.800 1.82700e-06 1.800 1.82705e-06 0.000 1.83600e-06 0.000
+ 1.83605e-06 1.800 1.84200e-06 1.800 1.84205e-06 0.000 1.84500e-06 0.000 1.84505e-06 1.800 1.85100e-06 1.800
+ 1.85105e-06 0.000 1.85400e-06 0.000 1.85405e-06 1.800 1.85700e-06 1.800 1.85705e-06 0.000 1.86000e-06 0.000
+ 1.86005e-06 1.800 1.86600e-06 1.800 1.86605e-06 0.000 1.86900e-06 0.000 1.86905e-06 1.800 1.87200e-06 1.800
+ 1.87205e-06 0.000 1.87500e-06 0.000 1.87505e-06 1.800 1.87800e-06 1.800 1.87805e-06 0.000 1.89000e-06 0.000
+ 1.89005e-06 1.800 1.89600e-06 1.800 1.89605e-06 0.000 1.89900e-06 0.000 1.89905e-06 1.800 1.90800e-06 1.800
+ 1.90805e-06 0.000 1.91100e-06 0.000 1.91105e-06 1.800 1.91700e-06 1.800 1.91705e-06 0.000 1.92900e-06 0.000
+ 1.92905e-06 1.800 1.93500e-06 1.800 1.93505e-06 0.000 1.93800e-06 0.000 1.93805e-06 1.800 1.94100e-06 1.800
+ 1.94105e-06 0.000 1.94400e-06 0.000 1.94405e-06 1.800 1.94700e-06 1.800 1.94705e-06 0.000 1.95300e-06 0.000
+ 1.95305e-06 1.800 1.95900e-06 1.800 1.95905e-06 0.000 1.96500e-06 0.000 1.96505e-06 1.800 1.97400e-06 1.800
+ 1.97405e-06 0.000 1.97700e-06 0.000 1.97705e-06 1.800 1.98300e-06 1.800 1.98305e-06 0.000 1.98900e-06 0.000
+ 1.98905e-06 1.800 1.99500e-06 1.800 1.99505e-06 0.000 2.01300e-06 0.000 2.01305e-06 1.800 2.01900e-06 1.800
+ 2.01905e-06 0.000 2.03100e-06 0.000 2.03105e-06 1.800 2.03400e-06 1.800 2.03405e-06 0.000 2.04300e-06 0.000
+ 2.04305e-06 1.800 2.04600e-06 1.800 2.04605e-06 0.000 2.04900e-06 0.000 2.04905e-06 1.800 2.05500e-06 1.800
+ 2.05505e-06 0.000 2.05800e-06 0.000 2.05805e-06 1.800 2.07300e-06 1.800 2.07305e-06 0.000 2.07600e-06 0.000
+ 2.07605e-06 1.800 2.07900e-06 1.800 2.07905e-06 0.000 2.09100e-06 0.000 2.09105e-06 1.800 2.10000e-06 1.800
+ 2.10005e-06 0.000 2.10300e-06 0.000 2.10305e-06 1.800 2.10600e-06 1.800 2.10605e-06 0.000 2.10900e-06 0.000
+ 2.10905e-06 1.800 2.11200e-06 1.800 2.11205e-06 0.000 2.12100e-06 0.000 2.12105e-06 1.800 2.12700e-06 1.800
+ 2.12705e-06 0.000 2.13000e-06 0.000 2.13005e-06 1.800 2.13300e-06 1.800 2.13305e-06 0.000 2.13600e-06 0.000
+ 2.13605e-06 1.800 2.13900e-06 1.800 2.13905e-06 0.000 2.15100e-06 0.000 2.15105e-06 1.800 2.15700e-06 1.800
+ 2.15705e-06 0.000 2.16300e-06 0.000 2.16305e-06 1.800 2.16600e-06 1.800 2.16605e-06 0.000 2.17200e-06 0.000
+ 2.17205e-06 1.800 2.18700e-06 1.800 2.18705e-06 0.000 2.19300e-06 0.000 2.19305e-06 1.800 2.19600e-06 1.800
+ 2.19605e-06 0.000 2.20200e-06 0.000 2.20205e-06 1.800 2.20500e-06 1.800 2.20505e-06 0.000 2.21100e-06 0.000
+ 2.21105e-06 1.800 2.21700e-06 1.800 2.21705e-06 0.000 2.22000e-06 0.000 2.22005e-06 1.800 2.23200e-06 1.800
+ 2.23205e-06 0.000 2.25600e-06 0.000 2.25605e-06 1.800 2.26200e-06 1.800 2.26205e-06 0.000 2.27100e-06 0.000
+ 2.27105e-06 1.800 2.28000e-06 1.800 2.28005e-06 0.000 2.28600e-06 0.000 2.28605e-06 1.800 2.29200e-06 1.800
+ 2.29205e-06 0.000 2.31000e-06 0.000 2.31005e-06 1.800 2.31600e-06 1.800 2.31605e-06 0.000 2.31900e-06 0.000
+ 2.31905e-06 1.800 2.32800e-06 1.800 2.32805e-06 0.000 2.33100e-06 0.000 2.33105e-06 1.800 2.35500e-06 1.800
+ 2.35505e-06 0.000 2.36100e-06 0.000 2.36105e-06 1.800 2.36700e-06 1.800 2.36705e-06 0.000 2.37600e-06 0.000
+ 2.37605e-06 1.800 2.39100e-06 1.800 2.39105e-06 0.000 2.39400e-06 0.000 2.39405e-06 1.800 2.39700e-06 1.800
+ 2.39705e-06 0.000 2.40300e-06 0.000 2.40305e-06 1.800 2.41500e-06 1.800 2.41505e-06 0.000 2.41800e-06 0.000
+ 2.41805e-06 1.800 2.42100e-06 1.800 2.42105e-06 0.000 2.42400e-06 0.000 2.42405e-06 1.800 2.43300e-06 1.800
+ 2.43305e-06 0.000 2.44800e-06 0.000 2.44805e-06 1.800 2.45400e-06 1.800 2.45405e-06 0.000 2.45700e-06 0.000
+ 2.45705e-06 1.800 2.46900e-06 1.800 2.46905e-06 0.000 2.47200e-06 0.000 2.47205e-06 1.800 2.47500e-06 1.800
+ 2.47505e-06 0.000 2.47800e-06 0.000 2.47805e-06 1.800 2.48100e-06 1.800 2.48105e-06 0.000 2.49000e-06 0.000
+ 2.49005e-06 1.800 2.49600e-06 1.800 2.49605e-06 0.000 2.49900e-06 0.000 2.49905e-06 1.800 2.50200e-06 1.800
+ 2.50205e-06 0.000 2.50800e-06 0.000 2.50805e-06 1.800 2.51100e-06 1.800 2.51105e-06 0.000 2.51400e-06 0.000
+ 2.51405e-06 1.800 2.51700e-06 1.800 2.51705e-06 0.000 2.52000e-06 0.000 2.52005e-06 1.800 2.52300e-06 1.800
+ 2.52305e-06 0.000 2.52600e-06 0.000 2.52605e-06 1.800 2.54100e-06 1.800 2.54105e-06 0.000 2.55900e-06 0.000
+ 2.55905e-06 1.800 2.56500e-06 1.800 2.56505e-06 0.000 2.56800e-06 0.000 2.56805e-06 1.800 2.57100e-06 1.800
+ 2.57105e-06 0.000 2.57700e-06 0.000 2.57705e-06 1.800 2.58000e-06 1.800 2.58005e-06 0.000 2.58600e-06 0.000
+ 2.58605e-06 1.800 2.58900e-06 1.800 2.58905e-06 0.000 2.59800e-06 0.000 2.59805e-06 1.800 2.60400e-06 1.800
+ 2.60405e-06 0.000 2.60700e-06 0.000 2.60705e-06 1.800 2.62500e-06 1.800 2.62505e-06 0.000 2.63100e-06 0.000
+ 2.63105e-06 1.800 2.63400e-06 1.800 2.63405e-06 0.000 2.63700e-06 0.000 2.63705e-06 1.800 2.64000e-06 1.800
+ 2.64005e-06 0.000 2.64600e-06 0.000 2.64605e-06 1.800 2.66400e-06 1.800 2.66405e-06 0.000 2.66700e-06 0.000
+ 2.66705e-06 1.800 2.67000e-06 1.800 2.67005e-06 0.000 2.67300e-06 0.000 2.67305e-06 1.800 2.68800e-06 1.800
+ 2.68805e-06 0.000 2.70000e-06 0.000 2.70005e-06 1.800 2.70600e-06 1.800 2.70605e-06 0.000 2.70900e-06 0.000
+ 2.70905e-06 1.800 2.71200e-06 1.800 2.71205e-06 0.000 2.72400e-06 0.000 2.72405e-06 1.800 2.73300e-06 1.800
+ 2.73305e-06 0.000 2.73600e-06 0.000 2.73605e-06 1.800 2.74500e-06 1.800 2.74505e-06 0.000 2.75400e-06 0.000
+ 2.75405e-06 1.800 2.76000e-06 1.800 2.76005e-06 0.000 2.76300e-06 0.000 2.76305e-06 1.800 2.76600e-06 1.800
+ 2.76605e-06 0.000 2.76900e-06 0.000 2.76905e-06 1.800 2.78400e-06 1.800 2.78405e-06 0.000 2.79300e-06 0.000
+ 2.79305e-06 1.800 2.79600e-06 1.800 2.79605e-06 0.000 2.79900e-06 0.000 2.79905e-06 1.800 2.80500e-06 1.800
+ 2.80505e-06 0.000 2.81100e-06 0.000 2.81105e-06 1.800 2.81700e-06 1.800 2.81705e-06 0.000 2.82000e-06 0.000
+ 2.82005e-06 1.800 2.82300e-06 1.800 2.82305e-06 0.000 2.82600e-06 0.000 2.82605e-06 1.800 2.83500e-06 1.800
+ 2.83505e-06 0.000 2.85000e-06 0.000 2.85005e-06 1.800 2.85300e-06 1.800 2.85305e-06 0.000 2.85600e-06 0.000
+ 2.85605e-06 1.800 2.86200e-06 1.800 2.86205e-06 0.000 2.86500e-06 0.000 2.86505e-06 1.800 2.87100e-06 1.800
+ 2.87105e-06 0.000 2.87400e-06 0.000 2.87405e-06 1.800 2.88300e-06 1.800 2.88305e-06 0.000 2.89200e-06 0.000
+ 2.89205e-06 1.800 2.89500e-06 1.800 2.89505e-06 0.000 2.90400e-06 0.000 2.90405e-06 1.800 2.90700e-06 1.800
+ 2.90705e-06 0.000 2.91900e-06 0.000 2.91905e-06 1.800 2.92200e-06 1.800 2.92205e-06 0.000 2.92800e-06 0.000
+ 2.92805e-06 1.800 2.93100e-06 1.800 2.93105e-06 0.000 2.93400e-06 0.000 2.93405e-06 1.800 2.96100e-06 1.800
+ 2.96105e-06 0.000 2.96400e-06 0.000 2.96405e-06 1.800 2.96700e-06 1.800 2.96705e-06 0.000 2.98200e-06 0.000
+ 2.98205e-06 1.800 2.98500e-06 1.800 2.98505e-06 0.000 2.99100e-06 0.000 2.99105e-06 1.800 3.00000e-06 1.800
+ 3.00005e-06 0.000 3.00300e-06 0.000 3.00305e-06 1.800 3.00900e-06 1.800 3.00905e-06 0.000 3.01200e-06 0.000
+ 3.01205e-06 1.800 3.01800e-06 1.800 3.01805e-06 0.000 3.02700e-06 0.000 3.02705e-06 1.800 3.03600e-06 1.800
+ 3.03605e-06 0.000 3.04200e-06 0.000 3.04205e-06 1.800 3.04500e-06 1.800 3.04505e-06 0.000 3.05100e-06 0.000
+ 3.05105e-06 1.800 3.05400e-06 1.800 3.05405e-06 0.000 3.05700e-06 0.000 3.05705e-06 1.800 3.06300e-06 1.800
+ 3.06305e-06 0.000 3.06900e-06 0.000 3.06905e-06 1.800 3.07200e-06 1.800
+ )
Xd_a3 src_a3 a3 vdd gnd tb_inv
Vb0 src_b0 gnd PWL(
+ 0.00000e+00 1.800 4.80000e-08 1.800 4.80500e-08 0.000 9.60000e-08 0.000 9.60500e-08 1.800 1.44000e-07 1.800
+ 1.44050e-07 0.000 1.92000e-07 0.000 1.92050e-07 1.800 2.40000e-07 1.800 2.40050e-07 0.000 2.88000e-07 0.000
+ 2.88050e-07 1.800 3.36000e-07 1.800 3.36050e-07 0.000 3.84000e-07 0.000 3.84050e-07 1.800 4.32000e-07 1.800
+ 4.32050e-07 0.000 4.80000e-07 0.000 4.80050e-07 1.800 5.28000e-07 1.800 5.28050e-07 0.000 5.76000e-07 0.000
+ 5.76050e-07 1.800 6.24000e-07 1.800 6.24050e-07 0.000 6.72000e-07 0.000 6.72050e-07 1.800 7.20000e-07 1.800
+ 7.20050e-07 0.000 7.68000e-07 0.000 7.68050e-07 1.800 8.16000e-07 1.800 8.16050e-07 0.000 8.64000e-07 0.000
+ 8.64050e-07 1.800 9.12000e-07 1.800 9.12050e-07 0.000 9.60000e-07 0.000 9.60050e-07 1.800 1.00800e-06 1.800
+ 1.00805e-06 0.000 1.05600e-06 0.000 1.05605e-06 1.800 1.10400e-06 1.800 1.10405e-06 0.000 1.15200e-06 0.000
+ 1.15205e-06 1.800 1.20000e-06 1.800 1.20005e-06 0.000 1.24800e-06 0.000 1.24805e-06 1.800 1.29600e-06 1.800
+ 1.29605e-06 0.000 1.34400e-06 0.000 1.34405e-06 1.800 1.39200e-06 1.800 1.39205e-06 0.000 1.44000e-06 0.000
+ 1.44005e-06 1.800 1.48800e-06 1.800 1.48805e-06 0.000 1.54200e-06 0.000 1.54205e-06 1.800 1.54500e-06 1.800
+ 1.54505e-06 0.000 1.54800e-06 0.000 1.54805e-06 1.800 1.55100e-06 1.800 1.55105e-06 0.000 1.55400e-06 0.000
+ 1.55405e-06 1.800 1.55700e-06 1.800 1.55705e-06 0.000 1.56600e-06 0.000 1.56605e-06 1.800 1.57200e-06 1.800
+ 1.57205e-06 0.000 1.57500e-06 0.000 1.57505e-06 1.800 1.57800e-06 1.800 1.57805e-06 0.000 1.58400e-06 0.000
+ 1.58405e-06 1.800 1.58700e-06 1.800 1.58705e-06 0.000 1.59300e-06 0.000 1.59305e-06 1.800 1.60200e-06 1.800
+ 1.60205e-06 0.000 1.60500e-06 0.000 1.60505e-06 1.800 1.62000e-06 1.800 1.62005e-06 0.000 1.62600e-06 0.000
+ 1.62605e-06 1.800 1.63500e-06 1.800 1.63505e-06 0.000 1.64100e-06 0.000 1.64105e-06 1.800 1.64400e-06 1.800
+ 1.64405e-06 0.000 1.65000e-06 0.000 1.65005e-06 1.800 1.65300e-06 1.800 1.65305e-06 0.000 1.65600e-06 0.000
+ 1.65605e-06 1.800 1.65900e-06 1.800 1.65905e-06 0.000 1.66800e-06 0.000 1.66805e-06 1.800 1.68600e-06 1.800
+ 1.68605e-06 0.000 1.68900e-06 0.000 1.68905e-06 1.800 1.69500e-06 1.800 1.69505e-06 0.000 1.69800e-06 0.000
+ 1.69805e-06 1.800 1.70100e-06 1.800 1.70105e-06 0.000 1.71600e-06 0.000 1.71605e-06 1.800 1.71900e-06 1.800
+ 1.71905e-06 0.000 1.72200e-06 0.000 1.72205e-06 1.800 1.72500e-06 1.800 1.72505e-06 0.000 1.72800e-06 0.000
+ 1.72805e-06 1.800 1.73100e-06 1.800 1.73105e-06 0.000 1.73400e-06 0.000 1.73405e-06 1.800 1.73700e-06 1.800
+ 1.73705e-06 0.000 1.74000e-06 0.000 1.74005e-06 1.800 1.75200e-06 1.800 1.75205e-06 0.000 1.75500e-06 0.000
+ 1.75505e-06 1.800 1.75800e-06 1.800 1.75805e-06 0.000 1.76700e-06 0.000 1.76705e-06 1.800 1.78500e-06 1.800
+ 1.78505e-06 0.000 1.78800e-06 0.000 1.78805e-06 1.800 1.79100e-06 1.800 1.79105e-06 0.000 1.79400e-06 0.000
+ 1.79405e-06 1.800 1.79700e-06 1.800 1.79705e-06 0.000 1.80000e-06 0.000 1.80005e-06 1.800 1.80300e-06 1.800
+ 1.80305e-06 0.000 1.80600e-06 0.000 1.80605e-06 1.800 1.80900e-06 1.800 1.80905e-06 0.000 1.81800e-06 0.000
+ 1.81805e-06 1.800 1.82100e-06 1.800 1.82105e-06 0.000 1.82400e-06 0.000 1.82405e-06 1.800 1.82700e-06 1.800
+ 1.82705e-06 0.000 1.83000e-06 0.000 1.83005e-06 1.800 1.84500e-06 1.800 1.84505e-06 0.000 1.84800e-06 0.000
+ 1.84805e-06 1.800 1.85400e-06 1.800 1.85405e-06 0.000 1.86300e-06 0.000 1.86305e-06 1.800 1.86900e-06 1.800
+ 1.86905e-06 0.000 1.87200e-06 0.000 1.87205e-06 1.800 1.88400e-06 1.800 1.88405e-06 0.000 1.88700e-06 0.000
+ 1.88705e-06 1.800 1.89000e-06 1.800 1.89005e-06 0.000 1.90200e-06 0.000 1.90205e-06 1.800 1.90500e-06 1.800
+ 1.90505e-06 0.000 1.90800e-06 0.000 1.90805e-06 1.800 1.91100e-06 1.800 1.91105e-06 0.000 1.91400e-06 0.000
+ 1.91405e-06 1.800 1.92300e-06 1.800 1.92305e-06 0.000 1.92600e-06 0.000 1.92605e-06 1.800 1.92900e-06 1.800
+ 1.92905e-06 0.000 1.93200e-06 0.000 1.93205e-06 1.800 1.93800e-06 1.800 1.93805e-06 0.000 1.94400e-06 0.000
+ 1.94405e-06 1.800 1.95000e-06 1.800 1.95005e-06 0.000 1.95600e-06 0.000 1.95605e-06 1.800 1.95900e-06 1.800
+ 1.95905e-06 0.000 1.96200e-06 0.000 1.96205e-06 1.800 1.96500e-06 1.800 1.96505e-06 0.000 1.97400e-06 0.000
+ 1.97405e-06 1.800 1.97700e-06 1.800 1.97705e-06 0.000 1.98600e-06 0.000 1.98605e-06 1.800 1.98900e-06 1.800
+ 1.98905e-06 0.000 1.99500e-06 0.000 1.99505e-06 1.800 1.99800e-06 1.800 1.99805e-06 0.000 2.00100e-06 0.000
+ 2.00105e-06 1.800 2.00700e-06 1.800 2.00705e-06 0.000 2.01000e-06 0.000 2.01005e-06 1.800 2.02500e-06 1.800
+ 2.02505e-06 0.000 2.02800e-06 0.000 2.02805e-06 1.800 2.03400e-06 1.800 2.03405e-06 0.000 2.04900e-06 0.000
+ 2.04905e-06 1.800 2.05200e-06 1.800 2.05205e-06 0.000 2.06100e-06 0.000 2.06105e-06 1.800 2.06700e-06 1.800
+ 2.06705e-06 0.000 2.07600e-06 0.000 2.07605e-06 1.800 2.07900e-06 1.800 2.07905e-06 0.000 2.08800e-06 0.000
+ 2.08805e-06 1.800 2.09400e-06 1.800 2.09405e-06 0.000 2.10300e-06 0.000 2.10305e-06 1.800 2.10600e-06 1.800
+ 2.10605e-06 0.000 2.10900e-06 0.000 2.10905e-06 1.800 2.11800e-06 1.800 2.11805e-06 0.000 2.12100e-06 0.000
+ 2.12105e-06 1.800 2.13900e-06 1.800 2.13905e-06 0.000 2.14200e-06 0.000 2.14205e-06 1.800 2.14500e-06 1.800
+ 2.14505e-06 0.000 2.14800e-06 0.000 2.14805e-06 1.800 2.15400e-06 1.800 2.15405e-06 0.000 2.16000e-06 0.000
+ 2.16005e-06 1.800 2.17500e-06 1.800 2.17505e-06 0.000 2.17800e-06 0.000 2.17805e-06 1.800 2.18100e-06 1.800
+ 2.18105e-06 0.000 2.19000e-06 0.000 2.19005e-06 1.800 2.19900e-06 1.800 2.19905e-06 0.000 2.21100e-06 0.000
+ 2.21105e-06 1.800 2.21400e-06 1.800 2.21405e-06 0.000 2.21700e-06 0.000 2.21705e-06 1.800 2.22000e-06 1.800
+ 2.22005e-06 0.000 2.23500e-06 0.000 2.23505e-06 1.800 2.24100e-06 1.800 2.24105e-06 0.000 2.24400e-06 0.000
+ 2.24405e-06 1.800 2.24700e-06 1.800 2.24705e-06 0.000 2.25000e-06 0.000 2.25005e-06 1.800 2.25600e-06 1.800
+ 2.25605e-06 0.000 2.26200e-06 0.000 2.26205e-06 1.800 2.26500e-06 1.800 2.26505e-06 0.000 2.26800e-06 0.000
+ 2.26805e-06 1.800 2.27100e-06 1.800 2.27105e-06 0.000 2.29500e-06 0.000 2.29505e-06 1.800 2.30400e-06 1.800
+ 2.30405e-06 0.000 2.31000e-06 0.000 2.31005e-06 1.800 2.31300e-06 1.800 2.31305e-06 0.000 2.31600e-06 0.000
+ 2.31605e-06 1.800 2.32200e-06 1.800 2.32205e-06 0.000 2.32800e-06 0.000 2.32805e-06 1.800 2.33400e-06 1.800
+ 2.33405e-06 0.000 2.34600e-06 0.000 2.34605e-06 1.800 2.35500e-06 1.800 2.35505e-06 0.000 2.36100e-06 0.000
+ 2.36105e-06 1.800 2.36400e-06 1.800 2.36405e-06 0.000 2.36700e-06 0.000 2.36705e-06 1.800 2.37600e-06 1.800
+ 2.37605e-06 0.000 2.38200e-06 0.000 2.38205e-06 1.800 2.39100e-06 1.800 2.39105e-06 0.000 2.39400e-06 0.000
+ 2.39405e-06 1.800 2.40000e-06 1.800 2.40005e-06 0.000 2.40300e-06 0.000 2.40305e-06 1.800 2.41800e-06 1.800
+ 2.41805e-06 0.000 2.42100e-06 0.000 2.42105e-06 1.800 2.42700e-06 1.800 2.42705e-06 0.000 2.43000e-06 0.000
+ 2.43005e-06 1.800 2.43300e-06 1.800 2.43305e-06 0.000 2.44200e-06 0.000 2.44205e-06 1.800 2.44800e-06 1.800
+ 2.44805e-06 0.000 2.45100e-06 0.000 2.45105e-06 1.800 2.45700e-06 1.800 2.45705e-06 0.000 2.46900e-06 0.000
+ 2.46905e-06 1.800 2.47500e-06 1.800 2.47505e-06 0.000 2.48400e-06 0.000 2.48405e-06 1.800 2.48700e-06 1.800
+ 2.48705e-06 0.000 2.49000e-06 0.000 2.49005e-06 1.800 2.50800e-06 1.800 2.50805e-06 0.000 2.51700e-06 0.000
+ 2.51705e-06 1.800 2.52000e-06 1.800 2.52005e-06 0.000 2.52300e-06 0.000 2.52305e-06 1.800 2.52600e-06 1.800
+ 2.52605e-06 0.000 2.53200e-06 0.000 2.53205e-06 1.800 2.53500e-06 1.800 2.53505e-06 0.000 2.53800e-06 0.000
+ 2.53805e-06 1.800 2.54100e-06 1.800 2.54105e-06 0.000 2.54400e-06 0.000 2.54405e-06 1.800 2.55000e-06 1.800
+ 2.55005e-06 0.000 2.55600e-06 0.000 2.55605e-06 1.800 2.55900e-06 1.800 2.55905e-06 0.000 2.56200e-06 0.000
+ 2.56205e-06 1.800 2.56500e-06 1.800 2.56505e-06 0.000 2.58000e-06 0.000 2.58005e-06 1.800 2.58300e-06 1.800
+ 2.58305e-06 0.000 2.58600e-06 0.000 2.58605e-06 1.800 2.58900e-06 1.800 2.58905e-06 0.000 2.60400e-06 0.000
+ 2.60405e-06 1.800 2.60700e-06 1.800 2.60705e-06 0.000 2.61000e-06 0.000 2.61005e-06 1.800 2.62800e-06 1.800
+ 2.62805e-06 0.000 2.63700e-06 0.000 2.63705e-06 1.800 2.64000e-06 1.800 2.64005e-06 0.000 2.64300e-06 0.000
+ 2.64305e-06 1.800 2.65800e-06 1.800 2.65805e-06 0.000 2.66400e-06 0.000 2.66405e-06 1.800 2.67000e-06 1.800
+ 2.67005e-06 0.000 2.67300e-06 0.000 2.67305e-06 1.800 2.67600e-06 1.800 2.67605e-06 0.000 2.68200e-06 0.000
+ 2.68205e-06 1.800 2.69400e-06 1.800 2.69405e-06 0.000 2.69700e-06 0.000 2.69705e-06 1.800 2.70000e-06 1.800
+ 2.70005e-06 0.000 2.72100e-06 0.000 2.72105e-06 1.800 2.72700e-06 1.800 2.72705e-06 0.000 2.73000e-06 0.000
+ 2.73005e-06 1.800 2.73300e-06 1.800 2.73305e-06 0.000 2.73600e-06 0.000 2.73605e-06 1.800 2.73900e-06 1.800
+ 2.73905e-06 0.000 2.74200e-06 0.000 2.74205e-06 1.800 2.74800e-06 1.800 2.74805e-06 0.000 2.75700e-06 0.000
+ 2.75705e-06 1.800 2.76300e-06 1.800 2.76305e-06 0.000 2.77800e-06 0.000 2.77805e-06 1.800 2.78100e-06 1.800
+ 2.78105e-06 0.000 2.79600e-06 0.000 2.79605e-06 1.800 2.80500e-06 1.800 2.80505e-06 0.000 2.80800e-06 0.000
+ 2.80805e-06 1.800 2.81100e-06 1.800 2.81105e-06 0.000 2.81700e-06 0.000 2.81705e-06 1.800 2.82000e-06 1.800
+ 2.82005e-06 0.000 2.82300e-06 0.000 2.82305e-06 1.800 2.82900e-06 1.800 2.82905e-06 0.000 2.83200e-06 0.000
+ 2.83205e-06 1.800 2.84400e-06 1.800 2.84405e-06 0.000 2.85600e-06 0.000 2.85605e-06 1.800 2.85900e-06 1.800
+ 2.85905e-06 0.000 2.86500e-06 0.000 2.86505e-06 1.800 2.86800e-06 1.800 2.86805e-06 0.000 2.87100e-06 0.000
+ 2.87105e-06 1.800 2.87400e-06 1.800 2.87405e-06 0.000 2.88300e-06 0.000 2.88305e-06 1.800 2.88600e-06 1.800
+ 2.88605e-06 0.000 2.91000e-06 0.000 2.91005e-06 1.800 2.91300e-06 1.800 2.91305e-06 0.000 2.91900e-06 0.000
+ 2.91905e-06 1.800 2.92500e-06 1.800 2.92505e-06 0.000 2.93100e-06 0.000 2.93105e-06 1.800 2.93400e-06 1.800
+ 2.93405e-06 0.000 2.93700e-06 0.000 2.93705e-06 1.800 2.94600e-06 1.800 2.94605e-06 0.000 2.94900e-06 0.000
+ 2.94905e-06 1.800 2.96700e-06 1.800 2.96705e-06 0.000 2.97000e-06 0.000 2.97005e-06 1.800 2.97300e-06 1.800
+ 2.97305e-06 0.000 2.98200e-06 0.000 2.98205e-06 1.800 3.00000e-06 1.800 3.00005e-06 0.000 3.00600e-06 0.000
+ 3.00605e-06 1.800 3.01800e-06 1.800 3.01805e-06 0.000 3.02400e-06 0.000 3.02405e-06 1.800 3.02700e-06 1.800
+ 3.02705e-06 0.000 3.03000e-06 0.000 3.03005e-06 1.800 3.03600e-06 1.800 3.03605e-06 0.000 3.03900e-06 0.000
+ 3.03905e-06 1.800 3.04500e-06 1.800 3.04505e-06 0.000 3.05100e-06 0.000 3.05105e-06 1.800 3.06000e-06 1.800
+ 3.06005e-06 0.000 3.06600e-06 0.000 3.06605e-06 1.800 3.07200e-06 1.800
+ )
Xd_b0 src_b0 b0 vdd gnd tb_inv
Vb1 src_b1 gnd PWL(
+ 0.00000e+00 1.800 2.40000e-08 1.800 2.40500e-08 0.000 4.80000e-08 0.000 4.80500e-08 1.800 7.20000e-08 1.800
+ 7.20500e-08 0.000 9.60000e-08 0.000 9.60500e-08 1.800 1.20000e-07 1.800 1.20050e-07 0.000 1.44000e-07 0.000
+ 1.44050e-07 1.800 1.68000e-07 1.800 1.68050e-07 0.000 1.92000e-07 0.000 1.92050e-07 1.800 2.16000e-07 1.800
+ 2.16050e-07 0.000 2.40000e-07 0.000 2.40050e-07 1.800 2.64000e-07 1.800 2.64050e-07 0.000 2.88000e-07 0.000
+ 2.88050e-07 1.800 3.12000e-07 1.800 3.12050e-07 0.000 3.36000e-07 0.000 3.36050e-07 1.800 3.60000e-07 1.800
+ 3.60050e-07 0.000 3.84000e-07 0.000 3.84050e-07 1.800 4.08000e-07 1.800 4.08050e-07 0.000 4.32000e-07 0.000
+ 4.32050e-07 1.800 4.56000e-07 1.800 4.56050e-07 0.000 4.80000e-07 0.000 4.80050e-07 1.800 5.04000e-07 1.800
+ 5.04050e-07 0.000 5.28000e-07 0.000 5.28050e-07 1.800 5.52000e-07 1.800 5.52050e-07 0.000 5.76000e-07 0.000
+ 5.76050e-07 1.800 6.00000e-07 1.800 6.00050e-07 0.000 6.24000e-07 0.000 6.24050e-07 1.800 6.48000e-07 1.800
+ 6.48050e-07 0.000 6.72000e-07 0.000 6.72050e-07 1.800 6.96000e-07 1.800 6.96050e-07 0.000 7.20000e-07 0.000
+ 7.20050e-07 1.800 7.44000e-07 1.800 7.44050e-07 0.000 7.68000e-07 0.000 7.68050e-07 1.800 7.92000e-07 1.800
+ 7.92050e-07 0.000 8.16000e-07 0.000 8.16050e-07 1.800 8.40000e-07 1.800 8.40050e-07 0.000 8.64000e-07 0.000
+ 8.64050e-07 1.800 8.88000e-07 1.800 8.88050e-07 0.000 9.12000e-07 0.000 9.12050e-07 1.800 9.36000e-07 1.800
+ 9.36050e-07 0.000 9.60000e-07 0.000 9.60050e-07 1.800 9.84000e-07 1.800 9.84050e-07 0.000 1.00800e-06 0.000
+ 1.00805e-06 1.800 1.03200e-06 1.800 1.03205e-06 0.000 1.05600e-06 0.000 1.05605e-06 1.800 1.08000e-06 1.800
+ 1.08005e-06 0.000 1.10400e-06 0.000 1.10405e-06 1.800 1.12800e-06 1.800 1.12805e-06 0.000 1.15200e-06 0.000
+ 1.15205e-06 1.800 1.17600e-06 1.800 1.17605e-06 0.000 1.20000e-06 0.000 1.20005e-06 1.800 1.22400e-06 1.800
+ 1.22405e-06 0.000 1.24800e-06 0.000 1.24805e-06 1.800 1.27200e-06 1.800 1.27205e-06 0.000 1.29600e-06 0.000
+ 1.29605e-06 1.800 1.32000e-06 1.800 1.32005e-06 0.000 1.34400e-06 0.000 1.34405e-06 1.800 1.36800e-06 1.800
+ 1.36805e-06 0.000 1.39200e-06 0.000 1.39205e-06 1.800 1.41600e-06 1.800 1.41605e-06 0.000 1.44000e-06 0.000
+ 1.44005e-06 1.800 1.46400e-06 1.800 1.46405e-06 0.000 1.48800e-06 0.000 1.48805e-06 1.800 1.51200e-06 1.800
+ 1.51205e-06 0.000 1.53600e-06 0.000 1.53605e-06 1.800 1.53900e-06 1.800 1.53905e-06 0.000 1.54200e-06 0.000
+ 1.54205e-06 1.800 1.54800e-06 1.800 1.54805e-06 0.000 1.55100e-06 0.000 1.55105e-06 1.800 1.56300e-06 1.800
+ 1.56305e-06 0.000 1.56600e-06 0.000 1.56605e-06 1.800 1.57200e-06 1.800 1.57205e-06 0.000 1.58100e-06 0.000
+ 1.58105e-06 1.800 1.58400e-06 1.800 1.58405e-06 0.000 1.58700e-06 0.000 1.58705e-06 1.800 1.60800e-06 1.800
+ 1.60805e-06 0.000 1.61100e-06 0.000 1.61105e-06 1.800 1.61400e-06 1.800 1.61405e-06 0.000 1.61700e-06 0.000
+ 1.61705e-06 1.800 1.62300e-06 1.800 1.62305e-06 0.000 1.62900e-06 0.000 1.62905e-06 1.800 1.64400e-06 1.800
+ 1.64405e-06 0.000 1.65000e-06 0.000 1.65005e-06 1.800 1.65600e-06 1.800 1.65605e-06 0.000 1.65900e-06 0.000
+ 1.65905e-06 1.800 1.66200e-06 1.800 1.66205e-06 0.000 1.66500e-06 0.000 1.66505e-06 1.800 1.68000e-06 1.800
+ 1.68005e-06 0.000 1.68300e-06 0.000 1.68305e-06 1.800 1.69200e-06 1.800 1.69205e-06 0.000 1.69800e-06 0.000
+ 1.69805e-06 1.800 1.70700e-06 1.800 1.70705e-06 0.000 1.72200e-06 0.000 1.72205e-06 1.800 1.72500e-06 1.800
+ 1.72505e-06 0.000 1.72800e-06 0.000 1.72805e-06 1.800 1.73100e-06 1.800 1.73105e-06 0.000 1.73400e-06 0.000
+ 1.73405e-06 1.800 1.74000e-06 1.800 1.74005e-06 0.000 1.74600e-06 0.000 1.74605e-06 1.800 1.75200e-06 1.800
+ 1.75205e-06 0.000 1.75500e-06 0.000 1.75505e-06 1.800 1.76100e-06 1.800 1.76105e-06 0.000 1.76700e-06 0.000
+ 1.76705e-06 1.800 1.77300e-06 1.800 1.77305e-06 0.000 1.77600e-06 0.000 1.77605e-06 1.800 1.77900e-06 1.800
+ 1.77905e-06 0.000 1.78500e-06 0.000 1.78505e-06 1.800 1.78800e-06 1.800 1.78805e-06 0.000 1.79700e-06 0.000
+ 1.79705e-06 1.800 1.80000e-06 1.800 1.80005e-06 0.000 1.80600e-06 0.000 1.80605e-06 1.800 1.81200e-06 1.800
+ 1.81205e-06 0.000 1.81500e-06 0.000 1.81505e-06 1.800 1.81800e-06 1.800 1.81805e-06 0.000 1.82100e-06 0.000
+ 1.82105e-06 1.800 1.82400e-06 1.800 1.82405e-06 0.000 1.83300e-06 0.000 1.83305e-06 1.800 1.84200e-06 1.800
+ 1.84205e-06 0.000 1.84500e-06 0.000 1.84505e-06 1.800 1.84800e-06 1.800 1.84805e-06 0.000 1.85400e-06 0.000
+ 1.85405e-06 1.800 1.85700e-06 1.800 1.85705e-06 0.000 1.86300e-06 0.000 1.86305e-06 1.800 1.86600e-06 1.800
+ 1.86605e-06 0.000 1.86900e-06 0.000 1.86905e-06 1.800 1.88100e-06 1.800 1.88105e-06 0.000 1.88700e-06 0.000
+ 1.88705e-06 1.800 1.89000e-06 1.800 1.89005e-06 0.000 1.89300e-06 0.000 1.89305e-06 1.800 1.89600e-06 1.800
+ 1.89605e-06 0.000 1.89900e-06 0.000 1.89905e-06 1.800 1.90200e-06 1.800 1.90205e-06 0.000 1.90500e-06 0.000
+ 1.90505e-06 1.800 1.91400e-06 1.800 1.91405e-06 0.000 1.92000e-06 0.000 1.92005e-06 1.800 1.92600e-06 1.800
+ 1.92605e-06 0.000 1.93500e-06 0.000 1.93505e-06 1.800 1.94100e-06 1.800 1.94105e-06 0.000 1.94400e-06 0.000
+ 1.94405e-06 1.800 1.95000e-06 1.800 1.95005e-06 0.000 1.95600e-06 0.000 1.95605e-06 1.800 1.96200e-06 1.800
+ 1.96205e-06 0.000 1.96500e-06 0.000 1.96505e-06 1.800 1.96800e-06 1.800 1.96805e-06 0.000 1.97700e-06 0.000
+ 1.97705e-06 1.800 1.98000e-06 1.800 1.98005e-06 0.000 1.98900e-06 0.000 1.98905e-06 1.800 1.99500e-06 1.800
+ 1.99505e-06 0.000 1.99800e-06 0.000 1.99805e-06 1.800 2.00100e-06 1.800 2.00105e-06 0.000 2.01000e-06 0.000
+ 2.01005e-06 1.800 2.01600e-06 1.800 2.01605e-06 0.000 2.02200e-06 0.000 2.02205e-06 1.800 2.02500e-06 1.800
+ 2.02505e-06 0.000 2.04900e-06 0.000 2.04905e-06 1.800 2.05200e-06 1.800 2.05205e-06 0.000 2.06100e-06 0.000
+ 2.06105e-06 1.800 2.07000e-06 1.800 2.07005e-06 0.000 2.07300e-06 0.000 2.07305e-06 1.800 2.07600e-06 1.800
+ 2.07605e-06 0.000 2.09400e-06 0.000 2.09405e-06 1.800 2.09700e-06 1.800 2.09705e-06 0.000 2.10300e-06 0.000
+ 2.10305e-06 1.800 2.10600e-06 1.800 2.10605e-06 0.000 2.10900e-06 0.000 2.10905e-06 1.800 2.12400e-06 1.800
+ 2.12405e-06 0.000 2.13300e-06 0.000 2.13305e-06 1.800 2.14200e-06 1.800 2.14205e-06 0.000 2.14500e-06 0.000
+ 2.14505e-06 1.800 2.15100e-06 1.800 2.15105e-06 0.000 2.15400e-06 0.000 2.15405e-06 1.800 2.16600e-06 1.800
+ 2.16605e-06 0.000 2.17800e-06 0.000 2.17805e-06 1.800 2.18700e-06 1.800 2.18705e-06 0.000 2.19000e-06 0.000
+ 2.19005e-06 1.800 2.19300e-06 1.800 2.19305e-06 0.000 2.19600e-06 0.000 2.19605e-06 1.800 2.20200e-06 1.800
+ 2.20205e-06 0.000 2.20800e-06 0.000 2.20805e-06 1.800 2.21700e-06 1.800 2.21705e-06 0.000 2.22000e-06 0.000
+ 2.22005e-06 1.800 2.22300e-06 1.800 2.22305e-06 0.000 2.23500e-06 0.000 2.23505e-06 1.800 2.23800e-06 1.800
+ 2.23805e-06 0.000 2.24100e-06 0.000 2.24105e-06 1.800 2.24400e-06 1.800 2.24405e-06 0.000 2.24700e-06 0.000
+ 2.24705e-06 1.800 2.25000e-06 1.800 2.25005e-06 0.000 2.25300e-06 0.000 2.25305e-06 1.800 2.25600e-06 1.800
+ 2.25605e-06 0.000 2.26500e-06 0.000 2.26505e-06 1.800 2.26800e-06 1.800 2.26805e-06 0.000 2.27100e-06 0.000
+ 2.27105e-06 1.800 2.28300e-06 1.800 2.28305e-06 0.000 2.28900e-06 0.000 2.28905e-06 1.800 2.29200e-06 1.800
+ 2.29205e-06 0.000 2.29800e-06 0.000 2.29805e-06 1.800 2.30400e-06 1.800 2.30405e-06 0.000 2.30700e-06 0.000
+ 2.30705e-06 1.800 2.31000e-06 1.800 2.31005e-06 0.000 2.31600e-06 0.000 2.31605e-06 1.800 2.32200e-06 1.800
+ 2.32205e-06 0.000 2.33100e-06 0.000 2.33105e-06 1.800 2.33400e-06 1.800 2.33405e-06 0.000 2.34000e-06 0.000
+ 2.34005e-06 1.800 2.34300e-06 1.800 2.34305e-06 0.000 2.35500e-06 0.000 2.35505e-06 1.800 2.36100e-06 1.800
+ 2.36105e-06 0.000 2.36400e-06 0.000 2.36405e-06 1.800 2.37000e-06 1.800 2.37005e-06 0.000 2.37300e-06 0.000
+ 2.37305e-06 1.800 2.38200e-06 1.800 2.38205e-06 0.000 2.39100e-06 0.000 2.39105e-06 1.800 2.39400e-06 1.800
+ 2.39405e-06 0.000 2.40000e-06 0.000 2.40005e-06 1.800 2.40900e-06 1.800 2.40905e-06 0.000 2.41200e-06 0.000
+ 2.41205e-06 1.800 2.42100e-06 1.800 2.42105e-06 0.000 2.42400e-06 0.000 2.42405e-06 1.800 2.42700e-06 1.800
+ 2.42705e-06 0.000 2.43600e-06 0.000 2.43605e-06 1.800 2.43900e-06 1.800 2.43905e-06 0.000 2.44200e-06 0.000
+ 2.44205e-06 1.800 2.44500e-06 1.800 2.44505e-06 0.000 2.44800e-06 0.000 2.44805e-06 1.800 2.45100e-06 1.800
+ 2.45105e-06 0.000 2.45400e-06 0.000 2.45405e-06 1.800 2.45700e-06 1.800 2.45705e-06 0.000 2.46000e-06 0.000
+ 2.46005e-06 1.800 2.47800e-06 1.800 2.47805e-06 0.000 2.49300e-06 0.000 2.49305e-06 1.800 2.49900e-06 1.800
+ 2.49905e-06 0.000 2.50500e-06 0.000 2.50505e-06 1.800 2.51100e-06 1.800 2.51105e-06 0.000 2.53200e-06 0.000
+ 2.53205e-06 1.800 2.53500e-06 1.800 2.53505e-06 0.000 2.54100e-06 0.000 2.54105e-06 1.800 2.54400e-06 1.800
+ 2.54405e-06 0.000 2.55600e-06 0.000 2.55605e-06 1.800 2.56800e-06 1.800 2.56805e-06 0.000 2.57100e-06 0.000
+ 2.57105e-06 1.800 2.57400e-06 1.800 2.57405e-06 0.000 2.57700e-06 0.000 2.57705e-06 1.800 2.58300e-06 1.800
+ 2.58305e-06 0.000 2.59500e-06 0.000 2.59505e-06 1.800 2.59800e-06 1.800 2.59805e-06 0.000 2.61300e-06 0.000
+ 2.61305e-06 1.800 2.62500e-06 1.800 2.62505e-06 0.000 2.62800e-06 0.000 2.62805e-06 1.800 2.63400e-06 1.800
+ 2.63405e-06 0.000 2.63700e-06 0.000 2.63705e-06 1.800 2.65200e-06 1.800 2.65205e-06 0.000 2.65500e-06 0.000
+ 2.65505e-06 1.800 2.65800e-06 1.800 2.65805e-06 0.000 2.66100e-06 0.000 2.66105e-06 1.800 2.68200e-06 1.800
+ 2.68205e-06 0.000 2.70300e-06 0.000 2.70305e-06 1.800 2.70900e-06 1.800 2.70905e-06 0.000 2.71200e-06 0.000
+ 2.71205e-06 1.800 2.71500e-06 1.800 2.71505e-06 0.000 2.72100e-06 0.000 2.72105e-06 1.800 2.72400e-06 1.800
+ 2.72405e-06 0.000 2.72700e-06 0.000 2.72705e-06 1.800 2.73000e-06 1.800 2.73005e-06 0.000 2.73300e-06 0.000
+ 2.73305e-06 1.800 2.74200e-06 1.800 2.74205e-06 0.000 2.76000e-06 0.000 2.76005e-06 1.800 2.76300e-06 1.800
+ 2.76305e-06 0.000 2.77200e-06 0.000 2.77205e-06 1.800 2.77800e-06 1.800 2.77805e-06 0.000 2.78400e-06 0.000
+ 2.78405e-06 1.800 2.78700e-06 1.800 2.78705e-06 0.000 2.79000e-06 0.000 2.79005e-06 1.800 2.79600e-06 1.800
+ 2.79605e-06 0.000 2.80200e-06 0.000 2.80205e-06 1.800 2.80500e-06 1.800 2.80505e-06 0.000 2.81100e-06 0.000
+ 2.81105e-06 1.800 2.81400e-06 1.800 2.81405e-06 0.000 2.81700e-06 0.000 2.81705e-06 1.800 2.82300e-06 1.800
+ 2.82305e-06 0.000 2.82600e-06 0.000 2.82605e-06 1.800 2.83500e-06 1.800 2.83505e-06 0.000 2.83800e-06 0.000
+ 2.83805e-06 1.800 2.84100e-06 1.800 2.84105e-06 0.000 2.85000e-06 0.000 2.85005e-06 1.800 2.85900e-06 1.800
+ 2.85905e-06 0.000 2.86200e-06 0.000 2.86205e-06 1.800 2.86500e-06 1.800 2.86505e-06 0.000 2.87400e-06 0.000
+ 2.87405e-06 1.800 2.87700e-06 1.800 2.87705e-06 0.000 2.88000e-06 0.000 2.88005e-06 1.800 2.88300e-06 1.800
+ 2.88305e-06 0.000 2.88600e-06 0.000 2.88605e-06 1.800 2.89200e-06 1.800 2.89205e-06 0.000 2.89500e-06 0.000
+ 2.89505e-06 1.800 2.90400e-06 1.800 2.90405e-06 0.000 2.90700e-06 0.000 2.90705e-06 1.800 2.91300e-06 1.800
+ 2.91305e-06 0.000 2.91600e-06 0.000 2.91605e-06 1.800 2.91900e-06 1.800 2.91905e-06 0.000 2.92500e-06 0.000
+ 2.92505e-06 1.800 2.92800e-06 1.800 2.92805e-06 0.000 2.93700e-06 0.000 2.93705e-06 1.800 2.94900e-06 1.800
+ 2.94905e-06 0.000 2.96100e-06 0.000 2.96105e-06 1.800 2.96400e-06 1.800 2.96405e-06 0.000 2.96700e-06 0.000
+ 2.96705e-06 1.800 2.97000e-06 1.800 2.97005e-06 0.000 2.97300e-06 0.000 2.97305e-06 1.800 2.97600e-06 1.800
+ 2.97605e-06 0.000 2.97900e-06 0.000 2.97905e-06 1.800 2.98200e-06 1.800 2.98205e-06 0.000 2.98500e-06 0.000
+ 2.98505e-06 1.800 2.99400e-06 1.800 2.99405e-06 0.000 2.99700e-06 0.000 2.99705e-06 1.800 3.00300e-06 1.800
+ 3.00305e-06 0.000 3.00600e-06 0.000 3.00605e-06 1.800 3.00900e-06 1.800 3.00905e-06 0.000 3.02100e-06 0.000
+ 3.02105e-06 1.800 3.02400e-06 1.800 3.02405e-06 0.000 3.02700e-06 0.000 3.02705e-06 1.800 3.03300e-06 1.800
+ 3.03305e-06 0.000 3.03600e-06 0.000 3.03605e-06 1.800 3.04500e-06 1.800 3.04505e-06 0.000 3.05100e-06 0.000
+ 3.05105e-06 1.800 3.06000e-06 1.800 3.06005e-06 0.000 3.06300e-06 0.000 3.06305e-06 1.800 3.06900e-06 1.800
+ 3.06905e-06 0.000 3.07200e-06 0.000
+ )
Xd_b1 src_b1 b1 vdd gnd tb_inv
Vb2 src_b2 gnd PWL(
+ 0.00000e+00 1.800 1.20000e-08 1.800 1.20500e-08 0.000 2.40000e-08 0.000 2.40500e-08 1.800 3.60000e-08 1.800
+ 3.60500e-08 0.000 4.80000e-08 0.000 4.80500e-08 1.800 6.00000e-08 1.800 6.00500e-08 0.000 7.20000e-08 0.000
+ 7.20500e-08 1.800 8.40000e-08 1.800 8.40500e-08 0.000 9.60000e-08 0.000 9.60500e-08 1.800 1.08000e-07 1.800
+ 1.08050e-07 0.000 1.20000e-07 0.000 1.20050e-07 1.800 1.32000e-07 1.800 1.32050e-07 0.000 1.44000e-07 0.000
+ 1.44050e-07 1.800 1.56000e-07 1.800 1.56050e-07 0.000 1.68000e-07 0.000 1.68050e-07 1.800 1.80000e-07 1.800
+ 1.80050e-07 0.000 1.92000e-07 0.000 1.92050e-07 1.800 2.04000e-07 1.800 2.04050e-07 0.000 2.16000e-07 0.000
+ 2.16050e-07 1.800 2.28000e-07 1.800 2.28050e-07 0.000 2.40000e-07 0.000 2.40050e-07 1.800 2.52000e-07 1.800
+ 2.52050e-07 0.000 2.64000e-07 0.000 2.64050e-07 1.800 2.76000e-07 1.800 2.76050e-07 0.000 2.88000e-07 0.000
+ 2.88050e-07 1.800 3.00000e-07 1.800 3.00050e-07 0.000 3.12000e-07 0.000 3.12050e-07 1.800 3.24000e-07 1.800
+ 3.24050e-07 0.000 3.36000e-07 0.000 3.36050e-07 1.800 3.48000e-07 1.800 3.48050e-07 0.000 3.60000e-07 0.000
+ 3.60050e-07 1.800 3.72000e-07 1.800 3.72050e-07 0.000 3.84000e-07 0.000 3.84050e-07 1.800 3.96000e-07 1.800
+ 3.96050e-07 0.000 4.08000e-07 0.000 4.08050e-07 1.800 4.20000e-07 1.800 4.20050e-07 0.000 4.32000e-07 0.000
+ 4.32050e-07 1.800 4.44000e-07 1.800 4.44050e-07 0.000 4.56000e-07 0.000 4.56050e-07 1.800 4.68000e-07 1.800
+ 4.68050e-07 0.000 4.80000e-07 0.000 4.80050e-07 1.800 4.92000e-07 1.800 4.92050e-07 0.000 5.04000e-07 0.000
+ 5.04050e-07 1.800 5.16000e-07 1.800 5.16050e-07 0.000 5.28000e-07 0.000 5.28050e-07 1.800 5.40000e-07 1.800
+ 5.40050e-07 0.000 5.52000e-07 0.000 5.52050e-07 1.800 5.64000e-07 1.800 5.64050e-07 0.000 5.76000e-07 0.000
+ 5.76050e-07 1.800 5.88000e-07 1.800 5.88050e-07 0.000 6.00000e-07 0.000 6.00050e-07 1.800 6.12000e-07 1.800
+ 6.12050e-07 0.000 6.24000e-07 0.000 6.24050e-07 1.800 6.36000e-07 1.800 6.36050e-07 0.000 6.48000e-07 0.000
+ 6.48050e-07 1.800 6.60000e-07 1.800 6.60050e-07 0.000 6.72000e-07 0.000 6.72050e-07 1.800 6.84000e-07 1.800
+ 6.84050e-07 0.000 6.96000e-07 0.000 6.96050e-07 1.800 7.08000e-07 1.800 7.08050e-07 0.000 7.20000e-07 0.000
+ 7.20050e-07 1.800 7.32000e-07 1.800 7.32050e-07 0.000 7.44000e-07 0.000 7.44050e-07 1.800 7.56000e-07 1.800
+ 7.56050e-07 0.000 7.68000e-07 0.000 7.68050e-07 1.800 7.80000e-07 1.800 7.80050e-07 0.000 7.92000e-07 0.000
+ 7.92050e-07 1.800 8.04000e-07 1.800 8.04050e-07 0.000 8.16000e-07 0.000 8.16050e-07 1.800 8.28000e-07 1.800
+ 8.28050e-07 0.000 8.40000e-07 0.000 8.40050e-07 1.800 8.52000e-07 1.800 8.52050e-07 0.000 8.64000e-07 0.000
+ 8.64050e-07 1.800 8.76000e-07 1.800 8.76050e-07 0.000 8.88000e-07 0.000 8.88050e-07 1.800 9.00000e-07 1.800
+ 9.00050e-07 0.000 9.12000e-07 0.000 9.12050e-07 1.800 9.24000e-07 1.800 9.24050e-07 0.000 9.36000e-07 0.000
+ 9.36050e-07 1.800 9.48000e-07 1.800 9.48050e-07 0.000 9.60000e-07 0.000 9.60050e-07 1.800 9.72000e-07 1.800
+ 9.72050e-07 0.000 9.84000e-07 0.000 9.84050e-07 1.800 9.96000e-07 1.800 9.96050e-07 0.000 1.00800e-06 0.000
+ 1.00805e-06 1.800 1.02000e-06 1.800 1.02005e-06 0.000 1.03200e-06 0.000 1.03205e-06 1.800 1.04400e-06 1.800
+ 1.04405e-06 0.000 1.05600e-06 0.000 1.05605e-06 1.800 1.06800e-06 1.800 1.06805e-06 0.000 1.08000e-06 0.000
+ 1.08005e-06 1.800 1.09200e-06 1.800 1.09205e-06 0.000 1.10400e-06 0.000 1.10405e-06 1.800 1.11600e-06 1.800
+ 1.11605e-06 0.000 1.12800e-06 0.000 1.12805e-06 1.800 1.14000e-06 1.800 1.14005e-06 0.000 1.15200e-06 0.000
+ 1.15205e-06 1.800 1.16400e-06 1.800 1.16405e-06 0.000 1.17600e-06 0.000 1.17605e-06 1.800 1.18800e-06 1.800
+ 1.18805e-06 0.000 1.20000e-06 0.000 1.20005e-06 1.800 1.21200e-06 1.800 1.21205e-06 0.000 1.22400e-06 0.000
+ 1.22405e-06 1.800 1.23600e-06 1.800 1.23605e-06 0.000 1.24800e-06 0.000 1.24805e-06 1.800 1.26000e-06 1.800
+ 1.26005e-06 0.000 1.27200e-06 0.000 1.27205e-06 1.800 1.28400e-06 1.800 1.28405e-06 0.000 1.29600e-06 0.000
+ 1.29605e-06 1.800 1.30800e-06 1.800 1.30805e-06 0.000 1.32000e-06 0.000 1.32005e-06 1.800 1.33200e-06 1.800
+ 1.33205e-06 0.000 1.34400e-06 0.000 1.34405e-06 1.800 1.35600e-06 1.800 1.35605e-06 0.000 1.36800e-06 0.000
+ 1.36805e-06 1.800 1.38000e-06 1.800 1.38005e-06 0.000 1.39200e-06 0.000 1.39205e-06 1.800 1.40400e-06 1.800
+ 1.40405e-06 0.000 1.41600e-06 0.000 1.41605e-06 1.800 1.42800e-06 1.800 1.42805e-06 0.000 1.44000e-06 0.000
+ 1.44005e-06 1.800 1.45200e-06 1.800 1.45205e-06 0.000 1.46400e-06 0.000 1.46405e-06 1.800 1.47600e-06 1.800
+ 1.47605e-06 0.000 1.48800e-06 0.000 1.48805e-06 1.800 1.50000e-06 1.800 1.50005e-06 0.000 1.51200e-06 0.000
+ 1.51205e-06 1.800 1.52400e-06 1.800 1.52405e-06 0.000 1.53600e-06 0.000 1.53605e-06 1.800 1.54200e-06 1.800
+ 1.54205e-06 0.000 1.54500e-06 0.000 1.54505e-06 1.800 1.54800e-06 1.800 1.54805e-06 0.000 1.56000e-06 0.000
+ 1.56005e-06 1.800 1.56600e-06 1.800 1.56605e-06 0.000 1.57200e-06 0.000 1.57205e-06 1.800 1.57500e-06 1.800
+ 1.57505e-06 0.000 1.58100e-06 0.000 1.58105e-06 1.800 1.58400e-06 1.800 1.58405e-06 0.000 1.59300e-06 0.000
+ 1.59305e-06 1.800 1.59900e-06 1.800 1.59905e-06 0.000 1.60200e-06 0.000 1.60205e-06 1.800 1.61100e-06 1.800
+ 1.61105e-06 0.000 1.61700e-06 0.000 1.61705e-06 1.800 1.63500e-06 1.800 1.63505e-06 0.000 1.64100e-06 0.000
+ 1.64105e-06 1.800 1.64400e-06 1.800 1.64405e-06 0.000 1.64700e-06 0.000 1.64705e-06 1.800 1.65300e-06 1.800
+ 1.65305e-06 0.000 1.65600e-06 0.000 1.65605e-06 1.800 1.66200e-06 1.800 1.66205e-06 0.000 1.66500e-06 0.000
+ 1.66505e-06 1.800 1.66800e-06 1.800 1.66805e-06 0.000 1.68000e-06 0.000 1.68005e-06 1.800 1.68300e-06 1.800
+ 1.68305e-06 0.000 1.68900e-06 0.000 1.68905e-06 1.800 1.69200e-06 1.800 1.69205e-06 0.000 1.69800e-06 0.000
+ 1.69805e-06 1.800 1.70100e-06 1.800 1.70105e-06 0.000 1.70700e-06 0.000 1.70705e-06 1.800 1.71000e-06 1.800
+ 1.71005e-06 0.000 1.71300e-06 0.000 1.71305e-06 1.800 1.71600e-06 1.800 1.71605e-06 0.000 1.72200e-06 0.000
+ 1.72205e-06 1.800 1.72800e-06 1.800 1.72805e-06 0.000 1.73100e-06 0.000 1.73105e-06 1.800 1.74900e-06 1.800
+ 1.74905e-06 0.000 1.75500e-06 0.000 1.75505e-06 1.800 1.76100e-06 1.800 1.76105e-06 0.000 1.76400e-06 0.000
+ 1.76405e-06 1.800 1.76700e-06 1.800 1.76705e-06 0.000 1.78500e-06 0.000 1.78505e-06 1.800 1.78800e-06 1.800
+ 1.78805e-06 0.000 1.79400e-06 0.000 1.79405e-06 1.800 1.80000e-06 1.800 1.80005e-06 0.000 1.80600e-06 0.000
+ 1.80605e-06 1.800 1.80900e-06 1.800 1.80905e-06 0.000 1.81200e-06 0.000 1.81205e-06 1.800 1.82400e-06 1.800
+ 1.82405e-06 0.000 1.82700e-06 0.000 1.82705e-06 1.800 1.83000e-06 1.800 1.83005e-06 0.000 1.84200e-06 0.000
+ 1.84205e-06 1.800 1.84800e-06 1.800 1.84805e-06 0.000 1.85100e-06 0.000 1.85105e-06 1.800 1.85700e-06 1.800
+ 1.85705e-06 0.000 1.86000e-06 0.000 1.86005e-06 1.800 1.86300e-06 1.800 1.86305e-06 0.000 1.87200e-06 0.000
+ 1.87205e-06 1.800 1.87500e-06 1.800 1.87505e-06 0.000 1.88400e-06 0.000 1.88405e-06 1.800 1.89300e-06 1.800
+ 1.89305e-06 0.000 1.89600e-06 0.000 1.89605e-06 1.800 1.90500e-06 1.800 1.90505e-06 0.000 1.90800e-06 0.000
+ 1.90805e-06 1.800 1.91100e-06 1.800 1.91105e-06 0.000 1.91700e-06 0.000 1.91705e-06 1.800 1.92300e-06 1.800
+ 1.92305e-06 0.000 1.92900e-06 0.000 1.92905e-06 1.800 1.93200e-06 1.800 1.93205e-06 0.000 1.94400e-06 0.000
+ 1.94405e-06 1.800 1.94700e-06 1.800 1.94705e-06 0.000 1.95300e-06 0.000 1.95305e-06 1.800 1.95600e-06 1.800
+ 1.95605e-06 0.000 1.95900e-06 0.000 1.95905e-06 1.800 1.96500e-06 1.800 1.96505e-06 0.000 1.96800e-06 0.000
+ 1.96805e-06 1.800 1.97100e-06 1.800 1.97105e-06 0.000 1.98300e-06 0.000 1.98305e-06 1.800 1.98900e-06 1.800
+ 1.98905e-06 0.000 1.99200e-06 0.000 1.99205e-06 1.800 2.00100e-06 1.800 2.00105e-06 0.000 2.00700e-06 0.000
+ 2.00705e-06 1.800 2.01000e-06 1.800 2.01005e-06 0.000 2.01300e-06 0.000 2.01305e-06 1.800 2.02500e-06 1.800
+ 2.02505e-06 0.000 2.03400e-06 0.000 2.03405e-06 1.800 2.03700e-06 1.800 2.03705e-06 0.000 2.04300e-06 0.000
+ 2.04305e-06 1.800 2.04600e-06 1.800 2.04605e-06 0.000 2.06100e-06 0.000 2.06105e-06 1.800 2.07300e-06 1.800
+ 2.07305e-06 0.000 2.08500e-06 0.000 2.08505e-06 1.800 2.08800e-06 1.800 2.08805e-06 0.000 2.10000e-06 0.000
+ 2.10005e-06 1.800 2.10300e-06 1.800 2.10305e-06 0.000 2.10600e-06 0.000 2.10605e-06 1.800 2.12400e-06 1.800
+ 2.12405e-06 0.000 2.12700e-06 0.000 2.12705e-06 1.800 2.13000e-06 1.800 2.13005e-06 0.000 2.13300e-06 0.000
+ 2.13305e-06 1.800 2.13600e-06 1.800 2.13605e-06 0.000 2.14500e-06 0.000 2.14505e-06 1.800 2.15700e-06 1.800
+ 2.15705e-06 0.000 2.16300e-06 0.000 2.16305e-06 1.800 2.16900e-06 1.800 2.16905e-06 0.000 2.17200e-06 0.000
+ 2.17205e-06 1.800 2.17500e-06 1.800 2.17505e-06 0.000 2.17800e-06 0.000 2.17805e-06 1.800 2.18100e-06 1.800
+ 2.18105e-06 0.000 2.19300e-06 0.000 2.19305e-06 1.800 2.20500e-06 1.800 2.20505e-06 0.000 2.20800e-06 0.000
+ 2.20805e-06 1.800 2.21100e-06 1.800 2.21105e-06 0.000 2.21400e-06 0.000 2.21405e-06 1.800 2.21700e-06 1.800
+ 2.21705e-06 0.000 2.22000e-06 0.000 2.22005e-06 1.800 2.22300e-06 1.800 2.22305e-06 0.000 2.22600e-06 0.000
+ 2.22605e-06 1.800 2.23500e-06 1.800 2.23505e-06 0.000 2.24400e-06 0.000 2.24405e-06 1.800 2.25300e-06 1.800
+ 2.25305e-06 0.000 2.25900e-06 0.000 2.25905e-06 1.800 2.28000e-06 1.800 2.28005e-06 0.000 2.28600e-06 0.000
+ 2.28605e-06 1.800 2.29200e-06 1.800 2.29205e-06 0.000 2.29500e-06 0.000 2.29505e-06 1.800 2.30400e-06 1.800
+ 2.30405e-06 0.000 2.31900e-06 0.000 2.31905e-06 1.800 2.32200e-06 1.800 2.32205e-06 0.000 2.32500e-06 0.000
+ 2.32505e-06 1.800 2.32800e-06 1.800 2.32805e-06 0.000 2.33100e-06 0.000 2.33105e-06 1.800 2.33700e-06 1.800
+ 2.33705e-06 0.000 2.34600e-06 0.000 2.34605e-06 1.800 2.35200e-06 1.800 2.35205e-06 0.000 2.35500e-06 0.000
+ 2.35505e-06 1.800 2.35800e-06 1.800 2.35805e-06 0.000 2.36100e-06 0.000 2.36105e-06 1.800 2.36400e-06 1.800
+ 2.36405e-06 0.000 2.36700e-06 0.000 2.36705e-06 1.800 2.37000e-06 1.800 2.37005e-06 0.000 2.37300e-06 0.000
+ 2.37305e-06 1.800 2.40300e-06 1.800 2.40305e-06 0.000 2.40600e-06 0.000 2.40605e-06 1.800 2.40900e-06 1.800
+ 2.40905e-06 0.000 2.41500e-06 0.000 2.41505e-06 1.800 2.41800e-06 1.800 2.41805e-06 0.000 2.43300e-06 0.000
+ 2.43305e-06 1.800 2.43900e-06 1.800 2.43905e-06 0.000 2.44500e-06 0.000 2.44505e-06 1.800 2.44800e-06 1.800
+ 2.44805e-06 0.000 2.45100e-06 0.000 2.45105e-06 1.800 2.45700e-06 1.800 2.45705e-06 0.000 2.46300e-06 0.000
+ 2.46305e-06 1.800 2.46600e-06 1.800 2.46605e-06 0.000 2.46900e-06 0.000 2.46905e-06 1.800 2.47500e-06 1.800
+ 2.47505e-06 0.000 2.48100e-06 0.000 2.48105e-06 1.800 2.48400e-06 1.800 2.48405e-06 0.000 2.49900e-06 0.000
+ 2.49905e-06 1.800 2.50500e-06 1.800 2.50505e-06 0.000 2.50800e-06 0.000 2.50805e-06 1.800 2.51700e-06 1.800
+ 2.51705e-06 0.000 2.52300e-06 0.000 2.52305e-06 1.800 2.53200e-06 1.800 2.53205e-06 0.000 2.54100e-06 0.000
+ 2.54105e-06 1.800 2.55300e-06 1.800 2.55305e-06 0.000 2.55900e-06 0.000 2.55905e-06 1.800 2.56800e-06 1.800
+ 2.56805e-06 0.000 2.57400e-06 0.000 2.57405e-06 1.800 2.58000e-06 1.800 2.58005e-06 0.000 2.58300e-06 0.000
+ 2.58305e-06 1.800 2.58900e-06 1.800 2.58905e-06 0.000 2.59200e-06 0.000 2.59205e-06 1.800 2.59500e-06 1.800
+ 2.59505e-06 0.000 2.60100e-06 0.000 2.60105e-06 1.800 2.60700e-06 1.800 2.60705e-06 0.000 2.61000e-06 0.000
+ 2.61005e-06 1.800 2.61600e-06 1.800 2.61605e-06 0.000 2.62200e-06 0.000 2.62205e-06 1.800 2.62800e-06 1.800
+ 2.62805e-06 0.000 2.63100e-06 0.000 2.63105e-06 1.800 2.63400e-06 1.800 2.63405e-06 0.000 2.63700e-06 0.000
+ 2.63705e-06 1.800 2.64000e-06 1.800 2.64005e-06 0.000 2.65800e-06 0.000 2.65805e-06 1.800 2.66100e-06 1.800
+ 2.66105e-06 0.000 2.67300e-06 0.000 2.67305e-06 1.800 2.67600e-06 1.800 2.67605e-06 0.000 2.68200e-06 0.000
+ 2.68205e-06 1.800 2.69100e-06 1.800 2.69105e-06 0.000 2.69400e-06 0.000 2.69405e-06 1.800 2.70000e-06 1.800
+ 2.70005e-06 0.000 2.70600e-06 0.000 2.70605e-06 1.800 2.71200e-06 1.800 2.71205e-06 0.000 2.71500e-06 0.000
+ 2.71505e-06 1.800 2.71800e-06 1.800 2.71805e-06 0.000 2.72400e-06 0.000 2.72405e-06 1.800 2.73000e-06 1.800
+ 2.73005e-06 0.000 2.73900e-06 0.000 2.73905e-06 1.800 2.74500e-06 1.800 2.74505e-06 0.000 2.75100e-06 0.000
+ 2.75105e-06 1.800 2.75700e-06 1.800 2.75705e-06 0.000 2.76300e-06 0.000 2.76305e-06 1.800 2.77200e-06 1.800
+ 2.77205e-06 0.000 2.78100e-06 0.000 2.78105e-06 1.800 2.78400e-06 1.800 2.78405e-06 0.000 2.79300e-06 0.000
+ 2.79305e-06 1.800 2.79600e-06 1.800 2.79605e-06 0.000 2.79900e-06 0.000 2.79905e-06 1.800 2.80500e-06 1.800
+ 2.80505e-06 0.000 2.81100e-06 0.000 2.81105e-06 1.800 2.82000e-06 1.800 2.82005e-06 0.000 2.82300e-06 0.000
+ 2.82305e-06 1.800 2.83500e-06 1.800 2.83505e-06 0.000 2.83800e-06 0.000 2.83805e-06 1.800 2.84400e-06 1.800
+ 2.84405e-06 0.000 2.85300e-06 0.000 2.85305e-06 1.800 2.85900e-06 1.800 2.85905e-06 0.000 2.86200e-06 0.000
+ 2.86205e-06 1.800 2.86800e-06 1.800 2.86805e-06 0.000 2.87700e-06 0.000 2.87705e-06 1.800 2.88000e-06 1.800
+ 2.88005e-06 0.000 2.88300e-06 0.000 2.88305e-06 1.800 2.88600e-06 1.800 2.88605e-06 0.000 2.88900e-06 0.000
+ 2.88905e-06 1.800 2.89500e-06 1.800 2.89505e-06 0.000 2.89800e-06 0.000 2.89805e-06 1.800 2.90100e-06 1.800
+ 2.90105e-06 0.000 2.90400e-06 0.000 2.90405e-06 1.800 2.90700e-06 1.800 2.90705e-06 0.000 2.91000e-06 0.000
+ 2.91005e-06 1.800 2.91900e-06 1.800 2.91905e-06 0.000 2.92500e-06 0.000 2.92505e-06 1.800 2.93100e-06 1.800
+ 2.93105e-06 0.000 2.93700e-06 0.000 2.93705e-06 1.800 2.94300e-06 1.800 2.94305e-06 0.000 2.95500e-06 0.000
+ 2.95505e-06 1.800 2.95800e-06 1.800 2.95805e-06 0.000 2.96100e-06 0.000 2.96105e-06 1.800 2.96400e-06 1.800
+ 2.96405e-06 0.000 2.97900e-06 0.000 2.97905e-06 1.800 2.98500e-06 1.800 2.98505e-06 0.000 2.99100e-06 0.000
+ 2.99105e-06 1.800 2.99700e-06 1.800 2.99705e-06 0.000 3.00900e-06 0.000 3.00905e-06 1.800 3.01500e-06 1.800
+ 3.01505e-06 0.000 3.01800e-06 0.000 3.01805e-06 1.800 3.03300e-06 1.800 3.03305e-06 0.000 3.03600e-06 0.000
+ 3.03605e-06 1.800 3.03900e-06 1.800 3.03905e-06 0.000 3.05100e-06 0.000 3.05105e-06 1.800 3.05700e-06 1.800
+ 3.05705e-06 0.000 3.06000e-06 0.000 3.06005e-06 1.800 3.07200e-06 1.800
+ )
Xd_b2 src_b2 b2 vdd gnd tb_inv
Vb3 src_b3 gnd PWL(
+ 0.00000e+00 1.800 6.00000e-09 1.800 6.05000e-09 0.000 1.20000e-08 0.000 1.20500e-08 1.800 1.80000e-08 1.800
+ 1.80500e-08 0.000 2.40000e-08 0.000 2.40500e-08 1.800 3.00000e-08 1.800 3.00500e-08 0.000 3.60000e-08 0.000
+ 3.60500e-08 1.800 4.20000e-08 1.800 4.20500e-08 0.000 4.80000e-08 0.000 4.80500e-08 1.800 5.40000e-08 1.800
+ 5.40500e-08 0.000 6.00000e-08 0.000 6.00500e-08 1.800 6.60000e-08 1.800 6.60500e-08 0.000 7.20000e-08 0.000
+ 7.20500e-08 1.800 7.80000e-08 1.800 7.80500e-08 0.000 8.40000e-08 0.000 8.40500e-08 1.800 9.00000e-08 1.800
+ 9.00500e-08 0.000 9.60000e-08 0.000 9.60500e-08 1.800 1.02000e-07 1.800 1.02050e-07 0.000 1.08000e-07 0.000
+ 1.08050e-07 1.800 1.14000e-07 1.800 1.14050e-07 0.000 1.20000e-07 0.000 1.20050e-07 1.800 1.26000e-07 1.800
+ 1.26050e-07 0.000 1.32000e-07 0.000 1.32050e-07 1.800 1.38000e-07 1.800 1.38050e-07 0.000 1.44000e-07 0.000
+ 1.44050e-07 1.800 1.50000e-07 1.800 1.50050e-07 0.000 1.56000e-07 0.000 1.56050e-07 1.800 1.62000e-07 1.800
+ 1.62050e-07 0.000 1.68000e-07 0.000 1.68050e-07 1.800 1.74000e-07 1.800 1.74050e-07 0.000 1.80000e-07 0.000
+ 1.80050e-07 1.800 1.86000e-07 1.800 1.86050e-07 0.000 1.92000e-07 0.000 1.92050e-07 1.800 1.98000e-07 1.800
+ 1.98050e-07 0.000 2.04000e-07 0.000 2.04050e-07 1.800 2.10000e-07 1.800 2.10050e-07 0.000 2.16000e-07 0.000
+ 2.16050e-07 1.800 2.22000e-07 1.800 2.22050e-07 0.000 2.28000e-07 0.000 2.28050e-07 1.800 2.34000e-07 1.800
+ 2.34050e-07 0.000 2.40000e-07 0.000 2.40050e-07 1.800 2.46000e-07 1.800 2.46050e-07 0.000 2.52000e-07 0.000
+ 2.52050e-07 1.800 2.58000e-07 1.800 2.58050e-07 0.000 2.64000e-07 0.000 2.64050e-07 1.800 2.70000e-07 1.800
+ 2.70050e-07 0.000 2.76000e-07 0.000 2.76050e-07 1.800 2.82000e-07 1.800 2.82050e-07 0.000 2.88000e-07 0.000
+ 2.88050e-07 1.800 2.94000e-07 1.800 2.94050e-07 0.000 3.00000e-07 0.000 3.00050e-07 1.800 3.06000e-07 1.800
+ 3.06050e-07 0.000 3.12000e-07 0.000 3.12050e-07 1.800 3.18000e-07 1.800 3.18050e-07 0.000 3.24000e-07 0.000
+ 3.24050e-07 1.800 3.30000e-07 1.800 3.30050e-07 0.000 3.36000e-07 0.000 3.36050e-07 1.800 3.42000e-07 1.800
+ 3.42050e-07 0.000 3.48000e-07 0.000 3.48050e-07 1.800 3.54000e-07 1.800 3.54050e-07 0.000 3.60000e-07 0.000
+ 3.60050e-07 1.800 3.66000e-07 1.800 3.66050e-07 0.000 3.72000e-07 0.000 3.72050e-07 1.800 3.78000e-07 1.800
+ 3.78050e-07 0.000 3.84000e-07 0.000 3.84050e-07 1.800 3.90000e-07 1.800 3.90050e-07 0.000 3.96000e-07 0.000
+ 3.96050e-07 1.800 4.02000e-07 1.800 4.02050e-07 0.000 4.08000e-07 0.000 4.08050e-07 1.800 4.14000e-07 1.800
+ 4.14050e-07 0.000 4.20000e-07 0.000 4.20050e-07 1.800 4.26000e-07 1.800 4.26050e-07 0.000 4.32000e-07 0.000
+ 4.32050e-07 1.800 4.38000e-07 1.800 4.38050e-07 0.000 4.44000e-07 0.000 4.44050e-07 1.800 4.50000e-07 1.800
+ 4.50050e-07 0.000 4.56000e-07 0.000 4.56050e-07 1.800 4.62000e-07 1.800 4.62050e-07 0.000 4.68000e-07 0.000
+ 4.68050e-07 1.800 4.74000e-07 1.800 4.74050e-07 0.000 4.80000e-07 0.000 4.80050e-07 1.800 4.86000e-07 1.800
+ 4.86050e-07 0.000 4.92000e-07 0.000 4.92050e-07 1.800 4.98000e-07 1.800 4.98050e-07 0.000 5.04000e-07 0.000
+ 5.04050e-07 1.800 5.10000e-07 1.800 5.10050e-07 0.000 5.16000e-07 0.000 5.16050e-07 1.800 5.22000e-07 1.800
+ 5.22050e-07 0.000 5.28000e-07 0.000 5.28050e-07 1.800 5.34000e-07 1.800 5.34050e-07 0.000 5.40000e-07 0.000
+ 5.40050e-07 1.800 5.46000e-07 1.800 5.46050e-07 0.000 5.52000e-07 0.000 5.52050e-07 1.800 5.58000e-07 1.800
+ 5.58050e-07 0.000 5.64000e-07 0.000 5.64050e-07 1.800 5.70000e-07 1.800 5.70050e-07 0.000 5.76000e-07 0.000
+ 5.76050e-07 1.800 5.82000e-07 1.800 5.82050e-07 0.000 5.88000e-07 0.000 5.88050e-07 1.800 5.94000e-07 1.800
+ 5.94050e-07 0.000 6.00000e-07 0.000 6.00050e-07 1.800 6.06000e-07 1.800 6.06050e-07 0.000 6.12000e-07 0.000
+ 6.12050e-07 1.800 6.18000e-07 1.800 6.18050e-07 0.000 6.24000e-07 0.000 6.24050e-07 1.800 6.30000e-07 1.800
+ 6.30050e-07 0.000 6.36000e-07 0.000 6.36050e-07 1.800 6.42000e-07 1.800 6.42050e-07 0.000 6.48000e-07 0.000
+ 6.48050e-07 1.800 6.54000e-07 1.800 6.54050e-07 0.000 6.60000e-07 0.000 6.60050e-07 1.800 6.66000e-07 1.800
+ 6.66050e-07 0.000 6.72000e-07 0.000 6.72050e-07 1.800 6.78000e-07 1.800 6.78050e-07 0.000 6.84000e-07 0.000
+ 6.84050e-07 1.800 6.90000e-07 1.800 6.90050e-07 0.000 6.96000e-07 0.000 6.96050e-07 1.800 7.02000e-07 1.800
+ 7.02050e-07 0.000 7.08000e-07 0.000 7.08050e-07 1.800 7.14000e-07 1.800 7.14050e-07 0.000 7.20000e-07 0.000
+ 7.20050e-07 1.800 7.26000e-07 1.800 7.26050e-07 0.000 7.32000e-07 0.000 7.32050e-07 1.800 7.38000e-07 1.800
+ 7.38050e-07 0.000 7.44000e-07 0.000 7.44050e-07 1.800 7.50000e-07 1.800 7.50050e-07 0.000 7.56000e-07 0.000
+ 7.56050e-07 1.800 7.62000e-07 1.800 7.62050e-07 0.000 7.68000e-07 0.000 7.68050e-07 1.800 7.74000e-07 1.800
+ 7.74050e-07 0.000 7.80000e-07 0.000 7.80050e-07 1.800 7.86000e-07 1.800 7.86050e-07 0.000 7.92000e-07 0.000
+ 7.92050e-07 1.800 7.98000e-07 1.800 7.98050e-07 0.000 8.04000e-07 0.000 8.04050e-07 1.800 8.10000e-07 1.800
+ 8.10050e-07 0.000 8.16000e-07 0.000 8.16050e-07 1.800 8.22000e-07 1.800 8.22050e-07 0.000 8.28000e-07 0.000
+ 8.28050e-07 1.800 8.34000e-07 1.800 8.34050e-07 0.000 8.40000e-07 0.000 8.40050e-07 1.800 8.46000e-07 1.800
+ 8.46050e-07 0.000 8.52000e-07 0.000 8.52050e-07 1.800 8.58000e-07 1.800 8.58050e-07 0.000 8.64000e-07 0.000
+ 8.64050e-07 1.800 8.70000e-07 1.800 8.70050e-07 0.000 8.76000e-07 0.000 8.76050e-07 1.800 8.82000e-07 1.800
+ 8.82050e-07 0.000 8.88000e-07 0.000 8.88050e-07 1.800 8.94000e-07 1.800 8.94050e-07 0.000 9.00000e-07 0.000
+ 9.00050e-07 1.800 9.06000e-07 1.800 9.06050e-07 0.000 9.12000e-07 0.000 9.12050e-07 1.800 9.18000e-07 1.800
+ 9.18050e-07 0.000 9.24000e-07 0.000 9.24050e-07 1.800 9.30000e-07 1.800 9.30050e-07 0.000 9.36000e-07 0.000
+ 9.36050e-07 1.800 9.42000e-07 1.800 9.42050e-07 0.000 9.48000e-07 0.000 9.48050e-07 1.800 9.54000e-07 1.800
+ 9.54050e-07 0.000 9.60000e-07 0.000 9.60050e-07 1.800 9.66000e-07 1.800 9.66050e-07 0.000 9.72000e-07 0.000
+ 9.72050e-07 1.800 9.78000e-07 1.800 9.78050e-07 0.000 9.84000e-07 0.000 9.84050e-07 1.800 9.90000e-07 1.800
+ 9.90050e-07 0.000 9.96000e-07 0.000 9.96050e-07 1.800 1.00200e-06 1.800 1.00205e-06 0.000 1.00800e-06 0.000
+ 1.00805e-06 1.800 1.01400e-06 1.800 1.01405e-06 0.000 1.02000e-06 0.000 1.02005e-06 1.800 1.02600e-06 1.800
+ 1.02605e-06 0.000 1.03200e-06 0.000 1.03205e-06 1.800 1.03800e-06 1.800 1.03805e-06 0.000 1.04400e-06 0.000
+ 1.04405e-06 1.800 1.05000e-06 1.800 1.05005e-06 0.000 1.05600e-06 0.000 1.05605e-06 1.800 1.06200e-06 1.800
+ 1.06205e-06 0.000 1.06800e-06 0.000 1.06805e-06 1.800 1.07400e-06 1.800 1.07405e-06 0.000 1.08000e-06 0.000
+ 1.08005e-06 1.800 1.08600e-06 1.800 1.08605e-06 0.000 1.09200e-06 0.000 1.09205e-06 1.800 1.09800e-06 1.800
+ 1.09805e-06 0.000 1.10400e-06 0.000 1.10405e-06 1.800 1.11000e-06 1.800 1.11005e-06 0.000 1.11600e-06 0.000
+ 1.11605e-06 1.800 1.12200e-06 1.800 1.12205e-06 0.000 1.12800e-06 0.000 1.12805e-06 1.800 1.13400e-06 1.800
+ 1.13405e-06 0.000 1.14000e-06 0.000 1.14005e-06 1.800 1.14600e-06 1.800 1.14605e-06 0.000 1.15200e-06 0.000
+ 1.15205e-06 1.800 1.15800e-06 1.800 1.15805e-06 0.000 1.16400e-06 0.000 1.16405e-06 1.800 1.17000e-06 1.800
+ 1.17005e-06 0.000 1.17600e-06 0.000 1.17605e-06 1.800 1.18200e-06 1.800 1.18205e-06 0.000 1.18800e-06 0.000
+ 1.18805e-06 1.800 1.19400e-06 1.800 1.19405e-06 0.000 1.20000e-06 0.000 1.20005e-06 1.800 1.20600e-06 1.800
+ 1.20605e-06 0.000 1.21200e-06 0.000 1.21205e-06 1.800 1.21800e-06 1.800 1.21805e-06 0.000 1.22400e-06 0.000
+ 1.22405e-06 1.800 1.23000e-06 1.800 1.23005e-06 0.000 1.23600e-06 0.000 1.23605e-06 1.800 1.24200e-06 1.800
+ 1.24205e-06 0.000 1.24800e-06 0.000 1.24805e-06 1.800 1.25400e-06 1.800 1.25405e-06 0.000 1.26000e-06 0.000
+ 1.26005e-06 1.800 1.26600e-06 1.800 1.26605e-06 0.000 1.27200e-06 0.000 1.27205e-06 1.800 1.27800e-06 1.800
+ 1.27805e-06 0.000 1.28400e-06 0.000 1.28405e-06 1.800 1.29000e-06 1.800 1.29005e-06 0.000 1.29600e-06 0.000
+ 1.29605e-06 1.800 1.30200e-06 1.800 1.30205e-06 0.000 1.30800e-06 0.000 1.30805e-06 1.800 1.31400e-06 1.800
+ 1.31405e-06 0.000 1.32000e-06 0.000 1.32005e-06 1.800 1.32600e-06 1.800 1.32605e-06 0.000 1.33200e-06 0.000
+ 1.33205e-06 1.800 1.33800e-06 1.800 1.33805e-06 0.000 1.34400e-06 0.000 1.34405e-06 1.800 1.35000e-06 1.800
+ 1.35005e-06 0.000 1.35600e-06 0.000 1.35605e-06 1.800 1.36200e-06 1.800 1.36205e-06 0.000 1.36800e-06 0.000
+ 1.36805e-06 1.800 1.37400e-06 1.800 1.37405e-06 0.000 1.38000e-06 0.000 1.38005e-06 1.800 1.38600e-06 1.800
+ 1.38605e-06 0.000 1.39200e-06 0.000 1.39205e-06 1.800 1.39800e-06 1.800 1.39805e-06 0.000 1.40400e-06 0.000
+ 1.40405e-06 1.800 1.41000e-06 1.800 1.41005e-06 0.000 1.41600e-06 0.000 1.41605e-06 1.800 1.42200e-06 1.800
+ 1.42205e-06 0.000 1.42800e-06 0.000 1.42805e-06 1.800 1.43400e-06 1.800 1.43405e-06 0.000 1.44000e-06 0.000
+ 1.44005e-06 1.800 1.44600e-06 1.800 1.44605e-06 0.000 1.45200e-06 0.000 1.45205e-06 1.800 1.45800e-06 1.800
+ 1.45805e-06 0.000 1.46400e-06 0.000 1.46405e-06 1.800 1.47000e-06 1.800 1.47005e-06 0.000 1.47600e-06 0.000
+ 1.47605e-06 1.800 1.48200e-06 1.800 1.48205e-06 0.000 1.48800e-06 0.000 1.48805e-06 1.800 1.49400e-06 1.800
+ 1.49405e-06 0.000 1.50000e-06 0.000 1.50005e-06 1.800 1.50600e-06 1.800 1.50605e-06 0.000 1.51200e-06 0.000
+ 1.51205e-06 1.800 1.51800e-06 1.800 1.51805e-06 0.000 1.52400e-06 0.000 1.52405e-06 1.800 1.53000e-06 1.800
+ 1.53005e-06 0.000 1.54200e-06 0.000 1.54205e-06 1.800 1.54800e-06 1.800 1.54805e-06 0.000 1.55100e-06 0.000
+ 1.55105e-06 1.800 1.55400e-06 1.800 1.55405e-06 0.000 1.55700e-06 0.000 1.55705e-06 1.800 1.56000e-06 1.800
+ 1.56005e-06 0.000 1.56300e-06 0.000 1.56305e-06 1.800 1.56600e-06 1.800 1.56605e-06 0.000 1.57200e-06 0.000
+ 1.57205e-06 1.800 1.57500e-06 1.800 1.57505e-06 0.000 1.58100e-06 0.000 1.58105e-06 1.800 1.59000e-06 1.800
+ 1.59005e-06 0.000 1.60200e-06 0.000 1.60205e-06 1.800 1.60500e-06 1.800 1.60505e-06 0.000 1.61100e-06 0.000
+ 1.61105e-06 1.800 1.61400e-06 1.800 1.61405e-06 0.000 1.62000e-06 0.000 1.62005e-06 1.800 1.62300e-06 1.800
+ 1.62305e-06 0.000 1.62600e-06 0.000 1.62605e-06 1.800 1.62900e-06 1.800 1.62905e-06 0.000 1.63200e-06 0.000
+ 1.63205e-06 1.800 1.63500e-06 1.800 1.63505e-06 0.000 1.64100e-06 0.000 1.64105e-06 1.800 1.64700e-06 1.800
+ 1.64705e-06 0.000 1.65300e-06 0.000 1.65305e-06 1.800 1.66500e-06 1.800 1.66505e-06 0.000 1.66800e-06 0.000
+ 1.66805e-06 1.800 1.67400e-06 1.800 1.67405e-06 0.000 1.67700e-06 0.000 1.67705e-06 1.800 1.68000e-06 1.800
+ 1.68005e-06 0.000 1.68600e-06 0.000 1.68605e-06 1.800 1.69200e-06 1.800 1.69205e-06 0.000 1.70100e-06 0.000
+ 1.70105e-06 1.800 1.70700e-06 1.800 1.70705e-06 0.000 1.71300e-06 0.000 1.71305e-06 1.800 1.72500e-06 1.800
+ 1.72505e-06 0.000 1.72800e-06 0.000 1.72805e-06 1.800 1.73700e-06 1.800 1.73705e-06 0.000 1.75800e-06 0.000
+ 1.75805e-06 1.800 1.76400e-06 1.800 1.76405e-06 0.000 1.77000e-06 0.000 1.77005e-06 1.800 1.78200e-06 1.800
+ 1.78205e-06 0.000 1.78500e-06 0.000 1.78505e-06 1.800 1.78800e-06 1.800 1.78805e-06 0.000 1.79400e-06 0.000
+ 1.79405e-06 1.800 1.79700e-06 1.800 1.79705e-06 0.000 1.80000e-06 0.000 1.80005e-06 1.800 1.80300e-06 1.800
+ 1.80305e-06 0.000 1.80600e-06 0.000 1.80605e-06 1.800 1.80900e-06 1.800 1.80905e-06 0.000 1.81200e-06 0.000
+ 1.81205e-06 1.800 1.81500e-06 1.800 1.81505e-06 0.000 1.81800e-06 0.000 1.81805e-06 1.800 1.82700e-06 1.800
+ 1.82705e-06 0.000 1.83300e-06 0.000 1.83305e-06 1.800 1.83600e-06 1.800 1.83605e-06 0.000 1.83900e-06 0.000
+ 1.83905e-06 1.800 1.84200e-06 1.800 1.84205e-06 0.000 1.84500e-06 0.000 1.84505e-06 1.800 1.85100e-06 1.800
+ 1.85105e-06 0.000 1.85700e-06 0.000 1.85705e-06 1.800 1.86000e-06 1.800 1.86005e-06 0.000 1.86300e-06 0.000
+ 1.86305e-06 1.800 1.86900e-06 1.800 1.86905e-06 0.000 1.87200e-06 0.000 1.87205e-06 1.800 1.87800e-06 1.800
+ 1.87805e-06 0.000 1.88700e-06 0.000 1.88705e-06 1.800 1.89900e-06 1.800 1.89905e-06 0.000 1.90800e-06 0.000
+ 1.90805e-06 1.800 1.91400e-06 1.800 1.91405e-06 0.000 1.91700e-06 0.000 1.91705e-06 1.800 1.92600e-06 1.800
+ 1.92605e-06 0.000 1.93500e-06 0.000 1.93505e-06 1.800 1.93800e-06 1.800 1.93805e-06 0.000 1.94100e-06 0.000
+ 1.94105e-06 1.800 1.94400e-06 1.800 1.94405e-06 0.000 1.96500e-06 0.000 1.96505e-06 1.800 1.96800e-06 1.800
+ 1.96805e-06 0.000 1.97100e-06 0.000 1.97105e-06 1.800 1.98000e-06 1.800 1.98005e-06 0.000 1.98300e-06 0.000
+ 1.98305e-06 1.800 1.98900e-06 1.800 1.98905e-06 0.000 1.99500e-06 0.000 1.99505e-06 1.800 2.00100e-06 1.800
+ 2.00105e-06 0.000 2.00400e-06 0.000 2.00405e-06 1.800 2.00700e-06 1.800 2.00705e-06 0.000 2.01000e-06 0.000
+ 2.01005e-06 1.800 2.01600e-06 1.800 2.01605e-06 0.000 2.01900e-06 0.000 2.01905e-06 1.800 2.02800e-06 1.800
+ 2.02805e-06 0.000 2.03100e-06 0.000 2.03105e-06 1.800 2.04300e-06 1.800 2.04305e-06 0.000 2.05200e-06 0.000
+ 2.05205e-06 1.800 2.05800e-06 1.800 2.05805e-06 0.000 2.06400e-06 0.000 2.06405e-06 1.800 2.07300e-06 1.800
+ 2.07305e-06 0.000 2.07600e-06 0.000 2.07605e-06 1.800 2.07900e-06 1.800 2.07905e-06 0.000 2.08200e-06 0.000
+ 2.08205e-06 1.800 2.09700e-06 1.800 2.09705e-06 0.000 2.10000e-06 0.000 2.10005e-06 1.800 2.11500e-06 1.800
+ 2.11505e-06 0.000 2.12100e-06 0.000 2.12105e-06 1.800 2.12700e-06 1.800 2.12705e-06 0.000 2.13600e-06 0.000
+ 2.13605e-06 1.800 2.13900e-06 1.800 2.13905e-06 0.000 2.14200e-06 0.000 2.14205e-06 1.800 2.14500e-06 1.800
+ 2.14505e-06 0.000 2.15100e-06 0.000 2.15105e-06 1.800 2.16000e-06 1.800 2.16005e-06 0.000 2.16300e-06 0.000
+ 2.16305e-06 1.800 2.16900e-06 1.800 2.16905e-06 0.000 2.17200e-06 0.000 2.17205e-06 1.800 2.17800e-06 1.800
+ 2.17805e-06 0.000 2.18400e-06 0.000 2.18405e-06 1.800 2.19000e-06 1.800 2.19005e-06 0.000 2.20800e-06 0.000
+ 2.20805e-06 1.800 2.22000e-06 1.800 2.22005e-06 0.000 2.22300e-06 0.000 2.22305e-06 1.800 2.22900e-06 1.800
+ 2.22905e-06 0.000 2.23500e-06 0.000 2.23505e-06 1.800 2.23800e-06 1.800 2.23805e-06 0.000 2.24100e-06 0.000
+ 2.24105e-06 1.800 2.25000e-06 1.800 2.25005e-06 0.000 2.26800e-06 0.000 2.26805e-06 1.800 2.27100e-06 1.800
+ 2.27105e-06 0.000 2.27700e-06 0.000 2.27705e-06 1.800 2.28000e-06 1.800 2.28005e-06 0.000 2.28300e-06 0.000
+ 2.28305e-06 1.800 2.28900e-06 1.800 2.28905e-06 0.000 2.29800e-06 0.000 2.29805e-06 1.800 2.30100e-06 1.800
+ 2.30105e-06 0.000 2.30700e-06 0.000 2.30705e-06 1.800 2.31300e-06 1.800 2.31305e-06 0.000 2.32200e-06 0.000
+ 2.32205e-06 1.800 2.33700e-06 1.800 2.33705e-06 0.000 2.35200e-06 0.000 2.35205e-06 1.800 2.35500e-06 1.800
+ 2.35505e-06 0.000 2.35800e-06 0.000 2.35805e-06 1.800 2.36700e-06 1.800 2.36705e-06 0.000 2.38800e-06 0.000
+ 2.38805e-06 1.800 2.39100e-06 1.800 2.39105e-06 0.000 2.39700e-06 0.000 2.39705e-06 1.800 2.40900e-06 1.800
+ 2.40905e-06 0.000 2.41200e-06 0.000 2.41205e-06 1.800 2.41800e-06 1.800 2.41805e-06 0.000 2.42400e-06 0.000
+ 2.42405e-06 1.800 2.42700e-06 1.800 2.42705e-06 0.000 2.43000e-06 0.000 2.43005e-06 1.800 2.43300e-06 1.800
+ 2.43305e-06 0.000 2.44200e-06 0.000 2.44205e-06 1.800 2.44800e-06 1.800 2.44805e-06 0.000 2.45400e-06 0.000
+ 2.45405e-06 1.800 2.46000e-06 1.800 2.46005e-06 0.000 2.46300e-06 0.000 2.46305e-06 1.800 2.46900e-06 1.800
+ 2.46905e-06 0.000 2.47200e-06 0.000 2.47205e-06 1.800 2.47500e-06 1.800 2.47505e-06 0.000 2.48100e-06 0.000
+ 2.48105e-06 1.800 2.48400e-06 1.800 2.48405e-06 0.000 2.49900e-06 0.000 2.49905e-06 1.800 2.50200e-06 1.800
+ 2.50205e-06 0.000 2.50500e-06 0.000 2.50505e-06 1.800 2.51400e-06 1.800 2.51405e-06 0.000 2.52000e-06 0.000
+ 2.52005e-06 1.800 2.52300e-06 1.800 2.52305e-06 0.000 2.52600e-06 0.000 2.52605e-06 1.800 2.52900e-06 1.800
+ 2.52905e-06 0.000 2.53200e-06 0.000 2.53205e-06 1.800 2.53500e-06 1.800 2.53505e-06 0.000 2.54700e-06 0.000
+ 2.54705e-06 1.800 2.55300e-06 1.800 2.55305e-06 0.000 2.56200e-06 0.000 2.56205e-06 1.800 2.57100e-06 1.800
+ 2.57105e-06 0.000 2.57400e-06 0.000 2.57405e-06 1.800 2.57700e-06 1.800 2.57705e-06 0.000 2.58300e-06 0.000
+ 2.58305e-06 1.800 2.58900e-06 1.800 2.58905e-06 0.000 2.59800e-06 0.000 2.59805e-06 1.800 2.60100e-06 1.800
+ 2.60105e-06 0.000 2.60400e-06 0.000 2.60405e-06 1.800 2.60700e-06 1.800 2.60705e-06 0.000 2.61000e-06 0.000
+ 2.61005e-06 1.800 2.61300e-06 1.800 2.61305e-06 0.000 2.61900e-06 0.000 2.61905e-06 1.800 2.62200e-06 1.800
+ 2.62205e-06 0.000 2.62500e-06 0.000 2.62505e-06 1.800 2.62800e-06 1.800 2.62805e-06 0.000 2.63100e-06 0.000
+ 2.63105e-06 1.800 2.63400e-06 1.800 2.63405e-06 0.000 2.63700e-06 0.000 2.63705e-06 1.800 2.64300e-06 1.800
+ 2.64305e-06 0.000 2.65500e-06 0.000 2.65505e-06 1.800 2.66400e-06 1.800 2.66405e-06 0.000 2.67000e-06 0.000
+ 2.67005e-06 1.800 2.67600e-06 1.800 2.67605e-06 0.000 2.68800e-06 0.000 2.68805e-06 1.800 2.69100e-06 1.800
+ 2.69105e-06 0.000 2.69700e-06 0.000 2.69705e-06 1.800 2.70300e-06 1.800 2.70305e-06 0.000 2.70600e-06 0.000
+ 2.70605e-06 1.800 2.70900e-06 1.800 2.70905e-06 0.000 2.71800e-06 0.000 2.71805e-06 1.800 2.72400e-06 1.800
+ 2.72405e-06 0.000 2.73600e-06 0.000 2.73605e-06 1.800 2.73900e-06 1.800 2.73905e-06 0.000 2.74500e-06 0.000
+ 2.74505e-06 1.800 2.74800e-06 1.800 2.74805e-06 0.000 2.75100e-06 0.000 2.75105e-06 1.800 2.76000e-06 1.800
+ 2.76005e-06 0.000 2.76300e-06 0.000 2.76305e-06 1.800 2.76600e-06 1.800 2.76605e-06 0.000 2.76900e-06 0.000
+ 2.76905e-06 1.800 2.77800e-06 1.800 2.77805e-06 0.000 2.78100e-06 0.000 2.78105e-06 1.800 2.80200e-06 1.800
+ 2.80205e-06 0.000 2.80800e-06 0.000 2.80805e-06 1.800 2.81400e-06 1.800 2.81405e-06 0.000 2.81700e-06 0.000
+ 2.81705e-06 1.800 2.82000e-06 1.800 2.82005e-06 0.000 2.82300e-06 0.000 2.82305e-06 1.800 2.82600e-06 1.800
+ 2.82605e-06 0.000 2.82900e-06 0.000 2.82905e-06 1.800 2.84100e-06 1.800 2.84105e-06 0.000 2.84400e-06 0.000
+ 2.84405e-06 1.800 2.85000e-06 1.800 2.85005e-06 0.000 2.86500e-06 0.000 2.86505e-06 1.800 2.88300e-06 1.800
+ 2.88305e-06 0.000 2.88900e-06 0.000 2.88905e-06 1.800 2.89200e-06 1.800 2.89205e-06 0.000 2.89800e-06 0.000
+ 2.89805e-06 1.800 2.90100e-06 1.800 2.90105e-06 0.000 2.91000e-06 0.000 2.91005e-06 1.800 2.91300e-06 1.800
+ 2.91305e-06 0.000 2.91600e-06 0.000 2.91605e-06 1.800 2.91900e-06 1.800 2.91905e-06 0.000 2.92200e-06 0.000
+ 2.92205e-06 1.800 2.92500e-06 1.800 2.92505e-06 0.000 2.92800e-06 0.000 2.92805e-06 1.800 2.93100e-06 1.800
+ 2.93105e-06 0.000 2.94300e-06 0.000 2.94305e-06 1.800 2.95500e-06 1.800 2.95505e-06 0.000 2.96400e-06 0.000
+ 2.96405e-06 1.800 2.97000e-06 1.800 2.97005e-06 0.000 2.97300e-06 0.000 2.97305e-06 1.800 2.99700e-06 1.800
+ 2.99705e-06 0.000 3.00300e-06 0.000 3.00305e-06 1.800 3.00600e-06 1.800 3.00605e-06 0.000 3.01200e-06 0.000
+ 3.01205e-06 1.800 3.01500e-06 1.800 3.01505e-06 0.000 3.01800e-06 0.000 3.01805e-06 1.800 3.02400e-06 1.800
+ 3.02405e-06 0.000 3.03300e-06 0.000 3.03305e-06 1.800 3.03900e-06 1.800 3.03905e-06 0.000 3.04200e-06 0.000
+ 3.04205e-06 1.800 3.05100e-06 1.800 3.05105e-06 0.000 3.05400e-06 0.000 3.05405e-06 1.800 3.05700e-06 1.800
+ 3.05705e-06 0.000 3.06300e-06 0.000 3.06305e-06 1.800 3.06600e-06 1.800 3.06605e-06 0.000 3.06900e-06 0.000
+ 3.06905e-06 1.800 3.07200e-06 1.800
+ )
Xd_b3 src_b3 b3 vdd gnd tb_inv
Vc0 src_c0 gnd PWL(
+ 0.00000e+00 1.800 3.00000e-09 1.800 3.05000e-09 0.000 6.00000e-09 0.000 6.05000e-09 1.800 9.00000e-09 1.800
+ 9.05000e-09 0.000 1.20000e-08 0.000 1.20500e-08 1.800 1.50000e-08 1.800 1.50500e-08 0.000 1.80000e-08 0.000
+ 1.80500e-08 1.800 2.10000e-08 1.800 2.10500e-08 0.000 2.40000e-08 0.000 2.40500e-08 1.800 2.70000e-08 1.800
+ 2.70500e-08 0.000 3.00000e-08 0.000 3.00500e-08 1.800 3.30000e-08 1.800 3.30500e-08 0.000 3.60000e-08 0.000
+ 3.60500e-08 1.800 3.90000e-08 1.800 3.90500e-08 0.000 4.20000e-08 0.000 4.20500e-08 1.800 4.50000e-08 1.800
+ 4.50500e-08 0.000 4.80000e-08 0.000 4.80500e-08 1.800 5.10000e-08 1.800 5.10500e-08 0.000 5.40000e-08 0.000
+ 5.40500e-08 1.800 5.70000e-08 1.800 5.70500e-08 0.000 6.00000e-08 0.000 6.00500e-08 1.800 6.30000e-08 1.800
+ 6.30500e-08 0.000 6.60000e-08 0.000 6.60500e-08 1.800 6.90000e-08 1.800 6.90500e-08 0.000 7.20000e-08 0.000
+ 7.20500e-08 1.800 7.50000e-08 1.800 7.50500e-08 0.000 7.80000e-08 0.000 7.80500e-08 1.800 8.10000e-08 1.800
+ 8.10500e-08 0.000 8.40000e-08 0.000 8.40500e-08 1.800 8.70000e-08 1.800 8.70500e-08 0.000 9.00000e-08 0.000
+ 9.00500e-08 1.800 9.30000e-08 1.800 9.30500e-08 0.000 9.60000e-08 0.000 9.60500e-08 1.800 9.90000e-08 1.800
+ 9.90500e-08 0.000 1.02000e-07 0.000 1.02050e-07 1.800 1.05000e-07 1.800 1.05050e-07 0.000 1.08000e-07 0.000
+ 1.08050e-07 1.800 1.11000e-07 1.800 1.11050e-07 0.000 1.14000e-07 0.000 1.14050e-07 1.800 1.17000e-07 1.800
+ 1.17050e-07 0.000 1.20000e-07 0.000 1.20050e-07 1.800 1.23000e-07 1.800 1.23050e-07 0.000 1.26000e-07 0.000
+ 1.26050e-07 1.800 1.29000e-07 1.800 1.29050e-07 0.000 1.32000e-07 0.000 1.32050e-07 1.800 1.35000e-07 1.800
+ 1.35050e-07 0.000 1.38000e-07 0.000 1.38050e-07 1.800 1.41000e-07 1.800 1.41050e-07 0.000 1.44000e-07 0.000
+ 1.44050e-07 1.800 1.47000e-07 1.800 1.47050e-07 0.000 1.50000e-07 0.000 1.50050e-07 1.800 1.53000e-07 1.800
+ 1.53050e-07 0.000 1.56000e-07 0.000 1.56050e-07 1.800 1.59000e-07 1.800 1.59050e-07 0.000 1.62000e-07 0.000
+ 1.62050e-07 1.800 1.65000e-07 1.800 1.65050e-07 0.000 1.68000e-07 0.000 1.68050e-07 1.800 1.71000e-07 1.800
+ 1.71050e-07 0.000 1.74000e-07 0.000 1.74050e-07 1.800 1.77000e-07 1.800 1.77050e-07 0.000 1.80000e-07 0.000
+ 1.80050e-07 1.800 1.83000e-07 1.800 1.83050e-07 0.000 1.86000e-07 0.000 1.86050e-07 1.800 1.89000e-07 1.800
+ 1.89050e-07 0.000 1.92000e-07 0.000 1.92050e-07 1.800 1.95000e-07 1.800 1.95050e-07 0.000 1.98000e-07 0.000
+ 1.98050e-07 1.800 2.01000e-07 1.800 2.01050e-07 0.000 2.04000e-07 0.000 2.04050e-07 1.800 2.07000e-07 1.800
+ 2.07050e-07 0.000 2.10000e-07 0.000 2.10050e-07 1.800 2.13000e-07 1.800 2.13050e-07 0.000 2.16000e-07 0.000
+ 2.16050e-07 1.800 2.19000e-07 1.800 2.19050e-07 0.000 2.22000e-07 0.000 2.22050e-07 1.800 2.25000e-07 1.800
+ 2.25050e-07 0.000 2.28000e-07 0.000 2.28050e-07 1.800 2.31000e-07 1.800 2.31050e-07 0.000 2.34000e-07 0.000
+ 2.34050e-07 1.800 2.37000e-07 1.800 2.37050e-07 0.000 2.40000e-07 0.000 2.40050e-07 1.800 2.43000e-07 1.800
+ 2.43050e-07 0.000 2.46000e-07 0.000 2.46050e-07 1.800 2.49000e-07 1.800 2.49050e-07 0.000 2.52000e-07 0.000
+ 2.52050e-07 1.800 2.55000e-07 1.800 2.55050e-07 0.000 2.58000e-07 0.000 2.58050e-07 1.800 2.61000e-07 1.800
+ 2.61050e-07 0.000 2.64000e-07 0.000 2.64050e-07 1.800 2.67000e-07 1.800 2.67050e-07 0.000 2.70000e-07 0.000
+ 2.70050e-07 1.800 2.73000e-07 1.800 2.73050e-07 0.000 2.76000e-07 0.000 2.76050e-07 1.800 2.79000e-07 1.800
+ 2.79050e-07 0.000 2.82000e-07 0.000 2.82050e-07 1.800 2.85000e-07 1.800 2.85050e-07 0.000 2.88000e-07 0.000
+ 2.88050e-07 1.800 2.91000e-07 1.800 2.91050e-07 0.000 2.94000e-07 0.000 2.94050e-07 1.800 2.97000e-07 1.800
+ 2.97050e-07 0.000 3.00000e-07 0.000 3.00050e-07 1.800 3.03000e-07 1.800 3.03050e-07 0.000 3.06000e-07 0.000
+ 3.06050e-07 1.800 3.09000e-07 1.800 3.09050e-07 0.000 3.12000e-07 0.000 3.12050e-07 1.800 3.15000e-07 1.800
+ 3.15050e-07 0.000 3.18000e-07 0.000 3.18050e-07 1.800 3.21000e-07 1.800 3.21050e-07 0.000 3.24000e-07 0.000
+ 3.24050e-07 1.800 3.27000e-07 1.800 3.27050e-07 0.000 3.30000e-07 0.000 3.30050e-07 1.800 3.33000e-07 1.800
+ 3.33050e-07 0.000 3.36000e-07 0.000 3.36050e-07 1.800 3.39000e-07 1.800 3.39050e-07 0.000 3.42000e-07 0.000
+ 3.42050e-07 1.800 3.45000e-07 1.800 3.45050e-07 0.000 3.48000e-07 0.000 3.48050e-07 1.800 3.51000e-07 1.800
+ 3.51050e-07 0.000 3.54000e-07 0.000 3.54050e-07 1.800 3.57000e-07 1.800 3.57050e-07 0.000 3.60000e-07 0.000
+ 3.60050e-07 1.800 3.63000e-07 1.800 3.63050e-07 0.000 3.66000e-07 0.000 3.66050e-07 1.800 3.69000e-07 1.800
+ 3.69050e-07 0.000 3.72000e-07 0.000 3.72050e-07 1.800 3.75000e-07 1.800 3.75050e-07 0.000 3.78000e-07 0.000
+ 3.78050e-07 1.800 3.81000e-07 1.800 3.81050e-07 0.000 3.84000e-07 0.000 3.84050e-07 1.800 3.87000e-07 1.800
+ 3.87050e-07 0.000 3.90000e-07 0.000 3.90050e-07 1.800 3.93000e-07 1.800 3.93050e-07 0.000 3.96000e-07 0.000
+ 3.96050e-07 1.800 3.99000e-07 1.800 3.99050e-07 0.000 4.02000e-07 0.000 4.02050e-07 1.800 4.05000e-07 1.800
+ 4.05050e-07 0.000 4.08000e-07 0.000 4.08050e-07 1.800 4.11000e-07 1.800 4.11050e-07 0.000 4.14000e-07 0.000
+ 4.14050e-07 1.800 4.17000e-07 1.800 4.17050e-07 0.000 4.20000e-07 0.000 4.20050e-07 1.800 4.23000e-07 1.800
+ 4.23050e-07 0.000 4.26000e-07 0.000 4.26050e-07 1.800 4.29000e-07 1.800 4.29050e-07 0.000 4.32000e-07 0.000
+ 4.32050e-07 1.800 4.35000e-07 1.800 4.35050e-07 0.000 4.38000e-07 0.000 4.38050e-07 1.800 4.41000e-07 1.800
+ 4.41050e-07 0.000 4.44000e-07 0.000 4.44050e-07 1.800 4.47000e-07 1.800 4.47050e-07 0.000 4.50000e-07 0.000
+ 4.50050e-07 1.800 4.53000e-07 1.800 4.53050e-07 0.000 4.56000e-07 0.000 4.56050e-07 1.800 4.59000e-07 1.800
+ 4.59050e-07 0.000 4.62000e-07 0.000 4.62050e-07 1.800 4.65000e-07 1.800 4.65050e-07 0.000 4.68000e-07 0.000
+ 4.68050e-07 1.800 4.71000e-07 1.800 4.71050e-07 0.000 4.74000e-07 0.000 4.74050e-07 1.800 4.77000e-07 1.800
+ 4.77050e-07 0.000 4.80000e-07 0.000 4.80050e-07 1.800 4.83000e-07 1.800 4.83050e-07 0.000 4.86000e-07 0.000
+ 4.86050e-07 1.800 4.89000e-07 1.800 4.89050e-07 0.000 4.92000e-07 0.000 4.92050e-07 1.800 4.95000e-07 1.800
+ 4.95050e-07 0.000 4.98000e-07 0.000 4.98050e-07 1.800 5.01000e-07 1.800 5.01050e-07 0.000 5.04000e-07 0.000
+ 5.04050e-07 1.800 5.07000e-07 1.800 5.07050e-07 0.000 5.10000e-07 0.000 5.10050e-07 1.800 5.13000e-07 1.800
+ 5.13050e-07 0.000 5.16000e-07 0.000 5.16050e-07 1.800 5.19000e-07 1.800 5.19050e-07 0.000 5.22000e-07 0.000
+ 5.22050e-07 1.800 5.25000e-07 1.800 5.25050e-07 0.000 5.28000e-07 0.000 5.28050e-07 1.800 5.31000e-07 1.800
+ 5.31050e-07 0.000 5.34000e-07 0.000 5.34050e-07 1.800 5.37000e-07 1.800 5.37050e-07 0.000 5.40000e-07 0.000
+ 5.40050e-07 1.800 5.43000e-07 1.800 5.43050e-07 0.000 5.46000e-07 0.000 5.46050e-07 1.800 5.49000e-07 1.800
+ 5.49050e-07 0.000 5.52000e-07 0.000 5.52050e-07 1.800 5.55000e-07 1.800 5.55050e-07 0.000 5.58000e-07 0.000
+ 5.58050e-07 1.800 5.61000e-07 1.800 5.61050e-07 0.000 5.64000e-07 0.000 5.64050e-07 1.800 5.67000e-07 1.800
+ 5.67050e-07 0.000 5.70000e-07 0.000 5.70050e-07 1.800 5.73000e-07 1.800 5.73050e-07 0.000 5.76000e-07 0.000
+ 5.76050e-07 1.800 5.79000e-07 1.800 5.79050e-07 0.000 5.82000e-07 0.000 5.82050e-07 1.800 5.85000e-07 1.800
+ 5.85050e-07 0.000 5.88000e-07 0.000 5.88050e-07 1.800 5.91000e-07 1.800 5.91050e-07 0.000 5.94000e-07 0.000
+ 5.94050e-07 1.800 5.97000e-07 1.800 5.97050e-07 0.000 6.00000e-07 0.000 6.00050e-07 1.800 6.03000e-07 1.800
+ 6.03050e-07 0.000 6.06000e-07 0.000 6.06050e-07 1.800 6.09000e-07 1.800 6.09050e-07 0.000 6.12000e-07 0.000
+ 6.12050e-07 1.800 6.15000e-07 1.800 6.15050e-07 0.000 6.18000e-07 0.000 6.18050e-07 1.800 6.21000e-07 1.800
+ 6.21050e-07 0.000 6.24000e-07 0.000 6.24050e-07 1.800 6.27000e-07 1.800 6.27050e-07 0.000 6.30000e-07 0.000
+ 6.30050e-07 1.800 6.33000e-07 1.800 6.33050e-07 0.000 6.36000e-07 0.000 6.36050e-07 1.800 6.39000e-07 1.800
+ 6.39050e-07 0.000 6.42000e-07 0.000 6.42050e-07 1.800 6.45000e-07 1.800 6.45050e-07 0.000 6.48000e-07 0.000
+ 6.48050e-07 1.800 6.51000e-07 1.800 6.51050e-07 0.000 6.54000e-07 0.000 6.54050e-07 1.800 6.57000e-07 1.800
+ 6.57050e-07 0.000 6.60000e-07 0.000 6.60050e-07 1.800 6.63000e-07 1.800 6.63050e-07 0.000 6.66000e-07 0.000
+ 6.66050e-07 1.800 6.69000e-07 1.800 6.69050e-07 0.000 6.72000e-07 0.000 6.72050e-07 1.800 6.75000e-07 1.800
+ 6.75050e-07 0.000 6.78000e-07 0.000 6.78050e-07 1.800 6.81000e-07 1.800 6.81050e-07 0.000 6.84000e-07 0.000
+ 6.84050e-07 1.800 6.87000e-07 1.800 6.87050e-07 0.000 6.90000e-07 0.000 6.90050e-07 1.800 6.93000e-07 1.800
+ 6.93050e-07 0.000 6.96000e-07 0.000 6.96050e-07 1.800 6.99000e-07 1.800 6.99050e-07 0.000 7.02000e-07 0.000
+ 7.02050e-07 1.800 7.05000e-07 1.800 7.05050e-07 0.000 7.08000e-07 0.000 7.08050e-07 1.800 7.11000e-07 1.800
+ 7.11050e-07 0.000 7.14000e-07 0.000 7.14050e-07 1.800 7.17000e-07 1.800 7.17050e-07 0.000 7.20000e-07 0.000
+ 7.20050e-07 1.800 7.23000e-07 1.800 7.23050e-07 0.000 7.26000e-07 0.000 7.26050e-07 1.800 7.29000e-07 1.800
+ 7.29050e-07 0.000 7.32000e-07 0.000 7.32050e-07 1.800 7.35000e-07 1.800 7.35050e-07 0.000 7.38000e-07 0.000
+ 7.38050e-07 1.800 7.41000e-07 1.800 7.41050e-07 0.000 7.44000e-07 0.000 7.44050e-07 1.800 7.47000e-07 1.800
+ 7.47050e-07 0.000 7.50000e-07 0.000 7.50050e-07 1.800 7.53000e-07 1.800 7.53050e-07 0.000 7.56000e-07 0.000
+ 7.56050e-07 1.800 7.59000e-07 1.800 7.59050e-07 0.000 7.62000e-07 0.000 7.62050e-07 1.800 7.65000e-07 1.800
+ 7.65050e-07 0.000 7.68000e-07 0.000 7.68050e-07 1.800 7.71000e-07 1.800 7.71050e-07 0.000 7.74000e-07 0.000
+ 7.74050e-07 1.800 7.77000e-07 1.800 7.77050e-07 0.000 7.80000e-07 0.000 7.80050e-07 1.800 7.83000e-07 1.800
+ 7.83050e-07 0.000 7.86000e-07 0.000 7.86050e-07 1.800 7.89000e-07 1.800 7.89050e-07 0.000 7.92000e-07 0.000
+ 7.92050e-07 1.800 7.95000e-07 1.800 7.95050e-07 0.000 7.98000e-07 0.000 7.98050e-07 1.800 8.01000e-07 1.800
+ 8.01050e-07 0.000 8.04000e-07 0.000 8.04050e-07 1.800 8.07000e-07 1.800 8.07050e-07 0.000 8.10000e-07 0.000
+ 8.10050e-07 1.800 8.13000e-07 1.800 8.13050e-07 0.000 8.16000e-07 0.000 8.16050e-07 1.800 8.19000e-07 1.800
+ 8.19050e-07 0.000 8.22000e-07 0.000 8.22050e-07 1.800 8.25000e-07 1.800 8.25050e-07 0.000 8.28000e-07 0.000
+ 8.28050e-07 1.800 8.31000e-07 1.800 8.31050e-07 0.000 8.34000e-07 0.000 8.34050e-07 1.800 8.37000e-07 1.800
+ 8.37050e-07 0.000 8.40000e-07 0.000 8.40050e-07 1.800 8.43000e-07 1.800 8.43050e-07 0.000 8.46000e-07 0.000
+ 8.46050e-07 1.800 8.49000e-07 1.800 8.49050e-07 0.000 8.52000e-07 0.000 8.52050e-07 1.800 8.55000e-07 1.800
+ 8.55050e-07 0.000 8.58000e-07 0.000 8.58050e-07 1.800 8.61000e-07 1.800 8.61050e-07 0.000 8.64000e-07 0.000
+ 8.64050e-07 1.800 8.67000e-07 1.800 8.67050e-07 0.000 8.70000e-07 0.000 8.70050e-07 1.800 8.73000e-07 1.800
+ 8.73050e-07 0.000 8.76000e-07 0.000 8.76050e-07 1.800 8.79000e-07 1.800 8.79050e-07 0.000 8.82000e-07 0.000
+ 8.82050e-07 1.800 8.85000e-07 1.800 8.85050e-07 0.000 8.88000e-07 0.000 8.88050e-07 1.800 8.91000e-07 1.800
+ 8.91050e-07 0.000 8.94000e-07 0.000 8.94050e-07 1.800 8.97000e-07 1.800 8.97050e-07 0.000 9.00000e-07 0.000
+ 9.00050e-07 1.800 9.03000e-07 1.800 9.03050e-07 0.000 9.06000e-07 0.000 9.06050e-07 1.800 9.09000e-07 1.800
+ 9.09050e-07 0.000 9.12000e-07 0.000 9.12050e-07 1.800 9.15000e-07 1.800 9.15050e-07 0.000 9.18000e-07 0.000
+ 9.18050e-07 1.800 9.21000e-07 1.800 9.21050e-07 0.000 9.24000e-07 0.000 9.24050e-07 1.800 9.27000e-07 1.800
+ 9.27050e-07 0.000 9.30000e-07 0.000 9.30050e-07 1.800 9.33000e-07 1.800 9.33050e-07 0.000 9.36000e-07 0.000
+ 9.36050e-07 1.800 9.39000e-07 1.800 9.39050e-07 0.000 9.42000e-07 0.000 9.42050e-07 1.800 9.45000e-07 1.800
+ 9.45050e-07 0.000 9.48000e-07 0.000 9.48050e-07 1.800 9.51000e-07 1.800 9.51050e-07 0.000 9.54000e-07 0.000
+ 9.54050e-07 1.800 9.57000e-07 1.800 9.57050e-07 0.000 9.60000e-07 0.000 9.60050e-07 1.800 9.63000e-07 1.800
+ 9.63050e-07 0.000 9.66000e-07 0.000 9.66050e-07 1.800 9.69000e-07 1.800 9.69050e-07 0.000 9.72000e-07 0.000
+ 9.72050e-07 1.800 9.75000e-07 1.800 9.75050e-07 0.000 9.78000e-07 0.000 9.78050e-07 1.800 9.81000e-07 1.800
+ 9.81050e-07 0.000 9.84000e-07 0.000 9.84050e-07 1.800 9.87000e-07 1.800 9.87050e-07 0.000 9.90000e-07 0.000
+ 9.90050e-07 1.800 9.93000e-07 1.800 9.93050e-07 0.000 9.96000e-07 0.000 9.96050e-07 1.800 9.99000e-07 1.800
+ 9.99050e-07 0.000 1.00200e-06 0.000 1.00205e-06 1.800 1.00500e-06 1.800 1.00505e-06 0.000 1.00800e-06 0.000
+ 1.00805e-06 1.800 1.01100e-06 1.800 1.01105e-06 0.000 1.01400e-06 0.000 1.01405e-06 1.800 1.01700e-06 1.800
+ 1.01705e-06 0.000 1.02000e-06 0.000 1.02005e-06 1.800 1.02300e-06 1.800 1.02305e-06 0.000 1.02600e-06 0.000
+ 1.02605e-06 1.800 1.02900e-06 1.800 1.02905e-06 0.000 1.03200e-06 0.000 1.03205e-06 1.800 1.03500e-06 1.800
+ 1.03505e-06 0.000 1.03800e-06 0.000 1.03805e-06 1.800 1.04100e-06 1.800 1.04105e-06 0.000 1.04400e-06 0.000
+ 1.04405e-06 1.800 1.04700e-06 1.800 1.04705e-06 0.000 1.05000e-06 0.000 1.05005e-06 1.800 1.05300e-06 1.800
+ 1.05305e-06 0.000 1.05600e-06 0.000 1.05605e-06 1.800 1.05900e-06 1.800 1.05905e-06 0.000 1.06200e-06 0.000
+ 1.06205e-06 1.800 1.06500e-06 1.800 1.06505e-06 0.000 1.06800e-06 0.000 1.06805e-06 1.800 1.07100e-06 1.800
+ 1.07105e-06 0.000 1.07400e-06 0.000 1.07405e-06 1.800 1.07700e-06 1.800 1.07705e-06 0.000 1.08000e-06 0.000
+ 1.08005e-06 1.800 1.08300e-06 1.800 1.08305e-06 0.000 1.08600e-06 0.000 1.08605e-06 1.800 1.08900e-06 1.800
+ 1.08905e-06 0.000 1.09200e-06 0.000 1.09205e-06 1.800 1.09500e-06 1.800 1.09505e-06 0.000 1.09800e-06 0.000
+ 1.09805e-06 1.800 1.10100e-06 1.800 1.10105e-06 0.000 1.10400e-06 0.000 1.10405e-06 1.800 1.10700e-06 1.800
+ 1.10705e-06 0.000 1.11000e-06 0.000 1.11005e-06 1.800 1.11300e-06 1.800 1.11305e-06 0.000 1.11600e-06 0.000
+ 1.11605e-06 1.800 1.11900e-06 1.800 1.11905e-06 0.000 1.12200e-06 0.000 1.12205e-06 1.800 1.12500e-06 1.800
+ 1.12505e-06 0.000 1.12800e-06 0.000 1.12805e-06 1.800 1.13100e-06 1.800 1.13105e-06 0.000 1.13400e-06 0.000
+ 1.13405e-06 1.800 1.13700e-06 1.800 1.13705e-06 0.000 1.14000e-06 0.000 1.14005e-06 1.800 1.14300e-06 1.800
+ 1.14305e-06 0.000 1.14600e-06 0.000 1.14605e-06 1.800 1.14900e-06 1.800 1.14905e-06 0.000 1.15200e-06 0.000
+ 1.15205e-06 1.800 1.15500e-06 1.800 1.15505e-06 0.000 1.15800e-06 0.000 1.15805e-06 1.800 1.16100e-06 1.800
+ 1.16105e-06 0.000 1.16400e-06 0.000 1.16405e-06 1.800 1.16700e-06 1.800 1.16705e-06 0.000 1.17000e-06 0.000
+ 1.17005e-06 1.800 1.17300e-06 1.800 1.17305e-06 0.000 1.17600e-06 0.000 1.17605e-06 1.800 1.17900e-06 1.800
+ 1.17905e-06 0.000 1.18200e-06 0.000 1.18205e-06 1.800 1.18500e-06 1.800 1.18505e-06 0.000 1.18800e-06 0.000
+ 1.18805e-06 1.800 1.19100e-06 1.800 1.19105e-06 0.000 1.19400e-06 0.000 1.19405e-06 1.800 1.19700e-06 1.800
+ 1.19705e-06 0.000 1.20000e-06 0.000 1.20005e-06 1.800 1.20300e-06 1.800 1.20305e-06 0.000 1.20600e-06 0.000
+ 1.20605e-06 1.800 1.20900e-06 1.800 1.20905e-06 0.000 1.21200e-06 0.000 1.21205e-06 1.800 1.21500e-06 1.800
+ 1.21505e-06 0.000 1.21800e-06 0.000 1.21805e-06 1.800 1.22100e-06 1.800 1.22105e-06 0.000 1.22400e-06 0.000
+ 1.22405e-06 1.800 1.22700e-06 1.800 1.22705e-06 0.000 1.23000e-06 0.000 1.23005e-06 1.800 1.23300e-06 1.800
+ 1.23305e-06 0.000 1.23600e-06 0.000 1.23605e-06 1.800 1.23900e-06 1.800 1.23905e-06 0.000 1.24200e-06 0.000
+ 1.24205e-06 1.800 1.24500e-06 1.800 1.24505e-06 0.000 1.24800e-06 0.000 1.24805e-06 1.800 1.25100e-06 1.800
+ 1.25105e-06 0.000 1.25400e-06 0.000 1.25405e-06 1.800 1.25700e-06 1.800 1.25705e-06 0.000 1.26000e-06 0.000
+ 1.26005e-06 1.800 1.26300e-06 1.800 1.26305e-06 0.000 1.26600e-06 0.000 1.26605e-06 1.800 1.26900e-06 1.800
+ 1.26905e-06 0.000 1.27200e-06 0.000 1.27205e-06 1.800 1.27500e-06 1.800 1.27505e-06 0.000 1.27800e-06 0.000
+ 1.27805e-06 1.800 1.28100e-06 1.800 1.28105e-06 0.000 1.28400e-06 0.000 1.28405e-06 1.800 1.28700e-06 1.800
+ 1.28705e-06 0.000 1.29000e-06 0.000 1.29005e-06 1.800 1.29300e-06 1.800 1.29305e-06 0.000 1.29600e-06 0.000
+ 1.29605e-06 1.800 1.29900e-06 1.800 1.29905e-06 0.000 1.30200e-06 0.000 1.30205e-06 1.800 1.30500e-06 1.800
+ 1.30505e-06 0.000 1.30800e-06 0.000 1.30805e-06 1.800 1.31100e-06 1.800 1.31105e-06 0.000 1.31400e-06 0.000
+ 1.31405e-06 1.800 1.31700e-06 1.800 1.31705e-06 0.000 1.32000e-06 0.000 1.32005e-06 1.800 1.32300e-06 1.800
+ 1.32305e-06 0.000 1.32600e-06 0.000 1.32605e-06 1.800 1.32900e-06 1.800 1.32905e-06 0.000 1.33200e-06 0.000
+ 1.33205e-06 1.800 1.33500e-06 1.800 1.33505e-06 0.000 1.33800e-06 0.000 1.33805e-06 1.800 1.34100e-06 1.800
+ 1.34105e-06 0.000 1.34400e-06 0.000 1.34405e-06 1.800 1.34700e-06 1.800 1.34705e-06 0.000 1.35000e-06 0.000
+ 1.35005e-06 1.800 1.35300e-06 1.800 1.35305e-06 0.000 1.35600e-06 0.000 1.35605e-06 1.800 1.35900e-06 1.800
+ 1.35905e-06 0.000 1.36200e-06 0.000 1.36205e-06 1.800 1.36500e-06 1.800 1.36505e-06 0.000 1.36800e-06 0.000
+ 1.36805e-06 1.800 1.37100e-06 1.800 1.37105e-06 0.000 1.37400e-06 0.000 1.37405e-06 1.800 1.37700e-06 1.800
+ 1.37705e-06 0.000 1.38000e-06 0.000 1.38005e-06 1.800 1.38300e-06 1.800 1.38305e-06 0.000 1.38600e-06 0.000
+ 1.38605e-06 1.800 1.38900e-06 1.800 1.38905e-06 0.000 1.39200e-06 0.000 1.39205e-06 1.800 1.39500e-06 1.800
+ 1.39505e-06 0.000 1.39800e-06 0.000 1.39805e-06 1.800 1.40100e-06 1.800 1.40105e-06 0.000 1.40400e-06 0.000
+ 1.40405e-06 1.800 1.40700e-06 1.800 1.40705e-06 0.000 1.41000e-06 0.000 1.41005e-06 1.800 1.41300e-06 1.800
+ 1.41305e-06 0.000 1.41600e-06 0.000 1.41605e-06 1.800 1.41900e-06 1.800 1.41905e-06 0.000 1.42200e-06 0.000
+ 1.42205e-06 1.800 1.42500e-06 1.800 1.42505e-06 0.000 1.42800e-06 0.000 1.42805e-06 1.800 1.43100e-06 1.800
+ 1.43105e-06 0.000 1.43400e-06 0.000 1.43405e-06 1.800 1.43700e-06 1.800 1.43705e-06 0.000 1.44000e-06 0.000
+ 1.44005e-06 1.800 1.44300e-06 1.800 1.44305e-06 0.000 1.44600e-06 0.000 1.44605e-06 1.800 1.44900e-06 1.800
+ 1.44905e-06 0.000 1.45200e-06 0.000 1.45205e-06 1.800 1.45500e-06 1.800 1.45505e-06 0.000 1.45800e-06 0.000
+ 1.45805e-06 1.800 1.46100e-06 1.800 1.46105e-06 0.000 1.46400e-06 0.000 1.46405e-06 1.800 1.46700e-06 1.800
+ 1.46705e-06 0.000 1.47000e-06 0.000 1.47005e-06 1.800 1.47300e-06 1.800 1.47305e-06 0.000 1.47600e-06 0.000
+ 1.47605e-06 1.800 1.47900e-06 1.800 1.47905e-06 0.000 1.48200e-06 0.000 1.48205e-06 1.800 1.48500e-06 1.800
+ 1.48505e-06 0.000 1.48800e-06 0.000 1.48805e-06 1.800 1.49100e-06 1.800 1.49105e-06 0.000 1.49400e-06 0.000
+ 1.49405e-06 1.800 1.49700e-06 1.800 1.49705e-06 0.000 1.50000e-06 0.000 1.50005e-06 1.800 1.50300e-06 1.800
+ 1.50305e-06 0.000 1.50600e-06 0.000 1.50605e-06 1.800 1.50900e-06 1.800 1.50905e-06 0.000 1.51200e-06 0.000
+ 1.51205e-06 1.800 1.51500e-06 1.800 1.51505e-06 0.000 1.51800e-06 0.000 1.51805e-06 1.800 1.52100e-06 1.800
+ 1.52105e-06 0.000 1.52400e-06 0.000 1.52405e-06 1.800 1.52700e-06 1.800 1.52705e-06 0.000 1.53000e-06 0.000
+ 1.53005e-06 1.800 1.53300e-06 1.800 1.53305e-06 0.000 1.53600e-06 0.000 1.53605e-06 1.800 1.53900e-06 1.800
+ 1.53905e-06 0.000 1.54800e-06 0.000 1.54805e-06 1.800 1.55100e-06 1.800 1.55105e-06 0.000 1.56300e-06 0.000
+ 1.56305e-06 1.800 1.56600e-06 1.800 1.56605e-06 0.000 1.56900e-06 0.000 1.56905e-06 1.800 1.57200e-06 1.800
+ 1.57205e-06 0.000 1.57500e-06 0.000 1.57505e-06 1.800 1.57800e-06 1.800 1.57805e-06 0.000 1.58100e-06 0.000
+ 1.58105e-06 1.800 1.58400e-06 1.800 1.58405e-06 0.000 1.58700e-06 0.000 1.58705e-06 1.800 1.59300e-06 1.800
+ 1.59305e-06 0.000 1.59900e-06 0.000 1.59905e-06 1.800 1.61400e-06 1.800 1.61405e-06 0.000 1.61700e-06 0.000
+ 1.61705e-06 1.800 1.62000e-06 1.800 1.62005e-06 0.000 1.62300e-06 0.000 1.62305e-06 1.800 1.62600e-06 1.800
+ 1.62605e-06 0.000 1.62900e-06 0.000 1.62905e-06 1.800 1.63800e-06 1.800 1.63805e-06 0.000 1.65300e-06 0.000
+ 1.65305e-06 1.800 1.65600e-06 1.800 1.65605e-06 0.000 1.66200e-06 0.000 1.66205e-06 1.800 1.66500e-06 1.800
+ 1.66505e-06 0.000 1.67400e-06 0.000 1.67405e-06 1.800 1.67700e-06 1.800 1.67705e-06 0.000 1.68900e-06 0.000
+ 1.68905e-06 1.800 1.69200e-06 1.800 1.69205e-06 0.000 1.69500e-06 0.000 1.69505e-06 1.800 1.70100e-06 1.800
+ 1.70105e-06 0.000 1.70400e-06 0.000 1.70405e-06 1.800 1.70700e-06 1.800 1.70705e-06 0.000 1.71600e-06 0.000
+ 1.71605e-06 1.800 1.72500e-06 1.800 1.72505e-06 0.000 1.72800e-06 0.000 1.72805e-06 1.800 1.73400e-06 1.800
+ 1.73405e-06 0.000 1.73700e-06 0.000 1.73705e-06 1.800 1.74300e-06 1.800 1.74305e-06 0.000 1.75500e-06 0.000
+ 1.75505e-06 1.800 1.76400e-06 1.800 1.76405e-06 0.000 1.76700e-06 0.000 1.76705e-06 1.800 1.77300e-06 1.800
+ 1.77305e-06 0.000 1.77900e-06 0.000 1.77905e-06 1.800 1.78200e-06 1.800 1.78205e-06 0.000 1.79700e-06 0.000
+ 1.79705e-06 1.800 1.80600e-06 1.800 1.80605e-06 0.000 1.81200e-06 0.000 1.81205e-06 1.800 1.82700e-06 1.800
+ 1.82705e-06 0.000 1.84200e-06 0.000 1.84205e-06 1.800 1.84800e-06 1.800 1.84805e-06 0.000 1.85100e-06 0.000
+ 1.85105e-06 1.800 1.85700e-06 1.800 1.85705e-06 0.000 1.86300e-06 0.000 1.86305e-06 1.800 1.86600e-06 1.800
+ 1.86605e-06 0.000 1.86900e-06 0.000 1.86905e-06 1.800 1.87200e-06 1.800 1.87205e-06 0.000 1.88400e-06 0.000
+ 1.88405e-06 1.800 1.88700e-06 1.800 1.88705e-06 0.000 1.89000e-06 0.000 1.89005e-06 1.800 1.89300e-06 1.800
+ 1.89305e-06 0.000 1.90500e-06 0.000 1.90505e-06 1.800 1.91100e-06 1.800 1.91105e-06 0.000 1.91400e-06 0.000
+ 1.91405e-06 1.800 1.91700e-06 1.800 1.91705e-06 0.000 1.92000e-06 0.000 1.92005e-06 1.800 1.92300e-06 1.800
+ 1.92305e-06 0.000 1.93200e-06 0.000 1.93205e-06 1.800 1.93800e-06 1.800 1.93805e-06 0.000 1.94100e-06 0.000
+ 1.94105e-06 1.800 1.94400e-06 1.800 1.94405e-06 0.000 1.94700e-06 0.000 1.94705e-06 1.800 1.95000e-06 1.800
+ 1.95005e-06 0.000 1.95600e-06 0.000 1.95605e-06 1.800 1.95900e-06 1.800 1.95905e-06 0.000 1.96200e-06 0.000
+ 1.96205e-06 1.800 1.96800e-06 1.800 1.96805e-06 0.000 1.97700e-06 0.000 1.97705e-06 1.800 1.98300e-06 1.800
+ 1.98305e-06 0.000 1.99800e-06 0.000 1.99805e-06 1.800 2.00400e-06 1.800 2.00405e-06 0.000 2.00700e-06 0.000
+ 2.00705e-06 1.800 2.01000e-06 1.800 2.01005e-06 0.000 2.01300e-06 0.000 2.01305e-06 1.800 2.02500e-06 1.800
+ 2.02505e-06 0.000 2.03400e-06 0.000 2.03405e-06 1.800 2.04000e-06 1.800 2.04005e-06 0.000 2.04300e-06 0.000
+ 2.04305e-06 1.800 2.05200e-06 1.800 2.05205e-06 0.000 2.05800e-06 0.000 2.05805e-06 1.800 2.06400e-06 1.800
+ 2.06405e-06 0.000 2.06700e-06 0.000 2.06705e-06 1.800 2.07000e-06 1.800 2.07005e-06 0.000 2.07300e-06 0.000
+ 2.07305e-06 1.800 2.07600e-06 1.800 2.07605e-06 0.000 2.08200e-06 0.000 2.08205e-06 1.800 2.08800e-06 1.800
+ 2.08805e-06 0.000 2.09100e-06 0.000 2.09105e-06 1.800 2.09400e-06 1.800 2.09405e-06 0.000 2.09700e-06 0.000
+ 2.09705e-06 1.800 2.10000e-06 1.800 2.10005e-06 0.000 2.10300e-06 0.000 2.10305e-06 1.800 2.10900e-06 1.800
+ 2.10905e-06 0.000 2.11500e-06 0.000 2.11505e-06 1.800 2.12700e-06 1.800 2.12705e-06 0.000 2.13600e-06 0.000
+ 2.13605e-06 1.800 2.14200e-06 1.800 2.14205e-06 0.000 2.14500e-06 0.000 2.14505e-06 1.800 2.16300e-06 1.800
+ 2.16305e-06 0.000 2.16600e-06 0.000 2.16605e-06 1.800 2.16900e-06 1.800 2.16905e-06 0.000 2.17200e-06 0.000
+ 2.17205e-06 1.800 2.17500e-06 1.800 2.17505e-06 0.000 2.20200e-06 0.000 2.20205e-06 1.800 2.20800e-06 1.800
+ 2.20805e-06 0.000 2.21100e-06 0.000 2.21105e-06 1.800 2.21400e-06 1.800 2.21405e-06 0.000 2.21700e-06 0.000
+ 2.21705e-06 1.800 2.22300e-06 1.800 2.22305e-06 0.000 2.23200e-06 0.000 2.23205e-06 1.800 2.23500e-06 1.800
+ 2.23505e-06 0.000 2.23800e-06 0.000 2.23805e-06 1.800 2.24400e-06 1.800 2.24405e-06 0.000 2.24700e-06 0.000
+ 2.24705e-06 1.800 2.25300e-06 1.800 2.25305e-06 0.000 2.25600e-06 0.000 2.25605e-06 1.800 2.25900e-06 1.800
+ 2.25905e-06 0.000 2.27100e-06 0.000 2.27105e-06 1.800 2.27700e-06 1.800 2.27705e-06 0.000 2.28000e-06 0.000
+ 2.28005e-06 1.800 2.28600e-06 1.800 2.28605e-06 0.000 2.28900e-06 0.000 2.28905e-06 1.800 2.29800e-06 1.800
+ 2.29805e-06 0.000 2.30100e-06 0.000 2.30105e-06 1.800 2.30700e-06 1.800 2.30705e-06 0.000 2.31000e-06 0.000
+ 2.31005e-06 1.800 2.31600e-06 1.800 2.31605e-06 0.000 2.32200e-06 0.000 2.32205e-06 1.800 2.34900e-06 1.800
+ 2.34905e-06 0.000 2.35200e-06 0.000 2.35205e-06 1.800 2.35800e-06 1.800 2.35805e-06 0.000 2.36100e-06 0.000
+ 2.36105e-06 1.800 2.36700e-06 1.800 2.36705e-06 0.000 2.37000e-06 0.000 2.37005e-06 1.800 2.37300e-06 1.800
+ 2.37305e-06 0.000 2.37600e-06 0.000 2.37605e-06 1.800 2.38500e-06 1.800 2.38505e-06 0.000 2.39400e-06 0.000
+ 2.39405e-06 1.800 2.39700e-06 1.800 2.39705e-06 0.000 2.40000e-06 0.000 2.40005e-06 1.800 2.40300e-06 1.800
+ 2.40305e-06 0.000 2.41200e-06 0.000 2.41205e-06 1.800 2.41800e-06 1.800 2.41805e-06 0.000 2.43000e-06 0.000
+ 2.43005e-06 1.800 2.45100e-06 1.800 2.45105e-06 0.000 2.45400e-06 0.000 2.45405e-06 1.800 2.46000e-06 1.800
+ 2.46005e-06 0.000 2.47200e-06 0.000 2.47205e-06 1.800 2.47500e-06 1.800 2.47505e-06 0.000 2.47800e-06 0.000
+ 2.47805e-06 1.800 2.48700e-06 1.800 2.48705e-06 0.000 2.49900e-06 0.000 2.49905e-06 1.800 2.51100e-06 1.800
+ 2.51105e-06 0.000 2.51400e-06 0.000 2.51405e-06 1.800 2.52300e-06 1.800 2.52305e-06 0.000 2.52900e-06 0.000
+ 2.52905e-06 1.800 2.53200e-06 1.800 2.53205e-06 0.000 2.53800e-06 0.000 2.53805e-06 1.800 2.54100e-06 1.800
+ 2.54105e-06 0.000 2.54400e-06 0.000 2.54405e-06 1.800 2.54700e-06 1.800 2.54705e-06 0.000 2.55600e-06 0.000
+ 2.55605e-06 1.800 2.55900e-06 1.800 2.55905e-06 0.000 2.56200e-06 0.000 2.56205e-06 1.800 2.56500e-06 1.800
+ 2.56505e-06 0.000 2.57100e-06 0.000 2.57105e-06 1.800 2.57700e-06 1.800 2.57705e-06 0.000 2.58000e-06 0.000
+ 2.58005e-06 1.800 2.60400e-06 1.800 2.60405e-06 0.000 2.61300e-06 0.000 2.61305e-06 1.800 2.63100e-06 1.800
+ 2.63105e-06 0.000 2.64000e-06 0.000 2.64005e-06 1.800 2.64300e-06 1.800 2.64305e-06 0.000 2.64600e-06 0.000
+ 2.64605e-06 1.800 2.64900e-06 1.800 2.64905e-06 0.000 2.66100e-06 0.000 2.66105e-06 1.800 2.67300e-06 1.800
+ 2.67305e-06 0.000 2.67600e-06 0.000 2.67605e-06 1.800 2.67900e-06 1.800 2.67905e-06 0.000 2.68800e-06 0.000
+ 2.68805e-06 1.800 2.69100e-06 1.800 2.69105e-06 0.000 2.69400e-06 0.000 2.69405e-06 1.800 2.70000e-06 1.800
+ 2.70005e-06 0.000 2.70300e-06 0.000 2.70305e-06 1.800 2.71200e-06 1.800 2.71205e-06 0.000 2.71500e-06 0.000
+ 2.71505e-06 1.800 2.71800e-06 1.800 2.71805e-06 0.000 2.72400e-06 0.000 2.72405e-06 1.800 2.72700e-06 1.800
+ 2.72705e-06 0.000 2.73000e-06 0.000 2.73005e-06 1.800 2.73300e-06 1.800 2.73305e-06 0.000 2.73600e-06 0.000
+ 2.73605e-06 1.800 2.73900e-06 1.800 2.73905e-06 0.000 2.74200e-06 0.000 2.74205e-06 1.800 2.74800e-06 1.800
+ 2.74805e-06 0.000 2.76300e-06 0.000 2.76305e-06 1.800 2.76600e-06 1.800 2.76605e-06 0.000 2.76900e-06 0.000
+ 2.76905e-06 1.800 2.79000e-06 1.800 2.79005e-06 0.000 2.80200e-06 0.000 2.80205e-06 1.800 2.80500e-06 1.800
+ 2.80505e-06 0.000 2.80800e-06 0.000 2.80805e-06 1.800 2.81100e-06 1.800 2.81105e-06 0.000 2.82300e-06 0.000
+ 2.82305e-06 1.800 2.82600e-06 1.800 2.82605e-06 0.000 2.82900e-06 0.000 2.82905e-06 1.800 2.83800e-06 1.800
+ 2.83805e-06 0.000 2.84100e-06 0.000 2.84105e-06 1.800 2.84700e-06 1.800 2.84705e-06 0.000 2.85300e-06 0.000
+ 2.85305e-06 1.800 2.85900e-06 1.800 2.85905e-06 0.000 2.86500e-06 0.000 2.86505e-06 1.800 2.87400e-06 1.800
+ 2.87405e-06 0.000 2.88000e-06 0.000 2.88005e-06 1.800 2.88300e-06 1.800 2.88305e-06 0.000 2.88600e-06 0.000
+ 2.88605e-06 1.800 2.90100e-06 1.800 2.90105e-06 0.000 2.91000e-06 0.000 2.91005e-06 1.800 2.91300e-06 1.800
+ 2.91305e-06 0.000 2.91900e-06 0.000 2.91905e-06 1.800 2.92200e-06 1.800 2.92205e-06 0.000 2.92800e-06 0.000
+ 2.92805e-06 1.800 2.93400e-06 1.800 2.93405e-06 0.000 2.94300e-06 0.000 2.94305e-06 1.800 2.94600e-06 1.800
+ 2.94605e-06 0.000 2.94900e-06 0.000 2.94905e-06 1.800 2.95200e-06 1.800 2.95205e-06 0.000 2.96100e-06 0.000
+ 2.96105e-06 1.800 2.96400e-06 1.800 2.96405e-06 0.000 2.96700e-06 0.000 2.96705e-06 1.800 2.97300e-06 1.800
+ 2.97305e-06 0.000 2.97600e-06 0.000 2.97605e-06 1.800 2.97900e-06 1.800 2.97905e-06 0.000 2.98200e-06 0.000
+ 2.98205e-06 1.800 2.99100e-06 1.800 2.99105e-06 0.000 2.99400e-06 0.000 2.99405e-06 1.800 3.00000e-06 1.800
+ 3.00005e-06 0.000 3.01500e-06 0.000 3.01505e-06 1.800 3.01800e-06 1.800 3.01805e-06 0.000 3.02100e-06 0.000
+ 3.02105e-06 1.800 3.02400e-06 1.800 3.02405e-06 0.000 3.03000e-06 0.000 3.03005e-06 1.800 3.03300e-06 1.800
+ 3.03305e-06 0.000 3.03900e-06 0.000 3.03905e-06 1.800 3.04200e-06 1.800 3.04205e-06 0.000 3.04800e-06 0.000
+ 3.04805e-06 1.800 3.05700e-06 1.800 3.05705e-06 0.000 3.06000e-06 0.000 3.06005e-06 1.800 3.06300e-06 1.800
+ 3.06305e-06 0.000 3.07200e-06 0.000
+ )
Xd_c0 src_c0 c0 vdd gnd tb_inv
Xl_s0 s0 lo_s0 vdd gnd tb_inv
Xl_s1 s1 lo_s1 vdd gnd tb_inv
Xl_s2 s2 lo_s2 vdd gnd tb_inv
Xl_s3 s3 lo_s3 vdd gnd tb_inv
Xl_c4 c4 lo_c4 vdd gnd tb_inv
X0 a0 a1 a2 a3 b0 b1 b2 b3 c0 s0 s1 s2 s3 c4 vdd gnd cla_r_nand4
.tran 200p 3.07200e-06
.control
set wr_singlescale
set wr_vecnames
run
set curplottitle=NAME-ROLL-1.6-R_nand4-function
wrdata wave.txt v(a0) v(a1) v(a2) v(a3) v(b0) v(b1) v(b2) v(b3) v(c0) v(s0) v(s1) v(s2) v(s3) v(c4) i(VDD)
quit
.endc
.end
