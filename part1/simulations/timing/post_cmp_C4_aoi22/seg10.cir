* All-arc segment for post_cmp_C4_aoi22_post
.include ../../../spice/models/TSMC_180nm.txt
.options reltol=1e-4
VDD vdd gnd 1.8
* NGSPICE file created from top_cmp_C4_aoi22.ext - technology: scmos

.subckt top_cmp_C4_aoi22 a0 a1 a2 a3 b0 b1 b2 b3 c0 c4 s0 s1 s2 s3 vdd gnd
M1000 pg2_0/a_106_103# a2 vdd vdd CMOSP w=2.88u l=0.18u
+  ad=0.9072p pd=3.51u as=1.5552p ps=6.84u
M1001 pg2_0/a_43_103# a2 vdd vdd CMOSP w=7.02u l=0.18u
+  ad=2.2113p pd=7.65u as=3.7908p ps=15.12u
M1002 pg2_0/t2b b2 gnd Gnd CMOSN w=1.8u l=0.18u
+  ad=0.81p pd=4.5u as=0.567p ps=2.43u
M1003 pg2_0/oai2_xn1 b2 pg2_0/p2b Gnd CMOSN w=1.44u l=0.18u
+  ad=0.4536p pd=2.07u as=0.4536p ps=2.07u
M1004 vdd pg2_0/g2b pg2_0/p2b vdd CMOSP w=1.44u l=0.18u
+  ad=0.648p pd=3.78u as=0.7776p ps=3.51u
M1005 pg2_0/a_16_15# a2 pg2_0/g2b Gnd CMOSN w=1.8u l=0.18u
+  ad=0.567p pd=2.43u as=0.972p ps=4.68u
M1006 gnd pg2_0/g2b pg2_0/oai2_xn1 Gnd CMOSN w=1.44u l=0.18u
+  ad=0.648p pd=3.78u as=0.4536p ps=2.07u
M1007 pg2_0/a_70_19# a2 pg2_0/p2 Gnd CMOSN w=1.44u l=0.18u
+  ad=0.4536p pd=2.07u as=0.7776p ps=3.96u
M1008 vdd a2 pg2_0/g2b vdd CMOSP w=1.8u l=0.18u
+  ad=0.567p pd=2.43u as=0.972p ps=4.68u
M1009 pg2_0/aoi2_xp1 b2 vdd vdd CMOSP w=2.88u l=0.18u
+  ad=0.9072p pd=3.51u as=0.9072p ps=3.51u
M1010 gnd b2 pg2_0/a_16_15# Gnd CMOSN w=1.8u l=0.18u
+  ad=0.81p pd=4.5u as=0.567p ps=2.43u
M1011 pg2_0/p2b b2 pg2_0/a_106_103# vdd CMOSP w=2.88u l=0.18u
+  ad=0.7776p pd=3.51u as=0.9072p ps=3.51u
M1012 gnd b2 pg2_0/a_70_19# Gnd CMOSN w=1.44u l=0.18u
+  ad=0.3888p pd=2.07u as=0.4536p ps=2.07u
M1013 pg2_0/t2b b2 pg2_0/a_43_103# vdd CMOSP w=7.02u l=0.18u
+  ad=3.159p pd=14.94u as=2.2113p ps=7.65u
M1014 vdd a2 pg2_0/aoi2_xp1 vdd CMOSP w=2.88u l=0.18u
+  ad=0.9072p pd=3.51u as=1.5552p ps=6.84u
M1015 pg2_0/p2 pg2_0/t2b gnd Gnd CMOSN w=0.72u l=0.18u
+  ad=0.324p pd=2.34u as=0.3888p ps=2.07u
M1016 gnd a2 pg2_0/t2b Gnd CMOSN w=1.8u l=0.18u
+  ad=0.567p pd=2.43u as=0.972p ps=4.68u
M1017 pg2_0/p2b a2 pg2_0/oai2_xn1 Gnd CMOSN w=1.44u l=0.18u
+  ad=0.4536p pd=2.07u as=0.7776p ps=3.96u
M1018 pg2_0/g2b b2 vdd vdd CMOSP w=1.8u l=0.18u
+  ad=0.81p pd=4.5u as=0.567p ps=2.43u
M1019 pg2_0/p2 pg2_0/t2b pg2_0/aoi2_xp1 vdd CMOSP w=2.88u l=0.18u
+  ad=1.296p pd=6.66u as=0.9072p ps=3.51u
M1020 sum2_0/a_34_19# pg2_0/p2b s2 Gnd CMOSN w=1.44u l=0.18u
+  ad=0.4536p pd=2.07u as=0.4536p ps=2.07u
M1021 sum2_0/x2_s1xp1 sum2_0/x2_cb s2 vdd CMOSP w=2.88u l=0.18u
+  ad=0.9072p pd=3.51u as=0.9072p ps=3.51u
M1022 sum2_0/x2_cb sum2_0/c2 gnd Gnd CMOSN w=1.08u l=0.18u
+  ad=0.486p pd=3.06u as=0.4212p ps=2.07u
M1023 gnd sum2_0/x2_cb sum2_0/a_34_19# Gnd CMOSN w=1.44u l=0.18u
+  ad=0.4212p pd=2.07u as=0.4536p ps=2.07u
M1024 vdd sum2_0/c2 sum2_0/x2_cb vdd CMOSP w=2.25u l=0.18u
+  ad=0.8748p pd=3.51u as=1.215p ps=5.58u
M1025 s2 pg2_0/p2b sum2_0/x2_s1xp1 vdd CMOSP w=2.88u l=0.18u
+  ad=0.9072p pd=3.51u as=0.9072p ps=3.51u
M1026 sum2_0/a_16_19# sum2_0/c2 gnd Gnd CMOSN w=1.44u l=0.18u
+  ad=0.4536p pd=2.07u as=0.7776p ps=3.96u
M1027 vdd sum2_0/c2 sum2_0/x2_s1xp1 vdd CMOSP w=2.88u l=0.18u
+  ad=1.296p pd=6.66u as=0.9072p ps=3.51u
M1028 s2 pg2_0/p2 sum2_0/a_16_19# Gnd CMOSN w=1.44u l=0.18u
+  ad=0.4536p pd=2.07u as=0.4536p ps=2.07u
M1029 sum2_0/x2_s1xp1 pg2_0/p2 vdd vdd CMOSP w=2.88u l=0.18u
+  ad=0.9072p pd=3.51u as=0.8748p ps=3.51u
M1030 carry_0/a_34_148# pg0_0/t0b vdd vdd CMOSP w=1.8u l=0.18u
+  ad=0.567p pd=2.43u as=0.972p ps=4.68u
M1031 gnd pg2_0/g2b carry_0/g2 Gnd CMOSN w=0.9u l=0.18u
+  ad=0.405p pd=2.7u as=0.486p ps=2.88u
M1032 carry_0/t1_0 pg0_0/t0b carry_0/a_106_148# vdd CMOSP w=5.58u l=0.18u
+  ad=2.511p pd=12.06u as=1.7577p ps=6.21u
M1033 sum2_0/c2 carry_0/t1_0b carry_0/a_169_148# vdd CMOSP w=3.6u l=0.18u
+  ad=0.972p pd=4.23u as=1.134p ps=4.23u
M1034 carry_0/g30_xp1 carry_0/g3_2 vdd vdd CMOSP w=1.44u l=0.18u
+  ad=0.4536p pd=2.07u as=0.7776p ps=3.96u
M1035 carry_0/a_466_148# carry_0/c0b vdd vdd CMOSP w=2.88u l=0.18u
+  ad=0.9072p pd=3.51u as=1.5552p ps=6.84u
M1036 sum3_0/c3 carry_0/t2_0b carry_0/a_304_148# vdd CMOSP w=3.6u l=0.18u
+  ad=0.972p pd=4.23u as=1.134p ps=4.23u
M1037 carry_0/a_376_148# pg3_0/t3b vdd vdd CMOSP w=2.88u l=0.18u
+  ad=0.9072p pd=3.51u as=1.5552p ps=6.84u
M1038 carry_0/g2_0b carry_0/g1_0 carry_0/a_250_15# Gnd CMOSN w=1.8u l=0.18u
+  ad=0.81p pd=4.5u as=0.567p ps=2.43u
M1039 carry_0/t1_0 pg0_0/t0b gnd Gnd CMOSN w=1.44u l=0.18u
+  ad=0.648p pd=3.78u as=0.4536p ps=2.07u
M1040 gnd carry_0/c0b carry_0/c3_xn1 Gnd CMOSN w=1.8u l=0.18u
+  ad=0.567p pd=2.43u as=0.972p ps=4.68u
M1041 vdd pg0_0/g0b sum1_0/c1 vdd CMOSP w=0.9u l=0.18u
+  ad=0.405p pd=2.7u as=0.486p ps=2.43u
M1042 vdd pg2_0/t2b carry_0/t2 vdd CMOSP w=3.51u l=0.18u
+  ad=1.5795p pd=7.92u as=1.8954p ps=8.1u
M1043 carry_0/t2_0b carry_0/t1_0 vdd vdd CMOSP w=1.8u l=0.18u
+  ad=0.81p pd=4.5u as=0.567p ps=2.43u
M1044 vdd carry_0/g1_0 carry_0/g1_0b vdd CMOSP w=1.8u l=0.18u
+  ad=0.81p pd=4.5u as=0.972p ps=4.68u
M1045 vdd carry_0/g3_0b c4 vdd CMOSP w=1.44u l=0.18u
+  ad=0.648p pd=3.78u as=0.7776p ps=3.51u
M1046 carry_0/g3_0b carry_0/g1_0 carry_0/a_412_27# Gnd CMOSN w=0.72u l=0.18u
+  ad=0.324p pd=2.34u as=0.2268p ps=1.35u
M1047 carry_0/g30_xp1 carry_0/g1_0 carry_0/g3_0b vdd CMOSP w=1.44u l=0.18u
+  ad=0.648p pd=3.78u as=0.4536p ps=2.07u
M1048 gnd carry_0/c0b carry_0/c4g_xn1 Gnd CMOSN w=1.44u l=0.18u
+  ad=0.4536p pd=2.07u as=0.7776p ps=3.96u
M1049 carry_0/g20_xp1 carry_0/g2 vdd vdd CMOSP w=3.6u l=0.18u
+  ad=1.134p pd=4.23u as=1.944p ps=8.28u
M1050 carry_0/a_70_148# pg0_0/g0b vdd vdd CMOSP w=4.5u l=0.18u
+  ad=1.4175p pd=5.13u as=2.43p ps=10.08u
M1051 vdd carry_0/t1_0 carry_0/t1_0b vdd CMOSP w=1.8u l=0.18u
+  ad=0.81p pd=4.5u as=0.972p ps=4.68u
M1052 vdd carry_0/t3_2 carry_0/t3_0b vdd CMOSP w=0.72u l=0.18u
+  ad=0.2268p pd=1.35u as=0.3888p ps=2.52u
M1053 carry_0/g1_0 pg0_0/g0b carry_0/g10_xn1 Gnd CMOSN w=2.25u l=0.18u
+  ad=0.7047p pd=2.88u as=1.215p ps=5.58u
M1054 carry_0/c3_xn1 carry_0/t2_0b gnd Gnd CMOSN w=1.8u l=0.18u
+  ad=0.567p pd=2.43u as=0.567p ps=2.43u
M1055 gnd carry_0/g2 carry_0/g2_0b Gnd CMOSN w=0.9u l=0.18u
+  ad=0.5265p pd=2.43u as=0.486p ps=2.88u
M1056 carry_0/g3_2 pg2_0/g2b carry_0/a_340_148# vdd CMOSP w=3.6u l=0.18u
+  ad=0.972p pd=4.23u as=1.134p ps=4.23u
M1057 sum1_0/c1 pg0_0/t0b carry_0/c1_xn1 Gnd CMOSN w=0.9u l=0.18u
+  ad=0.2835p pd=1.53u as=0.486p ps=2.88u
M1058 carry_0/g20_xp1 carry_0/g1_0 carry_0/g2_0b vdd CMOSP w=3.6u l=0.18u
+  ad=1.62p pd=8.1u as=1.134p ps=4.23u
M1059 carry_0/g3_2 pg3_0/t3b carry_0/g32_xn1 Gnd CMOSN w=1.8u l=0.18u
+  ad=0.567p pd=2.43u as=0.972p ps=4.68u
M1060 carry_0/c4g_xn1 carry_0/t3_0b gnd Gnd CMOSN w=1.44u l=0.18u
+  ad=0.4536p pd=2.07u as=0.4536p ps=2.07u
M1061 vdd pg1_0/g1b carry_0/g1_0 vdd CMOSP w=2.25u l=0.18u
+  ad=1.0125p pd=5.4u as=1.215p ps=5.13u
M1062 carry_0/a_106_148# pg1_0/t1b vdd vdd CMOSP w=5.58u l=0.18u
+  ad=1.7577p pd=6.21u as=3.0132p ps=12.24u
M1063 carry_0/a_169_148# carry_0/c0b vdd vdd CMOSP w=3.6u l=0.18u
+  ad=1.134p pd=4.23u as=1.944p ps=8.28u
M1064 carry_0/a_412_27# carry_0/t3_2 gnd Gnd CMOSN w=0.72u l=0.18u
+  ad=0.2268p pd=1.35u as=0.2106p ps=1.35u
M1065 carry_0/a_304_148# carry_0/c0b vdd vdd CMOSP w=3.6u l=0.18u
+  ad=1.134p pd=4.23u as=1.944p ps=8.28u
M1066 gnd carry_0/c0b carry_0/c2_xn1 Gnd CMOSN w=1.8u l=0.18u
+  ad=0.567p pd=2.43u as=0.972p ps=4.68u
M1067 carry_0/a_277_15# carry_0/t2 carry_0/t2_0b Gnd CMOSN w=1.8u l=0.18u
+  ad=0.567p pd=2.43u as=0.972p ps=4.68u
M1068 vdd carry_0/t2 carry_0/t2_0b vdd CMOSP w=1.8u l=0.18u
+  ad=0.567p pd=2.43u as=0.972p ps=4.68u
M1069 carry_0/g10_xn1 pg1_0/t1b carry_0/g1_0 Gnd CMOSN w=2.25u l=0.18u
+  ad=0.7047p pd=2.88u as=0.7047p ps=2.88u
M1070 sum3_0/c3 carry_0/g2_0b carry_0/c3_xn1 Gnd CMOSN w=1.8u l=0.18u
+  ad=0.81p pd=4.5u as=0.567p ps=2.43u
M1071 sum1_0/c1 carry_0/c0b carry_0/a_34_148# vdd CMOSP w=1.8u l=0.18u
+  ad=0.486p pd=2.43u as=0.567p ps=2.43u
M1072 carry_0/a_439_27# carry_0/t3_2 carry_0/t3_0b Gnd CMOSN w=0.72u l=0.18u
+  ad=0.2268p pd=1.35u as=0.3888p ps=2.52u
M1073 vdd carry_0/g1_0b sum2_0/c2 vdd CMOSP w=1.8u l=0.18u
+  ad=0.81p pd=4.5u as=0.972p ps=4.23u
M1074 carry_0/g3_0b carry_0/t3_2 carry_0/g30_xp1 vdd CMOSP w=1.44u l=0.18u
+  ad=0.4536p pd=2.07u as=0.4536p ps=2.07u
M1075 c4 carry_0/t3_0b carry_0/a_466_148# vdd CMOSP w=2.88u l=0.18u
+  ad=0.7776p pd=3.51u as=0.9072p ps=3.51u
M1076 carry_0/c1_xn1 carry_0/c0b sum1_0/c1 Gnd CMOSN w=0.9u l=0.18u
+  ad=0.2835p pd=1.53u as=0.2835p ps=1.53u
M1077 vdd carry_0/g2_0b sum3_0/c3 vdd CMOSP w=1.8u l=0.18u
+  ad=0.81p pd=4.5u as=0.972p ps=4.23u
M1078 carry_0/t3_2 pg2_0/t2b carry_0/a_376_148# vdd CMOSP w=2.88u l=0.18u
+  ad=1.296p pd=6.66u as=0.9072p ps=3.51u
M1079 carry_0/g32_xn1 pg2_0/g2b carry_0/g3_2 Gnd CMOSN w=1.8u l=0.18u
+  ad=0.567p pd=2.43u as=0.567p ps=2.43u
M1080 c4 carry_0/g3_0b carry_0/c4g_xn1 Gnd CMOSN w=1.44u l=0.18u
+  ad=0.648p pd=3.78u as=0.4536p ps=2.07u
M1081 gnd pg3_0/t3b carry_0/t3_2 Gnd CMOSN w=0.72u l=0.18u
+  ad=0.2268p pd=1.35u as=0.3888p ps=2.52u
M1082 gnd pg1_0/g1b carry_0/g10_xn1 Gnd CMOSN w=2.25u l=0.18u
+  ad=1.0125p pd=5.4u as=0.7047p ps=2.88u
M1083 carry_0/c2_xn1 carry_0/t1_0b gnd Gnd CMOSN w=1.8u l=0.18u
+  ad=0.567p pd=2.43u as=0.567p ps=2.43u
M1084 gnd carry_0/t1_0 carry_0/a_277_15# Gnd CMOSN w=1.8u l=0.18u
+  ad=0.81p pd=4.5u as=0.567p ps=2.43u
M1085 gnd carry_0/t1_0 carry_0/t1_0b Gnd CMOSN w=0.9u l=0.18u
+  ad=0.405p pd=2.7u as=0.486p ps=2.88u
M1086 gnd pg2_0/t2b carry_0/t2 Gnd CMOSN w=1.8u l=0.18u
+  ad=0.81p pd=4.5u as=0.972p ps=4.68u
M1087 gnd carry_0/t1_0 carry_0/a_439_27# Gnd CMOSN w=0.72u l=0.18u
+  ad=0.324p pd=2.34u as=0.2268p ps=1.35u
M1088 carry_0/a_340_148# pg3_0/t3b vdd vdd CMOSP w=3.6u l=0.18u
+  ad=1.134p pd=4.23u as=1.944p ps=8.28u
M1089 gnd pg0_0/g0b carry_0/c1_xn1 Gnd CMOSN w=0.9u l=0.18u
+  ad=0.405p pd=2.7u as=0.2835p ps=1.53u
M1090 carry_0/g2_0b carry_0/t2 carry_0/g20_xp1 vdd CMOSP w=3.6u l=0.18u
+  ad=1.134p pd=4.23u as=1.134p ps=4.23u
M1091 carry_0/a_250_15# carry_0/t2 gnd Gnd CMOSN w=1.8u l=0.18u
+  ad=0.567p pd=2.43u as=0.5265p ps=2.43u
M1092 gnd pg3_0/g3b carry_0/g32_xn1 Gnd CMOSN w=1.8u l=0.18u
+  ad=0.81p pd=4.5u as=0.567p ps=2.43u
M1093 carry_0/t3_2 pg2_0/t2b gnd Gnd CMOSN w=0.72u l=0.18u
+  ad=0.324p pd=2.34u as=0.2268p ps=1.35u
M1094 vdd c0 carry_0/c0b vdd CMOSP w=1.8u l=0.18u
+  ad=0.81p pd=4.5u as=0.972p ps=4.68u
M1095 carry_0/g1_0 pg1_0/t1b carry_0/a_70_148# vdd CMOSP w=4.5u l=0.18u
+  ad=1.215p pd=5.13u as=1.4175p ps=5.13u
M1096 gnd carry_0/g1_0 carry_0/g1_0b Gnd CMOSN w=0.9u l=0.18u
+  ad=0.405p pd=2.7u as=0.486p ps=2.88u
M1097 carry_0/t3_0b carry_0/t1_0 vdd vdd CMOSP w=0.72u l=0.18u
+  ad=0.324p pd=2.34u as=0.2268p ps=1.35u
M1098 gnd pg1_0/t1b carry_0/t1_0 Gnd CMOSN w=1.44u l=0.18u
+  ad=0.4536p pd=2.07u as=0.7776p ps=3.96u
M1099 gnd carry_0/g3_2 carry_0/g3_0b Gnd CMOSN w=0.36u l=0.18u
+  ad=0.2106p pd=1.35u as=0.1944p ps=1.8u
M1100 vdd pg3_0/g3b carry_0/g3_2 vdd CMOSP w=1.8u l=0.18u
+  ad=0.81p pd=4.5u as=0.972p ps=4.23u
M1101 gnd c0 carry_0/c0b Gnd CMOSN w=0.9u l=0.18u
+  ad=0.405p pd=2.7u as=0.486p ps=2.88u
M1102 sum2_0/c2 carry_0/g1_0b carry_0/c2_xn1 Gnd CMOSN w=1.8u l=0.18u
+  ad=0.81p pd=4.5u as=0.567p ps=2.43u
M1103 vdd pg2_0/g2b carry_0/g2 vdd CMOSP w=1.8u l=0.18u
+  ad=0.81p pd=4.5u as=0.972p ps=4.68u
M1104 pg0_0/a_106_103# a0 vdd vdd CMOSP w=1.44u l=0.18u
+  ad=0.4536p pd=2.07u as=0.7776p ps=3.96u
M1105 pg0_0/a_43_103# a0 vdd vdd CMOSP w=5.58u l=0.18u
+  ad=1.7577p pd=6.21u as=3.0132p ps=12.24u
M1106 vdd pg0_0/g0b pg0_0/p0b vdd CMOSP w=0.72u l=0.18u
+  ad=0.324p pd=2.34u as=0.3888p ps=2.07u
M1107 pg0_0/oai0_xn1 b0 pg0_0/p0b Gnd CMOSN w=0.72u l=0.18u
+  ad=0.2268p pd=1.35u as=0.2268p ps=1.35u
M1108 gnd a0 pg0_0/t0b Gnd CMOSN w=1.44u l=0.18u
+  ad=0.4536p pd=2.07u as=0.7776p ps=3.96u
M1109 gnd pg0_0/g0b pg0_0/oai0_xn1 Gnd CMOSN w=0.72u l=0.18u
+  ad=0.324p pd=2.34u as=0.2268p ps=1.35u
M1110 pg0_0/a_70_27# a0 pg0_0/p0 Gnd CMOSN w=0.72u l=0.18u
+  ad=0.2268p pd=1.35u as=0.3888p ps=2.52u
M1111 vdd a0 pg0_0/g0b vdd CMOSP w=2.25u l=0.18u
+  ad=0.7047p pd=2.88u as=1.215p ps=5.58u
M1112 pg0_0/aoi0_xp1 b0 vdd vdd CMOSP w=1.44u l=0.18u
+  ad=0.4536p pd=2.07u as=0.4536p ps=2.07u
M1113 pg0_0/t0b b0 gnd Gnd CMOSN w=1.44u l=0.18u
+  ad=0.648p pd=3.78u as=0.4536p ps=2.07u
M1114 pg0_0/p0 pg0_0/t0b gnd Gnd CMOSN w=0.36u l=0.18u
+  ad=0.162p pd=1.62u as=0.1944p ps=1.35u
M1115 pg0_0/p0b b0 pg0_0/a_106_103# vdd CMOSP w=1.44u l=0.18u
+  ad=0.3888p pd=2.07u as=0.4536p ps=2.07u
M1116 pg0_0/a_16_10# a0 pg0_0/g0b Gnd CMOSN w=2.25u l=0.18u
+  ad=0.7047p pd=2.88u as=1.215p ps=5.58u
M1117 gnd b0 pg0_0/a_70_27# Gnd CMOSN w=0.72u l=0.18u
+  ad=0.1944p pd=1.35u as=0.2268p ps=1.35u
M1118 pg0_0/t0b b0 pg0_0/a_43_103# vdd CMOSP w=5.58u l=0.18u
+  ad=2.511p pd=12.06u as=1.7577p ps=6.21u
M1119 gnd b0 pg0_0/a_16_10# Gnd CMOSN w=2.25u l=0.18u
+  ad=1.0125p pd=5.4u as=0.7047p ps=2.88u
M1120 vdd a0 pg0_0/aoi0_xp1 vdd CMOSP w=1.44u l=0.18u
+  ad=0.4536p pd=2.07u as=0.7776p ps=3.96u
M1121 pg0_0/p0b a0 pg0_0/oai0_xn1 Gnd CMOSN w=0.72u l=0.18u
+  ad=0.2268p pd=1.35u as=0.3888p ps=2.52u
M1122 pg0_0/g0b b0 vdd vdd CMOSP w=2.25u l=0.18u
+  ad=1.0125p pd=5.4u as=0.7047p ps=2.88u
M1123 pg0_0/p0 pg0_0/t0b pg0_0/aoi0_xp1 vdd CMOSP w=1.44u l=0.18u
+  ad=0.648p pd=3.78u as=0.4536p ps=2.07u
M1124 sum0_0/x0_s1xp1 sum0_0/x0_cb s0 vdd CMOSP w=4.5u l=0.18u
+  ad=1.4175p pd=5.13u as=1.4175p ps=5.13u
M1125 gnd sum0_0/x0_cb sum0_0/a_34_10# Gnd CMOSN w=2.25u l=0.18u
+  ad=0.5427p pd=2.88u as=0.7047p ps=2.88u
M1126 vdd c0 sum0_0/x0_cb vdd CMOSP w=0.9u l=0.18u
+  ad=1.2555p pd=5.13u as=0.486p ps=2.88u
M1127 s0 pg0_0/p0b sum0_0/x0_s1xp1 vdd CMOSP w=4.5u l=0.18u
+  ad=1.4175p pd=5.13u as=1.4175p ps=5.13u
M1128 sum0_0/a_16_10# c0 gnd Gnd CMOSN w=2.25u l=0.18u
+  ad=0.7047p pd=2.88u as=1.215p ps=5.58u
M1129 vdd c0 sum0_0/x0_s1xp1 vdd CMOSP w=4.5u l=0.18u
+  ad=2.025p pd=9.9u as=1.4175p ps=5.13u
M1130 s0 pg0_0/p0 sum0_0/a_16_10# Gnd CMOSN w=2.25u l=0.18u
+  ad=0.7047p pd=2.88u as=0.7047p ps=2.88u
M1131 sum0_0/x0_cb c0 gnd Gnd CMOSN w=0.45u l=0.18u
+  ad=0.2025p pd=1.8u as=0.5427p ps=2.88u
M1132 sum0_0/x0_s1xp1 pg0_0/p0 vdd vdd CMOSP w=4.5u l=0.18u
+  ad=1.4175p pd=5.13u as=1.2555p ps=5.13u
M1133 sum0_0/a_34_10# pg0_0/p0b s0 Gnd CMOSN w=2.25u l=0.18u
+  ad=0.7047p pd=2.88u as=0.7047p ps=2.88u
M1134 pg3_0/a_106_103# a3 vdd vdd CMOSP w=3.6u l=0.18u
+  ad=1.134p pd=4.23u as=1.944p ps=8.28u
M1135 pg3_0/a_70_15# a3 pg3_0/p3 Gnd CMOSN w=1.8u l=0.18u
+  ad=0.567p pd=2.43u as=0.972p ps=4.68u
M1136 pg3_0/a_43_103# a3 vdd vdd CMOSP w=4.5u l=0.18u
+  ad=1.4175p pd=5.13u as=2.43p ps=10.08u
M1137 vdd pg3_0/g3b pg3_0/p3b vdd CMOSP w=1.8u l=0.18u
+  ad=0.81p pd=4.5u as=0.972p ps=4.23u
M1138 pg3_0/t3b b3 gnd Gnd CMOSN w=1.08u l=0.18u
+  ad=0.486p pd=3.06u as=0.3402p ps=1.71u
M1139 pg3_0/p3 pg3_0/t3b gnd Gnd CMOSN w=0.9u l=0.18u
+  ad=0.405p pd=2.7u as=0.486p ps=2.43u
M1140 gnd b3 pg3_0/a_70_15# Gnd CMOSN w=1.8u l=0.18u
+  ad=0.486p pd=2.43u as=0.567p ps=2.43u
M1141 pg3_0/a_16_15# a3 pg3_0/g3b Gnd CMOSN w=1.8u l=0.18u
+  ad=0.567p pd=2.43u as=0.972p ps=4.68u
M1142 vdd a3 pg3_0/g3b vdd CMOSP w=1.8u l=0.18u
+  ad=0.567p pd=2.43u as=0.972p ps=4.68u
M1143 pg3_0/aoi3_xp1 b3 vdd vdd CMOSP w=3.6u l=0.18u
+  ad=1.134p pd=4.23u as=1.134p ps=4.23u
M1144 gnd b3 pg3_0/a_16_15# Gnd CMOSN w=1.8u l=0.18u
+  ad=0.81p pd=4.5u as=0.567p ps=2.43u
M1145 pg3_0/p3b a3 pg3_0/oai3_xn1 Gnd CMOSN w=1.8u l=0.18u
+  ad=0.567p pd=2.43u as=0.972p ps=4.68u
M1146 pg3_0/p3b b3 pg3_0/a_106_103# vdd CMOSP w=3.6u l=0.18u
+  ad=0.972p pd=4.23u as=1.134p ps=4.23u
M1147 pg3_0/t3b b3 pg3_0/a_43_103# vdd CMOSP w=4.5u l=0.18u
+  ad=2.025p pd=9.9u as=1.4175p ps=5.13u
M1148 pg3_0/oai3_xn1 b3 pg3_0/p3b Gnd CMOSN w=1.8u l=0.18u
+  ad=0.567p pd=2.43u as=0.567p ps=2.43u
M1149 vdd a3 pg3_0/aoi3_xp1 vdd CMOSP w=3.6u l=0.18u
+  ad=1.134p pd=4.23u as=1.944p ps=8.28u
M1150 gnd a3 pg3_0/t3b Gnd CMOSN w=1.08u l=0.18u
+  ad=0.3402p pd=1.71u as=0.5832p ps=3.24u
M1151 pg3_0/g3b b3 vdd vdd CMOSP w=1.8u l=0.18u
+  ad=0.81p pd=4.5u as=0.567p ps=2.43u
M1152 pg3_0/p3 pg3_0/t3b pg3_0/aoi3_xp1 vdd CMOSP w=3.6u l=0.18u
+  ad=1.62p pd=8.1u as=1.134p ps=4.23u
M1153 gnd pg3_0/g3b pg3_0/oai3_xn1 Gnd CMOSN w=1.8u l=0.18u
+  ad=0.81p pd=4.5u as=0.567p ps=2.43u
M1154 sum3_0/x3_s1xp1 sum3_0/x3_cb s3 vdd CMOSP w=1.8u l=0.18u
+  ad=0.567p pd=2.43u as=0.567p ps=2.43u
M1155 s3 pg3_0/p3 sum3_0/a_16_25# Gnd CMOSN w=0.9u l=0.18u
+  ad=0.2835p pd=1.53u as=0.2835p ps=1.53u
M1156 sum3_0/a_34_25# pg3_0/p3b s3 Gnd CMOSN w=0.9u l=0.18u
+  ad=0.2835p pd=1.53u as=0.2835p ps=1.53u
M1157 vdd sum3_0/c3 sum3_0/x3_cb vdd CMOSP w=1.8u l=0.18u
+  ad=0.567p pd=2.43u as=0.972p ps=4.68u
M1158 s3 pg3_0/p3b sum3_0/x3_s1xp1 vdd CMOSP w=1.8u l=0.18u
+  ad=0.567p pd=2.43u as=0.567p ps=2.43u
M1159 gnd sum3_0/x3_cb sum3_0/a_34_25# Gnd CMOSN w=0.9u l=0.18u
+  ad=0.2835p pd=1.53u as=0.2835p ps=1.53u
M1160 vdd sum3_0/c3 sum3_0/x3_s1xp1 vdd CMOSP w=1.8u l=0.18u
+  ad=0.81p pd=4.5u as=0.567p ps=2.43u
M1161 sum3_0/x3_cb sum3_0/c3 gnd Gnd CMOSN w=0.9u l=0.18u
+  ad=0.405p pd=2.7u as=0.2835p ps=1.53u
M1162 sum3_0/a_16_25# sum3_0/c3 gnd Gnd CMOSN w=0.9u l=0.18u
+  ad=0.2835p pd=1.53u as=0.486p ps=2.88u
M1163 sum3_0/x3_s1xp1 pg3_0/p3 vdd vdd CMOSP w=1.8u l=0.18u
+  ad=0.567p pd=2.43u as=0.567p ps=2.43u
M1164 pg1_0/a_106_103# a1 vdd vdd CMOSP w=1.44u l=0.18u
+  ad=0.4536p pd=2.07u as=0.7776p ps=3.96u
M1165 pg1_0/a_43_103# a1 vdd vdd CMOSP w=7.02u l=0.18u
+  ad=2.2113p pd=7.65u as=3.7908p ps=15.12u
M1166 pg1_0/t1b b1 gnd Gnd CMOSN w=1.8u l=0.18u
+  ad=0.81p pd=4.5u as=0.567p ps=2.43u
M1167 vdd pg1_0/g1b pg1_0/p1b vdd CMOSP w=0.72u l=0.18u
+  ad=0.324p pd=2.34u as=0.3888p ps=2.07u
M1168 pg1_0/oai1_xn1 b1 pg1_0/p1b Gnd CMOSN w=0.72u l=0.18u
+  ad=0.2268p pd=1.35u as=0.2268p ps=1.35u
M1169 gnd pg1_0/g1b pg1_0/oai1_xn1 Gnd CMOSN w=0.72u l=0.18u
+  ad=0.324p pd=2.34u as=0.2268p ps=1.35u
M1170 pg1_0/a_70_27# a1 pg1_0/p1 Gnd CMOSN w=0.72u l=0.18u
+  ad=0.2268p pd=1.35u as=0.3888p ps=2.52u
M1171 vdd a1 pg1_0/g1b vdd CMOSP w=1.44u l=0.18u
+  ad=0.4536p pd=2.07u as=0.7776p ps=3.96u
M1172 pg1_0/aoi1_xp1 b1 vdd vdd CMOSP w=1.44u l=0.18u
+  ad=0.4536p pd=2.07u as=0.4536p ps=2.07u
M1173 pg1_0/p1 pg1_0/t1b gnd Gnd CMOSN w=0.36u l=0.18u
+  ad=0.162p pd=1.62u as=0.1944p ps=1.35u
M1174 pg1_0/p1b b1 pg1_0/a_106_103# vdd CMOSP w=1.44u l=0.18u
+  ad=0.3888p pd=2.07u as=0.4536p ps=2.07u
M1175 pg1_0/a_16_19# a1 pg1_0/g1b Gnd CMOSN w=1.44u l=0.18u
+  ad=0.4536p pd=2.07u as=0.7776p ps=3.96u
M1176 gnd b1 pg1_0/a_70_27# Gnd CMOSN w=0.72u l=0.18u
+  ad=0.1944p pd=1.35u as=0.2268p ps=1.35u
M1177 pg1_0/t1b b1 pg1_0/a_43_103# vdd CMOSP w=7.02u l=0.18u
+  ad=3.159p pd=14.94u as=2.2113p ps=7.65u
M1178 vdd a1 pg1_0/aoi1_xp1 vdd CMOSP w=1.44u l=0.18u
+  ad=0.4536p pd=2.07u as=0.7776p ps=3.96u
M1179 gnd b1 pg1_0/a_16_19# Gnd CMOSN w=1.44u l=0.18u
+  ad=0.648p pd=3.78u as=0.4536p ps=2.07u
M1180 gnd a1 pg1_0/t1b Gnd CMOSN w=1.8u l=0.18u
+  ad=0.567p pd=2.43u as=0.972p ps=4.68u
M1181 pg1_0/p1b a1 pg1_0/oai1_xn1 Gnd CMOSN w=0.72u l=0.18u
+  ad=0.2268p pd=1.35u as=0.3888p ps=2.52u
M1182 pg1_0/g1b b1 vdd vdd CMOSP w=1.44u l=0.18u
+  ad=0.648p pd=3.78u as=0.4536p ps=2.07u
M1183 pg1_0/p1 pg1_0/t1b pg1_0/aoi1_xp1 vdd CMOSP w=1.44u l=0.18u
+  ad=0.648p pd=3.78u as=0.4536p ps=2.07u
M1184 sum1_0/x1_s1xp1 sum1_0/x1_cb s1 vdd CMOSP w=3.6u l=0.18u
+  ad=1.134p pd=4.23u as=1.134p ps=4.23u
M1185 sum1_0/x1_cb sum1_0/c1 gnd Gnd CMOSN w=0.54u l=0.18u
+  ad=0.243p pd=1.98u as=0.4536p ps=2.43u
M1186 sum1_0/a_16_15# sum1_0/c1 gnd Gnd CMOSN w=1.8u l=0.18u
+  ad=0.567p pd=2.43u as=0.972p ps=4.68u
M1187 vdd sum1_0/c1 sum1_0/x1_cb vdd CMOSP w=1.17u l=0.18u
+  ad=1.0206p pd=4.23u as=0.6318p ps=3.42u
M1188 s1 pg1_0/p1 sum1_0/a_16_15# Gnd CMOSN w=1.8u l=0.18u
+  ad=0.567p pd=2.43u as=0.567p ps=2.43u
M1189 s1 pg1_0/p1b sum1_0/x1_s1xp1 vdd CMOSP w=3.6u l=0.18u
+  ad=1.134p pd=4.23u as=1.134p ps=4.23u
M1190 vdd sum1_0/c1 sum1_0/x1_s1xp1 vdd CMOSP w=3.6u l=0.18u
+  ad=1.62p pd=8.1u as=1.134p ps=4.23u
M1191 sum1_0/a_34_15# pg1_0/p1b s1 Gnd CMOSN w=1.8u l=0.18u
+  ad=0.567p pd=2.43u as=0.567p ps=2.43u
M1192 gnd sum1_0/x1_cb sum1_0/a_34_15# Gnd CMOSN w=1.8u l=0.18u
+  ad=0.4536p pd=2.43u as=0.567p ps=2.43u
M1193 sum1_0/x1_s1xp1 pg1_0/p1 vdd vdd CMOSP w=3.6u l=0.18u
+  ad=1.134p pd=4.23u as=1.0206p ps=4.23u
C0 carry_0/g1_0 carry_0/c2_xn1 0.01921f
C1 carry_0/c0b carry_0/c3_xn1 0.16844f
C2 pg2_0/p2b sum2_0/c2 0.01832f
C3 vdd pg1_0/aoi1_xp1 0.28719f
C4 c4 pg1_0/g1b 0.01789f
C5 c0 pg1_0/g1b 0.56013f
C6 carry_0/t3_0b vdd 0.23912f
C7 carry_0/t2 gnd 0.33323f
C8 carry_0/c2_xn1 c0 0.03224f
C9 pg2_0/p2b carry_0/g1_0 0.00113f
C10 pg2_0/t2b carry_0/t1_0 0.02749f
C11 sum2_0/a_34_19# s2 0
C12 vdd pg0_0/p0b 0.18075f
C13 pg0_0/oai0_xn1 gnd 0.06612f
C14 a0 pg0_0/p0 0.02977f
C15 b0 pg0_0/t0b 0.88516f
C16 sum3_0/c3 gnd 0.0084f
C17 carry_0/c0b pg1_0/g1b 0.03767f
C18 pg1_0/p1b sum1_0/x1_s1xp1 0.27828f
C19 pg2_0/p2b c0 0.00516f
C20 pg2_0/g2b sum2_0/c2 0
C21 carry_0/c0b carry_0/c2_xn1 0.16876f
C22 carry_0/g20_xp1 carry_0/g2_0b 1.17684f
C23 vdd s3 0.01113f
C24 pg2_0/p2 pg3_0/g3b 0
C25 carry_0/a_466_148# c4 0
C26 carry_0/g1_0b gnd 0.08297f
C27 carry_0/a_304_148# vdd 0
C28 pg2_0/t2b pg3_0/t3b 0.83392f
C29 sum3_0/a_16_25# s3 0
C30 pg2_0/p2b carry_0/c0b 0.00113f
C31 pg2_0/g2b carry_0/g1_0 0.02684f
C32 sum2_0/x2_cb s2 0.08563f
C33 pg0_0/a_70_27# pg0_0/p0 0
C34 a0 b0 1.92212f
C35 vdd pg0_0/g0b 0.7287f
C36 carry_0/g30_xp1 pg3_0/t3b 0.00599f
C37 c0 sum0_0/a_34_10# 0
C38 carry_0/g3_0b pg3_0/g3b 0.08891f
C39 pg2_0/aoi2_xp1 vdd 0.55295f
C40 carry_0/t2 carry_0/g20_xp1 0.01377f
C41 carry_0/g2 carry_0/g2_0b 0.02101f
C42 pg2_0/g2b c0 0.02266f
C43 carry_0/t1_0 carry_0/t3_0b 0.02115f
C44 carry_0/g1_0 carry_0/t3_2 0.98539f
C45 gnd pg3_0/p3b 0.00136f
C46 carry_0/t1_0 pg0_0/p0b 0.00421f
C47 carry_0/t2_0b vdd 0.53741f
C48 carry_0/t3_2 c0 0.0502f
C49 pg2_0/g2b carry_0/c0b 0.02748f
C50 pg2_0/p2 s2 0.15917f
C51 pg0_0/a_16_10# pg0_0/g0b 0
C52 pg0_0/aoi0_xp1 pg0_0/p0 0.48602f
C53 pg0_0/oai0_xn1 a0 0.02027f
C54 sum1_0/c1 gnd 0.0053f
C55 c0 sum0_0/x0_cb 0.70524f
C56 pg1_0/t1b pg1_0/p1 0.57863f
C57 pg1_0/g1b pg1_0/p1b 0.08772f
C58 carry_0/c0b carry_0/t3_2 0.1748f
C59 carry_0/g1_0 carry_0/g3_2 0.01874f
C60 carry_0/g2 carry_0/t2 0.40008f
C61 gnd pg3_0/g3b 0.00676f
C62 carry_0/a_250_15# pg1_0/p1 0
C63 carry_0/c3_xn1 pg1_0/g1b 0.03185f
C64 carry_0/g1_0 pg0_0/p0 0.03556f
C65 carry_0/a_169_148# vdd 0
C66 carry_0/g3_2 c0 0.02432f
C67 carry_0/g3_0b carry_0/c4g_xn1 0.00464f
C68 pg0_0/aoi0_xp1 b0 0.01183f
C69 c0 pg0_0/p0 0.58923f
C70 sum1_0/c1 pg0_0/t0b 0.1962f
C71 a1 pg1_0/p1 0.0326f
C72 b1 pg1_0/t1b 0.88714f
C73 carry_0/c0b carry_0/g3_2 0.08692f
C74 carry_0/g1_0 carry_0/g2_0b 0.04619f
C75 carry_0/t1_0 carry_0/t2_0b 0.5058f
C76 sum3_0/c3 sum3_0/x3_cb 0.72334f
C77 carry_0/c2_xn1 pg1_0/g1b 0.03254f
C78 carry_0/g10_xn1 pg1_0/t1b 0.01227f
C79 carry_0/c0b pg0_0/p0 0
C80 carry_0/t1_0 vdd 0.11831f
C81 carry_0/t2 sum2_0/c2 0.00114f
C82 carry_0/g2_0b c0 0.04132f
C83 gnd sum1_0/a_16_15# 0
C84 sum3_0/x3_cb sum3_0/x3_s1xp1 0.01217f
C85 pg2_0/p2b sum2_0/x2_s1xp1 0.27763f
C86 pg0_0/a_43_103# vdd 0.00141f
C87 pg2_0/t2b pg1_0/p1 0.03683f
C88 pg2_0/g2b pg1_0/p1b 0.00638f
C89 pg2_0/p2b pg1_0/g1b 0.00561f
C90 carry_0/c4g_xn1 gnd 0.39643f
C91 pg1_0/a_70_27# pg1_0/p1 0
C92 a1 b1 1.92216f
C93 carry_0/c0b carry_0/g2_0b 0.175f
C94 carry_0/g1_0 carry_0/t2 0.42698f
C95 carry_0/t1_0b carry_0/g1_0b 0.39987f
C96 pg2_0/g2b carry_0/c3_xn1 0.25595f
C97 gnd pg3_0/a_16_15# 0
C98 vdd pg3_0/t3b 0.09184f
C99 sum3_0/c3 pg3_0/p3 0.59374f
C100 carry_0/a_70_148# vdd 0.00113f
C101 carry_0/g1_0 sum3_0/c3 0.00996f
C102 carry_0/t2 c0 0.03438f
C103 carry_0/g1_0b sum2_0/c2 0.01912f
C104 pg3_0/p3 sum3_0/x3_s1xp1 0.00494f
C105 pg3_0/p3b sum3_0/x3_cb 0.26268f
C106 pg2_0/g2b pg1_0/g1b 1.5714f
C107 carry_0/g32_xn1 gnd 0.16529f
C108 c0 sum3_0/c3 0.01524f
C109 pg1_0/a_16_19# pg1_0/g1b 0
C110 pg1_0/aoi1_xp1 pg1_0/p1 0.4769f
C111 pg1_0/oai1_xn1 a1 0.02027f
C112 carry_0/c0b carry_0/t2 0.09675f
C113 carry_0/g1_0 carry_0/g1_0b 0.69359f
C114 vdd a3 0.09033f
C115 sum0_0/x0_s1xp1 s0 1.2274f
C116 carry_0/t3_2 pg1_0/g1b 0.04102f
C117 sum2_0/a_16_19# gnd 0
C118 carry_0/g1_0b c0 0.02508f
C119 carry_0/c0b sum3_0/c3 0.07766f
C120 pg3_0/p3 pg3_0/p3b 0.2539f
C121 gnd pg1_0/t1b 0.50738f
C122 pg2_0/t2b pg2_0/p2 0.6473f
C123 pg2_0/g2b pg2_0/p2b 0.08407f
C124 carry_0/a_250_15# gnd 0
C125 carry_0/t1_0 pg3_0/t3b 0.01855f
C126 pg1_0/aoi1_xp1 b1 0.01183f
C127 pg2_0/p2b carry_0/t3_2 0.00119f
C128 carry_0/c0b carry_0/g1_0b 0.09624f
C129 pg0_0/p0b s0 0.09552f
C130 carry_0/g2_0b pg1_0/p1b 0.00163f
C131 carry_0/g3_2 pg1_0/g1b 0.02509f
C132 carry_0/g30_xp1 carry_0/g3_0b 0.85283f
C133 carry_0/g2_0b carry_0/c3_xn1 0.00504f
C134 pg0_0/p0 pg1_0/g1b 0
C135 vdd sum1_0/x1_cb 0.13768f
C136 gnd a1 0.00266f
C137 b3 pg3_0/p3b 0.02645f
C138 pg3_0/g3b pg3_0/p3 0.16151f
C139 pg0_0/t0b pg1_0/t1b 0.40887f
C140 a2 pg2_0/p2 0.03709f
C141 b2 pg2_0/t2b 0.88722f
C142 carry_0/c1_xn1 gnd 0.16512f
C143 carry_0/g1_0 pg3_0/g3b 0.01884f
C144 c0 sum1_0/c1 0.28396f
C145 pg2_0/p2b carry_0/g3_2 0
C146 vdd pg3_0/aoi3_xp1 0.68583f
C147 c4 pg3_0/g3b 0.0856f
C148 carry_0/t2 pg1_0/p1b 0
C149 c0 pg3_0/g3b 0.01436f
C150 carry_0/g2_0b pg1_0/g1b 0.04132f
C151 pg2_0/t2b gnd 0.50232f
C152 carry_0/a_34_148# c0 0
C153 carry_0/t2_0b carry_0/a_277_15# 0
C154 carry_0/c0b sum1_0/c1 0.09333f
C155 carry_0/t3_0b carry_0/g3_0b 0.71141f
C156 s2 sum2_0/c2 0.02396f
C157 gnd pg1_0/a_70_27# 0
C158 vdd pg1_0/p1 0.1839f
C159 b3 pg3_0/g3b 0.28625f
C160 pg3_0/oai3_xn1 pg3_0/p3b 0.826f
C161 a3 pg3_0/t3b 0.04915f
C162 pg2_0/a_70_19# pg2_0/p2 0
C163 a2 b2 1.92223f
C164 carry_0/c0b pg3_0/g3b 0.02012f
C165 carry_0/g10_xn1 pg0_0/g0b 0.01259f
C166 carry_0/c1_xn1 pg0_0/t0b 0.21053f
C167 carry_0/c3_xn1 sum3_0/c3 0.42383f
C168 pg2_0/g2b carry_0/g3_2 0.02676f
C169 vdd s0 0.05358f
C170 carry_0/c4g_xn1 pg3_0/p3 0
C171 carry_0/g2 pg1_0/t1b 0.00966f
C172 carry_0/t2 pg1_0/g1b 0.03438f
C173 sum2_0/x2_cb vdd 0.23749f
C174 a2 gnd 0.00299f
C175 sum1_0/x1_s1xp1 s1 1.06215f
C176 carry_0/g3_2 carry_0/t3_2 0.40038f
C177 vdd b1 0.08007f
C178 pg3_0/a_106_103# pg3_0/p3b 0.01188f
C179 pg3_0/oai3_xn1 pg3_0/g3b 0.16082f
C180 pg2_0/a_16_15# pg2_0/g2b 0
C181 pg2_0/aoi2_xp1 pg2_0/p2 0.60913f
C182 pg2_0/oai2_xn1 a2 0.02092f
C183 sum1_0/c1 sum1_0/x1_s1xp1 0.00654f
C184 sum3_0/c3 pg1_0/g1b 0.01562f
C185 carry_0/t3_0b gnd 0.00202f
C186 carry_0/c4g_xn1 c4 0.33845f
C187 carry_0/c4g_xn1 c0 0.26993f
C188 pg2_0/g2b carry_0/g2_0b 0.02847f
C189 pg0_0/p0 sum0_0/x0_cb 0.01812f
C190 pg0_0/p0b gnd 0.01017f
C191 carry_0/t1_0 pg1_0/p1 0
C192 carry_0/a_439_27# pg3_0/g3b 0.00215f
C193 carry_0/a_412_27# pg3_0/t3b 0.00215f
C194 carry_0/t1_0b pg1_0/t1b 0.00705f
C195 carry_0/g1_0b pg1_0/g1b 0.0211f
C196 pg2_0/a_70_19# gnd 0
C197 pg2_0/p2 vdd 0.31795f
C198 pg1_0/p1b s1 0.09459f
C199 pg2_0/p2b sum3_0/c3 0.00472f
C200 carry_0/g1_0b carry_0/c2_xn1 0.02426f
C201 carry_0/g1_0 carry_0/g32_xn1 0.23789f
C202 carry_0/c0b carry_0/c4g_xn1 0.09002f
C203 pg3_0/aoi3_xp1 pg3_0/t3b 0.43054f
C204 pg2_0/aoi2_xp1 b2 0.01312f
C205 sum2_0/c2 pg1_0/t1b 0.00638f
C206 sum1_0/c1 pg1_0/p1b 0.01832f
C207 carry_0/g3_0b vdd 0.03188f
C208 carry_0/g32_xn1 c0 0.03106f
C209 pg2_0/t2b carry_0/g2 0.01823f
C210 pg2_0/g2b carry_0/t2 0.73227f
C211 pg0_0/t0b pg0_0/p0b 0.00126f
C212 pg0_0/g0b gnd 0.04705f
C213 carry_0/g1_0 pg1_0/t1b 0.05433f
C214 b2 vdd 0.08169f
C215 pg2_0/g2b sum3_0/c3 0.01023f
C216 carry_0/c0b carry_0/g32_xn1 0.15571f
C217 vdd pg1_0/a_106_103# 0
C218 pg3_0/aoi3_xp1 a3 0.01377f
C219 c0 pg1_0/t1b 0.02313f
C220 carry_0/t2_0b gnd 0.00266f
C221 carry_0/a_376_148# vdd 0
C222 carry_0/t3_2 sum3_0/c3 0.00693f
C223 pg3_0/g3b pg1_0/g1b 0.01513f
C224 pg2_0/p2 carry_0/t1_0 0
C225 vdd gnd 1.12746f
C226 a0 pg0_0/p0b 0.00647f
C227 b0 pg0_0/p0 0.0279f
C228 pg0_0/g0b pg0_0/t0b 0.54353f
C229 carry_0/c0b pg1_0/t1b 0.01959f
C230 carry_0/t1_0 carry_0/g3_0b 0.02809f
C231 gnd sum3_0/a_16_25# 0
C232 pg2_0/p2b pg3_0/g3b 0
C233 pg2_0/p2 pg3_0/t3b 0.00504f
C234 carry_0/a_340_148# vdd 0
C235 carry_0/g3_2 sum3_0/c3 0.00918f
C236 carry_0/c1_xn1 c0 0.27555f
C237 sum3_0/a_34_25# s3 0
C238 pg2_0/t2b carry_0/g1_0 0.02719f
C239 sum2_0/x2_s1xp1 s2 0.92999f
C240 pg0_0/a_16_10# gnd 0
C241 pg0_0/oai0_xn1 pg0_0/p0 0.19757f
C242 a0 pg0_0/g0b 1.06454f
C243 vdd pg0_0/t0b 0.08588f
C244 carry_0/g3_0b pg3_0/t3b 0.01276f
C245 sum1_0/c1 sum0_0/a_34_10# 0.00672f
C246 pg2_0/a_106_103# vdd 0
C247 pg1_0/p1 sum1_0/x1_cb 0.01812f
C248 pg2_0/t2b c0 0.02298f
C249 carry_0/t2_0b carry_0/g20_xp1 0.25906f
C250 carry_0/t2 carry_0/g2_0b 0.04213f
C251 carry_0/g1_0 carry_0/g30_xp1 0.01192f
C252 carry_0/c0b carry_0/c1_xn1 0.16716f
C253 carry_0/c4g_xn1 pg1_0/g1b 0.0107f
C254 pg2_0/g2b pg3_0/g3b 0.38194f
C255 carry_0/t1_0 gnd 0.402f
C256 carry_0/g20_xp1 vdd 0.35509f
C257 carry_0/g2_0b sum3_0/c3 0.12319f
C258 sum3_0/x3_cb s3 0.08338f
C259 pg2_0/t2b carry_0/c0b 0.02782f
C260 pg2_0/p2b s2 0.09334f
C261 pg0_0/a_70_27# pg0_0/g0b 0
C262 vdd a0 0.08783f
C263 pg0_0/oai0_xn1 b0 0.21867f
C264 sum1_0/c1 sum0_0/x0_cb 0.0021f
C265 c0 sum0_0/x0_s1xp1 0.00735f
C266 carry_0/t3_2 pg3_0/g3b 0.09785f
C267 gnd pg3_0/t3b 0.30198f
C268 carry_0/g32_xn1 pg1_0/g1b 0.01266f
C269 carry_0/g1_0 pg0_0/p0b 0.00113f
C270 carry_0/g2 vdd 0.36476f
C271 carry_0/t3_0b c4 0.0192f
C272 carry_0/t1_0 pg0_0/t0b 0.21826f
C273 carry_0/t3_0b c0 0.02503f
C274 pg3_0/p3 s3 0.15857f
C275 pg0_0/aoi0_xp1 pg0_0/g0b 0.00159f
C276 pg0_0/a_43_103# pg0_0/t0b 0.00176f
C277 sum1_0/c1 pg0_0/p0 0.04123f
C278 c0 pg0_0/p0b 0.02374f
C279 carry_0/g3_2 pg3_0/g3b 0.53961f
C280 a1 pg1_0/p1b 0.00644f
C281 b1 pg1_0/p1 0.0279f
C282 pg1_0/g1b pg1_0/t1b 0.91263f
C283 carry_0/c0b carry_0/t3_0b 0.47836f
C284 vdd sum3_0/x3_cb 0.1959f
C285 gnd a3 0.00266f
C286 carry_0/c2_xn1 pg1_0/t1b 0.01336f
C287 sum3_0/c3 sum3_0/x3_s1xp1 0.00492f
C288 carry_0/c0b pg0_0/p0b 0.00113f
C289 carry_0/t1_0b vdd 0.36068f
C290 carry_0/g1_0 pg0_0/g0b 0.03931f
C291 carry_0/g3_0b carry_0/a_412_27# 0
C292 gnd sum1_0/a_34_15# 0
C293 pg0_0/aoi0_xp1 vdd 0.28719f
C294 pg2_0/t2b pg1_0/p1b 0.00473f
C295 c0 pg0_0/g0b 0.02298f
C296 sum2_0/c2 vdd 0.40436f
C297 pg1_0/oai1_xn1 pg1_0/p1 0.19846f
C298 a1 pg1_0/g1b 1.06087f
C299 carry_0/g1_0 carry_0/t2_0b 0.50212f
C300 pg2_0/t2b carry_0/c3_xn1 0.25111f
C301 pg2_0/g2b carry_0/g32_xn1 0.01188f
C302 carry_0/t1_0 carry_0/g2 0.49291f
C303 gnd pg3_0/a_70_15# 0
C304 vdd pg3_0/p3 0.40059f
C305 sum3_0/c3 pg3_0/p3b 0.01832f
C306 carry_0/g1_0 vdd 0.48536f
C307 carry_0/c0b pg0_0/g0b 0.39967f
C308 carry_0/t3_0b carry_0/a_439_27# 0
C309 carry_0/t2_0b c0 0.02471f
C310 carry_0/a_169_148# sum2_0/c2 0.00113f
C311 gnd sum1_0/x1_cb 0.05225f
C312 pg3_0/p3b sum3_0/x3_s1xp1 0.27667f
C313 pg2_0/p2 sum2_0/x2_cb 0.01812f
C314 c4 vdd 0.27679f
C315 pg2_0/g2b pg1_0/t1b 0.29541f
C316 c0 vdd 0.08381f
C317 pg2_0/t2b pg1_0/g1b 0.02561f
C318 carry_0/a_412_27# gnd 0
C319 pg1_0/a_106_103# pg1_0/p1 0.00288f
C320 pg1_0/oai1_xn1 b1 0.21867f
C321 carry_0/t1_0 carry_0/t1_0b 0.03362f
C322 carry_0/c0b carry_0/t2_0b 0.48629f
C323 vdd b3 0.08128f
C324 sum0_0/a_16_10# s0 0
C325 sum3_0/c3 pg3_0/g3b 0.01333f
C326 carry_0/c0b vdd 0.26367f
C327 sum2_0/a_34_19# gnd 0
C328 carry_0/t1_0 sum2_0/c2 0.00934f
C329 carry_0/g3_2 carry_0/g32_xn1 0.66801f
C330 gnd pg1_0/p1 0.0425f
C331 pg2_0/g2b a1 0.00136f
C332 carry_0/a_277_15# gnd 0
C333 pg1_0/a_43_103# pg1_0/t1b 0.00221f
C334 pg2_0/p2b carry_0/g30_xp1 0.01624f
C335 carry_0/g1_0 carry_0/t1_0 0.05513f
C336 gnd s0 0.04131f
C337 carry_0/t3_0b pg1_0/g1b 0.51054f
C338 sum2_0/x2_cb gnd 0.1012f
C339 carry_0/t1_0 c0 3.69003f
C340 pg0_0/p0b pg1_0/g1b 0
C341 pg0_0/p0 pg1_0/t1b 0
C342 vdd sum1_0/x1_s1xp1 0.68564f
C343 gnd b1 0.00606f
C344 pg3_0/t3b pg3_0/p3 0.60628f
C345 pg3_0/g3b pg3_0/p3b 0.08454f
C346 a2 pg2_0/p2b 0.00708f
C347 b2 pg2_0/p2 0.02789f
C348 pg2_0/g2b pg2_0/t2b 0.28599f
C349 sum1_0/c1 s1 0.02334f
C350 carry_0/g10_xn1 gnd 0.4954f
C351 carry_0/g1_0 pg3_0/t3b 0.01905f
C352 pg2_0/p2 carry_0/a_376_148# 0.0086f
C353 pg2_0/t2b carry_0/t3_2 0.01862f
C354 carry_0/a_70_148# carry_0/g1_0 0.00142f
C355 carry_0/c0b carry_0/t1_0 0.20233f
C356 vdd pg3_0/a_106_103# 0
C357 carry_0/t2_0b pg1_0/p1b 0.04416f
C358 carry_0/g20_xp1 pg1_0/p1 0.01383f
C359 c0 pg3_0/t3b 0.02333f
C360 pg2_0/p2 gnd 0.07523f
C361 carry_0/a_34_148# sum1_0/c1 0.00594f
C362 carry_0/t3_2 carry_0/g30_xp1 0.01191f
C363 carry_0/g2_0b carry_0/a_250_15# 0
C364 carry_0/t2_0b carry_0/c3_xn1 0.13157f
C365 pg0_0/g0b pg1_0/g1b 0
C366 vdd pg1_0/p1b 0.18726f
C367 gnd pg1_0/oai1_xn1 0.06612f
C368 a3 pg3_0/p3 0.03077f
C369 b3 pg3_0/t3b 0.88476f
C370 pg2_0/oai2_xn1 pg2_0/p2 0.23155f
C371 a2 pg2_0/g2b 1.06163f
C372 pg2_0/g2b pg1_0/aoi1_xp1 0.00538f
C373 carry_0/g3_0b gnd 0.03306f
C374 carry_0/c0b pg3_0/t3b 0.01965f
C375 carry_0/g10_xn1 pg0_0/t0b 0.25456f
C376 carry_0/g32_xn1 sum3_0/c3 0.32953f
C377 pg2_0/t2b carry_0/g3_2 0.52528f
C378 sum0_0/x0_cb sum0_0/x0_s1xp1 0.01459f
C379 gnd sum0_0/a_16_10# 0
C380 carry_0/t2 pg1_0/t1b 0
C381 carry_0/g2 pg1_0/p1 0
C382 carry_0/t2_0b pg1_0/g1b 0.03443f
C383 sum2_0/x2_s1xp1 vdd 0.55276f
C384 b2 gnd 0.00735f
C385 sum1_0/a_16_15# s1 0
C386 carry_0/t3_0b carry_0/t3_2 0.12595f
C387 carry_0/g3_2 carry_0/g30_xp1 0.00755f
C388 pg3_0/a_70_15# pg3_0/p3 0
C389 a3 b3 1.92216f
C390 vdd pg1_0/g1b 0.47663f
C391 pg2_0/a_106_103# pg2_0/p2 0
C392 pg2_0/oai2_xn1 b2 0.21932f
C393 pg2_0/t2b carry_0/g2_0b 1.00851f
C394 pg0_0/p0b sum0_0/x0_cb 0.26268f
C395 pg0_0/p0 sum0_0/x0_s1xp1 0.00737f
C396 carry_0/t1_0 pg1_0/p1b 0
C397 carry_0/g1_0b pg1_0/t1b 0.00673f
C398 pg2_0/p2b vdd 0.32078f
C399 pg2_0/oai2_xn1 gnd 0.13223f
C400 carry_0/t1_0 carry_0/c3_xn1 0.01952f
C401 pg3_0/a_16_15# pg3_0/g3b 0
C402 pg3_0/aoi3_xp1 pg3_0/p3 0.67759f
C403 pg3_0/oai3_xn1 a3 0.02124f
C404 pg2_0/a_43_103# pg2_0/t2b 0.00221f
C405 sum2_0/c2 pg1_0/p1 0.07332f
C406 carry_0/a_466_148# vdd 0
C407 pg2_0/t2b carry_0/t2 0.65961f
C408 pg2_0/g2b carry_0/t2_0b 0.02795f
C409 pg0_0/p0 pg0_0/p0b 0.2539f
C410 pg0_0/t0b gnd 0.4009f
C411 carry_0/g1_0 pg1_0/p1 0.00113f
C412 carry_0/g32_xn1 pg3_0/g3b 0.00496f
C413 carry_0/t1_0 pg1_0/g1b 0.09137f
C414 pg2_0/g2b vdd 0.59206f
C415 pg2_0/t2b sum3_0/c3 0.01722f
C416 carry_0/t1_0 carry_0/c2_xn1 0.01921f
C417 sum2_0/x2_cb sum2_0/c2 0.71253f
C418 pg3_0/aoi3_xp1 b3 0.01377f
C419 c0 pg1_0/p1 0.00528f
C420 carry_0/t3_2 vdd 0.31536f
C421 carry_0/g30_xp1 sum3_0/c3 0.02176f
C422 pg3_0/t3b pg1_0/g1b 0.0241f
C423 pg2_0/p2b carry_0/t1_0 0
C424 vdd sum0_0/x0_cb 0.11378f
C425 a0 gnd 0.00307f
C426 b0 pg0_0/p0b 0.02346f
C427 pg0_0/g0b pg0_0/p0 0.43889f
C428 carry_0/c0b pg1_0/p1 0.00113f
C429 c0 s0 0.04109f
C430 sum1_0/x1_cb sum1_0/x1_s1xp1 0.01378f
C431 carry_0/g1_0 carry_0/g10_xn1 0.70367f
C432 pg2_0/p2 sum2_0/c2 0.58463f
C433 vdd pg1_0/a_43_103# 0.00193f
C434 gnd sum3_0/a_34_25# 0
C435 pg2_0/p2b pg3_0/t3b 0.31486f
C436 carry_0/g3_2 vdd 0.3641f
C437 carry_0/g2 gnd 0.08418f
C438 carry_0/t3_0b sum3_0/c3 0
C439 carry_0/c1_xn1 sum1_0/c1 0.45573f
C440 carry_0/g10_xn1 c0 0.26914f
C441 pg2_0/p2 carry_0/g1_0 0.00113f
C442 pg2_0/g2b carry_0/t1_0 0.02715f
C443 sum2_0/a_16_19# s2 0
C444 b0 pg0_0/g0b 0.28794f
C445 pg0_0/a_70_27# gnd 0
C446 vdd pg0_0/p0 0.18368f
C447 pg0_0/oai0_xn1 pg0_0/p0b 0.6277f
C448 a0 pg0_0/t0b 0.04862f
C449 carry_0/g3_0b pg3_0/p3 0
C450 pg1_0/p1b sum1_0/x1_cb 0.26268f
C451 pg1_0/p1 sum1_0/x1_s1xp1 0.00656f
C452 pg2_0/p2 c0 0.00528f
C453 carry_0/t2_0b carry_0/g2_0b 0.88085f
C454 carry_0/t1_0 carry_0/t3_2 1.18118f
C455 carry_0/c0b carry_0/g10_xn1 0.1561f
C456 carry_0/g1_0 carry_0/g3_0b 0.02667f
C457 gnd sum3_0/x3_cb 0.08418f
C458 sum3_0/c3 s3 0.02365f
C459 carry_0/g3_0b c4 0.02583f
C460 pg2_0/g2b pg3_0/t3b 0.55301f
C461 carry_0/t1_0b gnd 0.16779f
C462 carry_0/g2_0b vdd 0.03317f
C463 pg2_0/t2b pg3_0/g3b 0.0182f
C464 carry_0/g3_0b c0 0.04138f
C465 carry_0/a_304_148# sum3_0/c3 0.00113f
C466 sum3_0/x3_s1xp1 s3 0.73156f
C467 pg2_0/p2 carry_0/c0b 0.00113f
C468 vdd b0 0.07975f
C469 pg0_0/a_106_103# pg0_0/p0b 0.00475f
C470 pg0_0/oai0_xn1 pg0_0/g0b 0.15985f
C471 c0 sum0_0/a_16_10# 0
C472 carry_0/g30_xp1 pg3_0/g3b 0.15641f
C473 carry_0/t3_2 pg3_0/t3b 0.01901f
C474 sum2_0/c2 gnd 0.00509f
C475 pg2_0/a_43_103# vdd 0.00193f
C476 pg1_0/p1 pg1_0/p1b 0.26666f
C477 carry_0/g2 carry_0/g20_xp1 0.00652f
C478 carry_0/t1_0 carry_0/g3_2 0.01797f
C479 carry_0/t2 carry_0/t2_0b 0.02444f
C480 carry_0/c0b carry_0/g3_0b 0.16536f
C481 gnd pg3_0/p3 0.08539f
C482 carry_0/a_106_148# pg0_0/p0b 0.01666f
C483 carry_0/g1_0 gnd 0.04316f
C484 carry_0/t2 vdd 0.69628f
C485 carry_0/t2_0b sum3_0/c3 0.00653f
C486 pg3_0/p3b s3 0.09188f
C487 pg0_0/aoi0_xp1 pg0_0/t0b 0.23913f
C488 sum1_0/c1 pg0_0/p0b 0.00475f
C489 carry_0/t3_0b pg3_0/g3b 0.17988f
C490 sum3_0/c3 vdd 0.39525f
C491 carry_0/g3_2 pg3_0/t3b 0.03699f
C492 c0 gnd 0.00782f
C493 b1 pg1_0/p1b 0.02342f
C494 pg1_0/g1b pg1_0/p1 0.16183f
C495 pg2_0/p2b carry_0/a_412_27# 0
C496 carry_0/t1_0 carry_0/g2_0b 0.03812f
C497 vdd sum3_0/x3_s1xp1 0.35344f
C498 gnd b3 0.00735f
C499 sum3_0/c3 sum3_0/a_16_25# 0
C500 carry_0/a_70_148# pg0_0/p0 0
C501 carry_0/g1_0 pg0_0/t0b 0.49421f
C502 carry_0/c0b gnd 0.09f
C503 carry_0/g1_0b vdd 0.19796f
C504 sum2_0/x2_cb sum2_0/x2_s1xp1 0.01314f
C505 pg0_0/a_106_103# vdd 0
C506 pg0_0/aoi0_xp1 a0 0.01183f
C507 sum1_0/c1 pg0_0/g0b 0.0265f
C508 c0 pg0_0/t0b 0.0229f
C509 b1 pg1_0/g1b 0.28515f
C510 pg1_0/oai1_xn1 pg1_0/p1b 0.62751f
C511 a1 pg1_0/t1b 0.05107f
C512 pg2_0/t2b carry_0/g32_xn1 0.00104f
C513 carry_0/g1_0 carry_0/g20_xp1 0.01377f
C514 carry_0/t1_0 carry_0/t2 0.41885f
C515 vdd pg3_0/p3b 0.38422f
C516 gnd pg3_0/oai3_xn1 0.16529f
C517 carry_0/g10_xn1 pg1_0/g1b 0.00534f
C518 carry_0/a_106_148# vdd 0.00156f
C519 carry_0/c0b pg0_0/t0b 0.41754f
C520 carry_0/t3_0b carry_0/c4g_xn1 0.01188f
C521 carry_0/g2 sum2_0/c2 0.37289f
C522 carry_0/t1_0 sum3_0/c3 0.00941f
C523 vdd s1 0.01194f
C524 pg2_0/p2b sum2_0/x2_cb 0.26268f
C525 pg2_0/p2 sum2_0/x2_s1xp1 0.00591f
C526 pg2_0/g2b pg1_0/p1 0.00888f
C527 pg2_0/p2 pg1_0/g1b 0.00574f
C528 carry_0/a_439_27# gnd 0
C529 sum1_0/c1 vdd 0.23011f
C530 pg1_0/a_106_103# pg1_0/p1b 0
C531 pg1_0/oai1_xn1 pg1_0/g1b 0.15985f
C532 carry_0/g1_0 carry_0/g2 0.49291f
C533 carry_0/t1_0 carry_0/g1_0b 1.34505f
C534 sum0_0/a_34_10# s0 0
C535 vdd pg3_0/g3b 0.57783f
C536 sum3_0/c3 pg3_0/t3b 0
C537 carry_0/g3_0b pg1_0/g1b 0.98033f
C538 carry_0/a_34_148# vdd 0
C539 carry_0/t1_0b sum2_0/c2 0.0066f
C540 carry_0/g2 c0 0.02491f
C541 gnd pg1_0/p1b 0.00307f
C542 pg3_0/p3 sum3_0/x3_cb 0.01812f
C543 pg2_0/p2 pg2_0/p2b 0.25546f
C544 pg2_0/g2b b1 0.00397f
C545 carry_0/c3_xn1 gnd 0.49554f
C546 pg1_0/aoi1_xp1 pg1_0/t1b 0.23232f
C547 pg2_0/p2b carry_0/g3_0b 0.00355f
C548 carry_0/a_106_148# carry_0/t1_0 0.00176f
C549 carry_0/c0b carry_0/g2 0.08731f
C550 carry_0/g1_0 carry_0/t1_0b 0.01853f
C551 sum0_0/x0_cb s0 0.0858f
C552 s2 vdd 0.01161f
C553 carry_0/g1_0 sum2_0/c2 0.00934f
C554 carry_0/t1_0b c0 0.02529f
C555 pg0_0/p0b pg1_0/t1b 0.02514f
C556 gnd pg1_0/g1b 0.0129f
C557 b2 pg2_0/p2b 0.02536f
C558 pg2_0/g2b pg2_0/p2 0.1561f
C559 pg2_0/g2b pg1_0/oai1_xn1 0.01296f
C560 carry_0/c2_xn1 gnd 0.49554f
C561 carry_0/t1_0 pg3_0/g3b 0.01975f
C562 c0 sum2_0/c2 0.01524f
C563 pg1_0/aoi1_xp1 a1 0.01183f
C564 pg2_0/p2 carry_0/t3_2 0.00421f
C565 carry_0/c0b carry_0/t1_0b 0.48667f
C566 c4 pg3_0/p3 0.01995f
C567 pg0_0/p0 s0 0.15972f
C568 c0 pg3_0/p3 0.00496f
C569 carry_0/g2_0b pg1_0/p1 0.00406f
C570 carry_0/g20_xp1 pg1_0/p1b 0
C571 pg2_0/p2b gnd 0.00911f
C572 carry_0/c0b sum2_0/c2 0.07766f
C573 carry_0/g1_0 c0 0.04286f
C574 carry_0/t3_2 carry_0/g3_0b 0.30825f
C575 a3 pg3_0/p3b 0.00745f
C576 b3 pg3_0/p3 0.02799f
C577 pg0_0/t0b pg1_0/g1b 0.01852f
C578 pg0_0/g0b pg1_0/t1b 0.39169f
C579 pg3_0/g3b pg3_0/t3b 0.35361f
C580 b2 pg2_0/g2b 0.28547f
C581 pg2_0/oai2_xn1 pg2_0/p2b 0.7597f
C582 a2 pg2_0/t2b 0.0548f
C583 carry_0/g10_xn1 pg0_0/p0 0.01577f
C584 c0 c4 0.0295f
C585 pg2_0/p2 carry_0/g3_2 0.00113f
C586 carry_0/c0b carry_0/g1_0 0.12351f
C587 vdd pg3_0/a_43_103# 0.00113f
C588 gnd sum0_0/a_34_10# 0
C589 carry_0/t2 pg1_0/p1 0.00122f
C590 pg2_0/g2b gnd 0.00531f
C591 sum1_0/a_34_15# s1 0
C592 carry_0/g3_2 carry_0/g3_0b 0.01095f
C593 carry_0/c0b c0 4.75333f
C594 carry_0/a_376_148# carry_0/t3_2 0
C595 carry_0/t3_0b carry_0/g30_xp1 0.23056f
C596 gnd pg1_0/a_16_19# 0
C597 pg3_0/oai3_xn1 pg3_0/p3 0.24705f
C598 a3 pg3_0/g3b 1.06186f
C599 vdd pg1_0/t1b 0.13614f
C600 pg2_0/a_106_103# pg2_0/p2b 0
C601 pg2_0/oai2_xn1 pg2_0/g2b 0.16049f
C602 carry_0/t3_2 gnd 0.19959f
C603 carry_0/c1_xn1 pg0_0/g0b 0.00413f
C604 gnd sum0_0/x0_cb 0.04512f
C605 pg0_0/p0b sum0_0/x0_s1xp1 0.27909f
C606 carry_0/g2 pg1_0/g1b 0.02544f
C607 sum1_0/x1_cb s1 0.085f
C608 carry_0/t1_0 carry_0/g32_xn1 0.25556f
C609 vdd a1 0.08944f
C610 pg3_0/oai3_xn1 b3 0.21964f
C611 pg2_0/aoi2_xp1 pg2_0/t2b 0.36848f
C612 sum2_0/c2 pg1_0/p1b 0.00472f
C613 sum1_0/c1 sum1_0/x1_cb 0.71128f
C614 carry_0/g3_2 gnd 0.00105f
C615 pg2_0/t2b carry_0/t2_0b 0.04164f
C616 pg0_0/p0 gnd 0.03688f
C617 carry_0/g1_0 pg1_0/p1b 0
C618 carry_0/t1_0 pg1_0/t1b 0.01894f
C619 carry_0/g32_xn1 pg3_0/t3b 0.01188f
C620 carry_0/t1_0b pg1_0/g1b 0.40775f
C621 pg2_0/a_16_15# gnd 0
C622 pg2_0/t2b vdd 0.12649f
C623 pg1_0/p1 s1 0.1594f
C624 pg2_0/p2 sum3_0/c3 0.00472f
C625 carry_0/t1_0b carry_0/c2_xn1 0.22108f
C626 carry_0/g1_0 carry_0/c3_xn1 0.01914f
C627 carry_0/a_340_148# carry_0/g3_2 0.00113f
C628 sum2_0/x2_s1xp1 sum2_0/c2 0.00589f
C629 pg3_0/a_43_103# pg3_0/t3b 0.00142f
C630 pg2_0/aoi2_xp1 a2 0.01312f
C631 c0 pg1_0/p1b 0.00461f
C632 sum1_0/c1 pg1_0/p1 0.58401f
C633 sum2_0/c2 pg1_0/g1b 0.01562f
C634 carry_0/g2_0b gnd 0.16544f
C635 carry_0/g30_xp1 vdd 0.15458f
C636 carry_0/g3_0b sum3_0/c3 0.00692f
C637 carry_0/c2_xn1 sum2_0/c2 0.48896f
C638 carry_0/c3_xn1 c0 0.03224f
C639 pg3_0/p3 pg1_0/g1b 0.00541f
C640 pg2_0/g2b carry_0/g2 0.03811f
C641 vdd sum0_0/x0_s1xp1 0.93422f
C642 b0 gnd 0.00719f
C643 pg0_0/t0b pg0_0/p0 0.58271f
C644 pg0_0/g0b pg0_0/p0b 0.08267f
C645 carry_0/c0b pg1_0/p1b 0
C646 sum1_0/c1 s0 0
C647 carry_0/g1_0 pg1_0/g1b 3.52835f
C648 a2 vdd 0.09235f
C649 s1 0 0.54449f
C650 sum1_0/x1_s1xp1 0 0.29934f ; **FLOATING
C651 sum1_0/x1_cb 0 1.17812f ; **FLOATING
C652 pg1_0/p1b 0 0.81104f
C653 pg1_0/p1 0 1.24433f
C654 pg1_0/t1b 0 2.28824f
C655 pg1_0/g1b 0 3.33895f
C656 b1 0 1.26267f
C657 a1 0 1.50261f
C658 pg1_0/oai1_xn1 0 0.26111f ; **FLOATING
C659 pg1_0/aoi1_xp1 0 0.12668f ; **FLOATING
C660 s3 0 0.52634f
C661 sum3_0/x3_s1xp1 0 0.29934f ; **FLOATING
C662 sum3_0/x3_cb 0 1.18305f ; **FLOATING
C663 pg3_0/p3b 0 0.97767f
C664 pg3_0/p3 0 1.24026f
C665 pg3_0/t3b 0 2.40373f
C666 pg3_0/g3b 0 3.08847f
C667 b3 0 1.26222f
C668 a3 0 1.50215f
C669 pg3_0/oai3_xn1 0 0.26725f ; **FLOATING
C670 pg3_0/aoi3_xp1 0 0.12668f ; **FLOATING
C671 s0 0 0.5462f
C672 sum0_0/x0_s1xp1 0 0.29158f ; **FLOATING
C673 sum0_0/x0_cb 0 1.17429f ; **FLOATING
C674 gnd 0 12.04822f
C675 pg0_0/p0b 0 0.95154f
C676 pg0_0/p0 0 1.21511f
C677 pg0_0/t0b 0 2.55145f
C678 pg0_0/g0b 0 3.1781f
C679 b0 0 1.26176f
C680 a0 0 1.50169f
C681 vdd 0 0.15027p
C682 pg0_0/oai0_xn1 0 0.26111f ; **FLOATING
C683 pg0_0/aoi0_xp1 0 0.12668f ; **FLOATING
C684 c4 0 1.25966f
C685 sum3_0/c3 0 1.69047f
C686 sum2_0/c2 0 1.47826f
C687 sum1_0/c1 0 1.90878f
C688 c0 0 2.75971f
C689 carry_0/c4g_xn1 0 0.58741f ; **FLOATING
C690 carry_0/g32_xn1 0 0.22477f ; **FLOATING
C691 carry_0/c3_xn1 0 1.06494f ; **FLOATING
C692 carry_0/c2_xn1 0 1.30996f ; **FLOATING
C693 carry_0/g10_xn1 0 0.35039f ; **FLOATING
C694 carry_0/c1_xn1 0 0.35838f ; **FLOATING
C695 carry_0/g3_0b 0 1.43068f ; **FLOATING
C696 carry_0/g30_xp1 0 0.26792f ; **FLOATING
C697 carry_0/t3_2 0 2.18118f ; **FLOATING
C698 carry_0/t3_0b 0 1.73828f ; **FLOATING
C699 carry_0/g3_2 0 1.4366f ; **FLOATING
C700 carry_0/g2_0b 0 2.19989f ; **FLOATING
C701 carry_0/g20_xp1 0 0.04829f ; **FLOATING
C702 carry_0/t2_0b 0 1.61791f ; **FLOATING
C703 carry_0/t2 0 2.05924f ; **FLOATING
C704 carry_0/g2 0 1.31857f ; **FLOATING
C705 carry_0/g1_0b 0 1.20631f ; **FLOATING
C706 carry_0/t1_0b 0 1.60477f ; **FLOATING
C707 carry_0/t1_0 0 3.33847f ; **FLOATING
C708 carry_0/g1_0 0 3.19323f ; **FLOATING
C709 carry_0/c0b 0 3.98427f ; **FLOATING
C710 s2 0 0.5389f
C711 sum2_0/x2_s1xp1 0 0.29934f ; **FLOATING
C712 sum2_0/x2_cb 0 1.19568f ; **FLOATING
C713 pg2_0/p2b 0 0.91722f
C714 pg2_0/p2 0 1.2367f
C715 pg2_0/t2b 0 2.9249f
C716 pg2_0/g2b 0 3.38025f
C717 b2 0 1.26313f
C718 a2 0 1.50306f
C719 pg2_0/oai2_xn1 0 0.2652f ; **FLOATING
C720 pg2_0/aoi2_xp1 0 0.12668f ; **FLOATING
.ends

.subckt post_cmp_C4_aoi22_post a0 a1 a2 a3 b0 b1 b2 b3 c0 s0 s1 s2 s3 c4 vdd gnd
X0 a0 a1 a2 a3 b0 b1 b2 b3 c0 c4 s0 s1 s2 s3 vdd gnd top_cmp_C4_aoi22
.ends
.subckt tb_x1 a y vdd gnd
mp y a vdd vdd CMOSP W=1.8e-06 L=1.8e-07 AS=9.72e-13 PS=4.68e-06 AD=9.72e-13 PD=4.68e-06
mn y a gnd gnd CMOSN W=9.0e-07 L=1.8e-07 AS=4.86e-13 PS=2.88e-06 AD=4.86e-13 PD=2.88e-06
.ends
.subckt tb_x2 a y vdd gnd
mp y a vdd vdd CMOSP W=3.6e-06 L=1.8e-07 AS=1.944e-12 PS=8.28e-06 AD=1.944e-12 PD=8.28e-06
mn y a gnd gnd CMOSN W=1.8e-06 L=1.8e-07 AS=9.72e-13 PS=4.68e-06 AD=9.72e-13 PD=4.68e-06
.ends
Va0 src_a0 gnd PWL(
+ 0.00000e+00 1.800 4.82000e-07 1.800
+ )
Xs_a0 src_a0 drv_a0 vdd gnd tb_x1
Xd_a0 drv_a0 a0 vdd gnd tb_x2
Va1 src_a1 gnd PWL(
+ 0.00000e+00 0.000 2.40000e-08 0.000 2.40200e-08 1.800 4.82000e-07 1.800
+ )
Xs_a1 src_a1 drv_a1 vdd gnd tb_x1
Xd_a1 drv_a1 a1 vdd gnd tb_x2
Va2 src_a2 gnd PWL(
+ 0.00000e+00 0.000 4.82000e-07 0.000
+ )
Xs_a2 src_a2 drv_a2 vdd gnd tb_x1
Xd_a2 drv_a2 a2 vdd gnd tb_x2
Va3 src_a3 gnd PWL(
+ 0.00000e+00 0.000 2.60000e-08 0.000 2.60200e-08 1.800 2.80000e-08 1.800 2.80200e-08 0.000 3.20000e-08 0.000
+ 3.20200e-08 1.800 3.40000e-08 1.800 3.40200e-08 0.000 4.00000e-08 0.000 4.00200e-08 1.800 4.20000e-08 1.800
+ 4.20200e-08 0.000 4.60000e-08 0.000 4.60200e-08 1.800 4.80000e-08 1.800 4.80200e-08 0.000 5.60000e-08 0.000
+ 5.60200e-08 1.800 5.80000e-08 1.800 5.80200e-08 0.000 6.20000e-08 0.000 6.20200e-08 1.800 6.40000e-08 1.800
+ 6.40200e-08 0.000 7.00000e-08 0.000 7.00200e-08 1.800 7.20000e-08 1.800 7.20200e-08 0.000 7.60000e-08 0.000
+ 7.60200e-08 1.800 7.80000e-08 1.800 7.80200e-08 0.000 8.80000e-08 0.000 8.80200e-08 1.800 9.00000e-08 1.800
+ 9.00200e-08 0.000 9.40000e-08 0.000 9.40200e-08 1.800 9.60000e-08 1.800 9.60200e-08 0.000 1.02000e-07 0.000
+ 1.02020e-07 1.800 1.04000e-07 1.800 1.04020e-07 0.000 1.08000e-07 0.000 1.08020e-07 1.800 1.10000e-07 1.800
+ 1.10020e-07 0.000 1.18000e-07 0.000 1.18020e-07 1.800 1.20000e-07 1.800 1.20020e-07 0.000 1.24000e-07 0.000
+ 1.24020e-07 1.800 1.26000e-07 1.800 1.26020e-07 0.000 1.32000e-07 0.000 1.32020e-07 1.800 1.34000e-07 1.800
+ 1.34020e-07 0.000 1.38000e-07 0.000 1.38020e-07 1.800 1.40000e-07 1.800 1.40020e-07 0.000 1.52000e-07 0.000
+ 1.52020e-07 1.800 1.54000e-07 1.800 1.54020e-07 0.000 1.58000e-07 0.000 1.58020e-07 1.800 1.60000e-07 1.800
+ 1.60020e-07 0.000 1.66000e-07 0.000 1.66020e-07 1.800 1.68000e-07 1.800 1.68020e-07 0.000 1.72000e-07 0.000
+ 1.72020e-07 1.800 1.74000e-07 1.800 1.74020e-07 0.000 1.82000e-07 0.000 1.82020e-07 1.800 1.84000e-07 1.800
+ 1.84020e-07 0.000 1.88000e-07 0.000 1.88020e-07 1.800 1.90000e-07 1.800 1.90020e-07 0.000 1.96000e-07 0.000
+ 1.96020e-07 1.800 1.98000e-07 1.800 1.98020e-07 0.000 2.02000e-07 0.000 2.02020e-07 1.800 2.04000e-07 1.800
+ 2.04020e-07 0.000 2.14000e-07 0.000 2.14020e-07 1.800 2.16000e-07 1.800 2.16020e-07 0.000 2.20000e-07 0.000
+ 2.20020e-07 1.800 2.22000e-07 1.800 2.22020e-07 0.000 2.28000e-07 0.000 2.28020e-07 1.800 2.30000e-07 1.800
+ 2.30020e-07 0.000 2.34000e-07 0.000 2.34020e-07 1.800 2.36000e-07 1.800 2.36020e-07 0.000 2.44000e-07 0.000
+ 2.44020e-07 1.800 2.46000e-07 1.800 2.46020e-07 0.000 2.50000e-07 0.000 2.50020e-07 1.800 2.52000e-07 1.800
+ 2.52020e-07 0.000 2.58000e-07 0.000 2.58020e-07 1.800 2.60000e-07 1.800 2.60020e-07 0.000 2.64000e-07 0.000
+ 2.64020e-07 1.800 4.82000e-07 1.800
+ )
Xs_a3 src_a3 drv_a3 vdd gnd tb_x1
Xd_a3 drv_a3 a3 vdd gnd tb_x2
Vb0 src_b0 gnd PWL(
+ 0.00000e+00 0.000 3.00000e-08 0.000 3.00200e-08 1.800 3.60000e-08 1.800 3.60200e-08 0.000 4.40000e-08 0.000
+ 4.40200e-08 1.800 5.00000e-08 1.800 5.00200e-08 0.000 6.00000e-08 0.000 6.00200e-08 1.800 6.60000e-08 1.800
+ 6.60200e-08 0.000 7.40000e-08 0.000 7.40200e-08 1.800 8.00000e-08 1.800 8.00200e-08 0.000 9.20000e-08 0.000
+ 9.20200e-08 1.800 9.80000e-08 1.800 9.80200e-08 0.000 1.06000e-07 0.000 1.06020e-07 1.800 1.12000e-07 1.800
+ 1.12020e-07 0.000 1.22000e-07 0.000 1.22020e-07 1.800 1.28000e-07 1.800 1.28020e-07 0.000 1.36000e-07 0.000
+ 1.36020e-07 1.800 1.42000e-07 1.800 1.42020e-07 0.000 1.56000e-07 0.000 1.56020e-07 1.800 1.62000e-07 1.800
+ 1.62020e-07 0.000 1.70000e-07 0.000 1.70020e-07 1.800 1.76000e-07 1.800 1.76020e-07 0.000 1.86000e-07 0.000
+ 1.86020e-07 1.800 1.92000e-07 1.800 1.92020e-07 0.000 2.00000e-07 0.000 2.00020e-07 1.800 2.06000e-07 1.800
+ 2.06020e-07 0.000 2.18000e-07 0.000 2.18020e-07 1.800 2.24000e-07 1.800 2.24020e-07 0.000 2.32000e-07 0.000
+ 2.32020e-07 1.800 2.38000e-07 1.800 2.38020e-07 0.000 2.48000e-07 0.000 2.48020e-07 1.800 2.54000e-07 1.800
+ 2.54020e-07 0.000 2.62000e-07 0.000 2.62020e-07 1.800 2.66000e-07 1.800 2.66020e-07 0.000 2.68000e-07 0.000
+ 2.68020e-07 1.800 2.72000e-07 1.800 2.72020e-07 0.000 2.74000e-07 0.000 2.74020e-07 1.800 2.80000e-07 1.800
+ 2.80020e-07 0.000 2.82000e-07 0.000 2.82020e-07 1.800 2.86000e-07 1.800 2.86020e-07 0.000 2.88000e-07 0.000
+ 2.88020e-07 1.800 2.96000e-07 1.800 2.96020e-07 0.000 2.98000e-07 0.000 2.98020e-07 1.800 3.02000e-07 1.800
+ 3.02020e-07 0.000 3.04000e-07 0.000 3.04020e-07 1.800 3.10000e-07 1.800 3.10020e-07 0.000 3.12000e-07 0.000
+ 3.12020e-07 1.800 3.16000e-07 1.800 3.16020e-07 0.000 3.18000e-07 0.000 3.18020e-07 1.800 3.28000e-07 1.800
+ 3.28020e-07 0.000 3.30000e-07 0.000 3.30020e-07 1.800 3.34000e-07 1.800 3.34020e-07 0.000 3.36000e-07 0.000
+ 3.36020e-07 1.800 3.42000e-07 1.800 3.42020e-07 0.000 3.44000e-07 0.000 3.44020e-07 1.800 3.48000e-07 1.800
+ 3.48020e-07 0.000 3.50000e-07 0.000 3.50020e-07 1.800 3.58000e-07 1.800 3.58020e-07 0.000 3.60000e-07 0.000
+ 3.60020e-07 1.800 3.64000e-07 1.800 3.64020e-07 0.000 3.66000e-07 0.000 3.66020e-07 1.800 3.72000e-07 1.800
+ 3.72020e-07 0.000 3.74000e-07 0.000 3.74020e-07 1.800 3.78000e-07 1.800 3.78020e-07 0.000 4.82000e-07 0.000
+ )
Xs_b0 src_b0 drv_b0 vdd gnd tb_x1
Xd_b0 drv_b0 b0 vdd gnd tb_x2
Vb1 src_b1 gnd PWL(
+ 0.00000e+00 0.000 3.80000e-08 0.000 3.80200e-08 1.800 5.20000e-08 1.800 5.20200e-08 0.000 6.80000e-08 0.000
+ 6.80200e-08 1.800 8.20000e-08 1.800 8.20200e-08 0.000 1.00000e-07 0.000 1.00020e-07 1.800 1.14000e-07 1.800
+ 1.14020e-07 0.000 1.30000e-07 0.000 1.30020e-07 1.800 1.44000e-07 1.800 1.44020e-07 0.000 1.64000e-07 0.000
+ 1.64020e-07 1.800 1.78000e-07 1.800 1.78020e-07 0.000 1.94000e-07 0.000 1.94020e-07 1.800 2.08000e-07 1.800
+ 2.08020e-07 0.000 2.26000e-07 0.000 2.26020e-07 1.800 2.40000e-07 1.800 2.40020e-07 0.000 2.56000e-07 0.000
+ 2.56020e-07 1.800 2.70000e-07 1.800 2.70020e-07 0.000 2.76000e-07 0.000 2.76020e-07 1.800 2.84000e-07 1.800
+ 2.84020e-07 0.000 2.90000e-07 0.000 2.90020e-07 1.800 3.00000e-07 1.800 3.00020e-07 0.000 3.06000e-07 0.000
+ 3.06020e-07 1.800 3.14000e-07 1.800 3.14020e-07 0.000 3.20000e-07 0.000 3.20020e-07 1.800 3.32000e-07 1.800
+ 3.32020e-07 0.000 3.38000e-07 0.000 3.38020e-07 1.800 3.46000e-07 1.800 3.46020e-07 0.000 3.52000e-07 0.000
+ 3.52020e-07 1.800 3.62000e-07 1.800 3.62020e-07 0.000 3.68000e-07 0.000 3.68020e-07 1.800 3.76000e-07 1.800
+ 3.76020e-07 0.000 3.80000e-07 0.000 3.80020e-07 1.800 3.82000e-07 1.800 3.82020e-07 0.000 3.86000e-07 0.000
+ 3.86020e-07 1.800 3.88000e-07 1.800 3.88020e-07 0.000 3.94000e-07 0.000 3.94020e-07 1.800 3.96000e-07 1.800
+ 3.96020e-07 0.000 4.00000e-07 0.000 4.00020e-07 1.800 4.02000e-07 1.800 4.02020e-07 0.000 4.10000e-07 0.000
+ 4.10020e-07 1.800 4.12000e-07 1.800 4.12020e-07 0.000 4.16000e-07 0.000 4.16020e-07 1.800 4.18000e-07 1.800
+ 4.18020e-07 0.000 4.24000e-07 0.000 4.24020e-07 1.800 4.26000e-07 1.800 4.26020e-07 0.000 4.30000e-07 0.000
+ 4.30020e-07 1.800 4.80000e-07 1.800 4.80020e-07 0.000 4.82000e-07 0.000
+ )
Xs_b1 src_b1 drv_b1 vdd gnd tb_x1
Xd_b1 drv_b1 b1 vdd gnd tb_x2
Vb2 src_b2 gnd PWL(
+ 0.00000e+00 1.800 1.40000e-08 1.800 1.40200e-08 0.000 5.40000e-08 0.000 5.40200e-08 1.800 8.40000e-08 1.800
+ 8.40200e-08 0.000 1.16000e-07 0.000 1.16020e-07 1.800 1.46000e-07 1.800 1.46020e-07 0.000 1.80000e-07 0.000
+ 1.80020e-07 1.800 2.10000e-07 1.800 2.10020e-07 0.000 2.42000e-07 0.000 2.42020e-07 1.800 2.78000e-07 1.800
+ 2.78020e-07 0.000 2.92000e-07 0.000 2.92020e-07 1.800 3.08000e-07 1.800 3.08020e-07 0.000 3.22000e-07 0.000
+ 3.22020e-07 1.800 3.40000e-07 1.800 3.40020e-07 0.000 3.54000e-07 0.000 3.54020e-07 1.800 3.70000e-07 1.800
+ 3.70020e-07 0.000 3.84000e-07 0.000 3.84020e-07 1.800 3.90000e-07 1.800 3.90020e-07 0.000 3.98000e-07 0.000
+ 3.98020e-07 1.800 4.04000e-07 1.800 4.04020e-07 0.000 4.14000e-07 0.000 4.14020e-07 1.800 4.20000e-07 1.800
+ 4.20020e-07 0.000 4.28000e-07 0.000 4.28020e-07 1.800 4.32000e-07 1.800 4.32020e-07 0.000 4.34000e-07 0.000
+ 4.34020e-07 1.800 4.38000e-07 1.800 4.38020e-07 0.000 4.40000e-07 0.000 4.40020e-07 1.800 4.46000e-07 1.800
+ 4.46020e-07 0.000 4.48000e-07 0.000 4.48020e-07 1.800 4.52000e-07 1.800 4.52020e-07 0.000 4.70000e-07 0.000
+ 4.70020e-07 1.800 4.82000e-07 1.800
+ )
Xs_b2 src_b2 drv_b2 vdd gnd tb_x1
Xd_b2 drv_b2 b2 vdd gnd tb_x2
Vb3 src_b3 gnd PWL(
+ 0.00000e+00 1.800 4.00000e-09 1.800 4.02000e-09 0.000 1.00000e-08 0.000 1.00200e-08 1.800 2.00000e-08 1.800
+ 2.00200e-08 0.000 8.60000e-08 0.000 8.60200e-08 1.800 1.48000e-07 1.800 1.48020e-07 0.000 2.12000e-07 0.000
+ 2.12020e-07 1.800 2.94000e-07 1.800 2.94020e-07 0.000 3.24000e-07 0.000 3.24020e-07 1.800 3.56000e-07 1.800
+ 3.56020e-07 0.000 3.92000e-07 0.000 3.92020e-07 1.800 4.06000e-07 1.800 4.06020e-07 0.000 4.22000e-07 0.000
+ 4.22020e-07 1.800 4.36000e-07 1.800 4.36020e-07 0.000 4.42000e-07 0.000 4.42020e-07 1.800 4.50000e-07 1.800
+ 4.50020e-07 0.000 4.54000e-07 0.000 4.54020e-07 1.800 4.56000e-07 1.800 4.56020e-07 0.000 4.60000e-07 0.000
+ 4.60020e-07 1.800 4.66000e-07 1.800 4.66020e-07 0.000 4.76000e-07 0.000 4.76020e-07 1.800 4.82000e-07 1.800
+ )
Xs_b3 src_b3 drv_b3 vdd gnd tb_x1
Xd_b3 drv_b3 b3 vdd gnd tb_x2
Vc0 src_c0 gnd PWL(
+ 0.00000e+00 1.800 2.00000e-09 1.800 2.02000e-09 0.000 6.00000e-09 0.000 6.02000e-09 1.800 8.00000e-09 1.800
+ 8.02000e-09 0.000 1.20000e-08 0.000 1.20200e-08 1.800 1.60000e-08 1.800 1.60200e-08 0.000 1.80000e-08 0.000
+ 1.80200e-08 1.800 2.20000e-08 1.800 2.20200e-08 0.000 1.50000e-07 0.000 1.50020e-07 1.800 3.26000e-07 1.800
+ 3.26020e-07 0.000 4.08000e-07 0.000 4.08020e-07 1.800 4.44000e-07 1.800 4.44020e-07 0.000 4.58000e-07 0.000
+ 4.58020e-07 1.800 4.62000e-07 1.800 4.62020e-07 0.000 4.64000e-07 0.000 4.64020e-07 1.800 4.68000e-07 1.800
+ 4.68020e-07 0.000 4.72000e-07 0.000 4.72020e-07 1.800 4.74000e-07 1.800 4.74020e-07 0.000 4.78000e-07 0.000
+ 4.78020e-07 1.800 4.82000e-07 1.800
+ )
Xs_c0 src_c0 drv_c0 vdd gnd tb_x1
Xd_c0 drv_c0 c0 vdd gnd tb_x2
Xl_s0 s0 lo_s0 vdd gnd tb_x1
Xl_s1 s1 lo_s1 vdd gnd tb_x1
Xl_s2 s2 lo_s2 vdd gnd tb_x1
Xl_s3 s3 lo_s3 vdd gnd tb_x1
Xl_c4 c4 lo_c4 vdd gnd tb_x1
X0 a0 a1 a2 a3 b0 b1 b2 b3 c0 s0 s1 s2 s3 c4 vdd gnd post_cmp_C4_aoi22_post
.tran 20p 4.82000e-07
.control
set wr_singlescale
set wr_vecnames
run
wrdata seg10.txt v(a0) v(a1) v(a2) v(a3) v(b0) v(b1) v(b2) v(b3) v(c0) v(drv_a0) v(drv_a1) v(drv_a2) v(drv_a3) v(drv_b0) v(drv_b1) v(drv_b2) v(drv_b3) v(drv_c0) v(s0) v(s1) v(s2) v(s3) v(c4)
quit
.endc
.end
