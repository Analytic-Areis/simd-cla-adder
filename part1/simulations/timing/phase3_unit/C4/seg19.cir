* All-arc segment for cla_c4
.include ../../../../spice/models/TSMC_180nm.txt
.options reltol=1e-4
VDD vdd gnd 1.8
* nand2_x1: 2-input NAND
* GENERATED from part1/cells/library.py. Do not edit by hand.
.subckt nand2_x1 i0 i1 y vdd gnd
Mp1 y i0 vdd vdd CMOSP W=1.8000e-06 L=1.8000e-07 AS=9.7200e-13 PS=4.6800e-06 AD=9.7200e-13 PD=4.6800e-06
Mp2 y i1 vdd vdd CMOSP W=1.8000e-06 L=1.8000e-07 AS=9.7200e-13 PS=4.6800e-06 AD=9.7200e-13 PD=4.6800e-06
Mn1 y i0 xn1 gnd CMOSN W=1.8000e-06 L=1.8000e-07 AS=4.8600e-13 PS=4.1400e-06 AD=9.7200e-13 PD=4.6800e-06
Mn2 xn1 i1 gnd gnd CMOSN W=1.8000e-06 L=1.8000e-07 AS=9.7200e-13 PS=4.6800e-06 AD=4.8600e-13 PD=4.1400e-06
.ends nand2_x1
* nor2_x1: 2-input NOR
* GENERATED from part1/cells/library.py. Do not edit by hand.
.subckt nor2_x1 i0 i1 y vdd gnd
Mp1 xp1 i0 vdd vdd CMOSP W=3.6000e-06 L=1.8000e-07 AS=1.9440e-12 PS=8.2800e-06 AD=9.7200e-13 PD=7.7400e-06
Mp2 y i1 xp1 vdd CMOSP W=3.6000e-06 L=1.8000e-07 AS=9.7200e-13 PS=7.7400e-06 AD=1.9440e-12 PD=8.2800e-06
Mn1 y i0 gnd gnd CMOSN W=9.0000e-07 L=1.8000e-07 AS=4.8600e-13 PS=2.8800e-06 AD=4.8600e-13 PD=2.8800e-06
Mn2 y i1 gnd gnd CMOSN W=9.0000e-07 L=1.8000e-07 AS=4.8600e-13 PS=2.8800e-06 AD=4.8600e-13 PD=2.8800e-06
.ends nor2_x1
* aoi21_x1: NOT(a b + c)
* GENERATED from part1/cells/library.py. Do not edit by hand.
.subckt aoi21_x1 a b c y vdd gnd
Mp1 xp1 a vdd vdd CMOSP W=3.6000e-06 L=1.8000e-07 AS=1.9440e-12 PS=8.2800e-06 AD=1.9440e-12 PD=8.2800e-06
Mp2 xp1 b vdd vdd CMOSP W=3.6000e-06 L=1.8000e-07 AS=1.9440e-12 PS=8.2800e-06 AD=1.9440e-12 PD=8.2800e-06
Mp3 y c xp1 vdd CMOSP W=3.6000e-06 L=1.8000e-07 AS=1.9440e-12 PS=8.2800e-06 AD=1.9440e-12 PD=8.2800e-06
Mn1 y a xn1 gnd CMOSN W=1.8000e-06 L=1.8000e-07 AS=4.8600e-13 PS=4.1400e-06 AD=9.7200e-13 PD=4.6800e-06
Mn2 xn1 b gnd gnd CMOSN W=1.8000e-06 L=1.8000e-07 AS=9.7200e-13 PS=4.6800e-06 AD=4.8600e-13 PD=4.1400e-06
Mn3 y c gnd gnd CMOSN W=9.0000e-07 L=1.8000e-07 AS=4.8600e-13 PS=2.8800e-06 AD=4.8600e-13 PD=2.8800e-06
.ends aoi21_x1
* oai21_x1: NOT((a + b) c)
* GENERATED from part1/cells/library.py. Do not edit by hand.
.subckt oai21_x1 a b c y vdd gnd
Mp1 xp1 a vdd vdd CMOSP W=3.6000e-06 L=1.8000e-07 AS=1.9440e-12 PS=8.2800e-06 AD=9.7200e-13 PD=7.7400e-06
Mp2 y b xp1 vdd CMOSP W=3.6000e-06 L=1.8000e-07 AS=9.7200e-13 PS=7.7400e-06 AD=1.9440e-12 PD=8.2800e-06
Mp3 y c vdd vdd CMOSP W=1.8000e-06 L=1.8000e-07 AS=9.7200e-13 PS=4.6800e-06 AD=9.7200e-13 PD=4.6800e-06
Mn1 y a xn1 gnd CMOSN W=1.8000e-06 L=1.8000e-07 AS=9.7200e-13 PS=4.6800e-06 AD=9.7200e-13 PD=4.6800e-06
Mn2 y b xn1 gnd CMOSN W=1.8000e-06 L=1.8000e-07 AS=9.7200e-13 PS=4.6800e-06 AD=9.7200e-13 PD=4.6800e-06
Mn3 xn1 c gnd gnd CMOSN W=1.8000e-06 L=1.8000e-07 AS=9.7200e-13 PS=4.6800e-06 AD=9.7200e-13 PD=4.6800e-06
.ends oai21_x1
* inv_x1: inverter
* GENERATED from part1/cells/library.py. Do not edit by hand.
.subckt inv_x1 a y vdd gnd
Mp1 y a vdd vdd CMOSP W=1.8000e-06 L=1.8000e-07 AS=9.7200e-13 PS=4.6800e-06 AD=9.7200e-13 PD=4.6800e-06
Mn1 y a gnd gnd CMOSN W=9.0000e-07 L=1.8000e-07 AS=4.8600e-13 PS=2.8800e-06 AD=4.8600e-13 PD=2.8800e-06
.ends inv_x1
* xor_aoi22_x1: dual-rail XOR, AOI22 with c-bar inverter
* GENERATED from part1/cells/library.py. Do not edit by hand.
.subckt xor_aoi22_x1 p pb c s vdd gnd
Ms0p1 cb c vdd vdd CMOSP W=1.8000e-06 L=1.8000e-07 AS=9.7200e-13 PS=4.6800e-06 AD=9.7200e-13 PD=4.6800e-06
Ms0n1 cb c gnd gnd CMOSN W=9.0000e-07 L=1.8000e-07 AS=4.8600e-13 PS=2.8800e-06 AD=4.8600e-13 PD=2.8800e-06
Ms1p1 s1xp1 p vdd vdd CMOSP W=3.6000e-06 L=1.8000e-07 AS=1.9440e-12 PS=8.2800e-06 AD=1.9440e-12 PD=8.2800e-06
Ms1p2 s1xp1 c vdd vdd CMOSP W=3.6000e-06 L=1.8000e-07 AS=1.9440e-12 PS=8.2800e-06 AD=1.9440e-12 PD=8.2800e-06
Ms1p3 s pb s1xp1 vdd CMOSP W=3.6000e-06 L=1.8000e-07 AS=1.9440e-12 PS=8.2800e-06 AD=1.9440e-12 PD=8.2800e-06
Ms1p4 s cb s1xp1 vdd CMOSP W=3.6000e-06 L=1.8000e-07 AS=1.9440e-12 PS=8.2800e-06 AD=1.9440e-12 PD=8.2800e-06
Ms1n1 s p s1xn1 gnd CMOSN W=1.8000e-06 L=1.8000e-07 AS=4.8600e-13 PS=4.1400e-06 AD=9.7200e-13 PD=4.6800e-06
Ms1n2 s1xn1 c gnd gnd CMOSN W=1.8000e-06 L=1.8000e-07 AS=9.7200e-13 PS=4.6800e-06 AD=4.8600e-13 PD=4.1400e-06
Ms1n3 s pb s1xn2 gnd CMOSN W=1.8000e-06 L=1.8000e-07 AS=4.8600e-13 PS=4.1400e-06 AD=9.7200e-13 PD=4.6800e-06
Ms1n4 s1xn2 cb gnd gnd CMOSN W=1.8000e-06 L=1.8000e-07 AS=9.7200e-13 PS=4.6800e-06 AD=4.8600e-13 PD=4.1400e-06
.ends xor_aoi22_x1
* cla_c4: Candidate C4: valency-2 prefix, late C0
* GENERATED from part1/cells/library.py. Do not edit by hand.
.subckt cla_c4 a0 a1 a2 a3 b0 b1 b2 b3 c0 s0 s1 s2 s3 c4 vdd gnd
Xnand0 a0 b0 g0b vdd gnd nand2_x1
Xnor0 a0 b0 t0b vdd gnd nor2_x1
Xaoi0 a0 b0 t0b p0 vdd gnd aoi21_x1
Xoai0 a0 b0 g0b p0b vdd gnd oai21_x1
Xnand1 a1 b1 g1b vdd gnd nand2_x1
Xnor1 a1 b1 t1b vdd gnd nor2_x1
Xaoi1 a1 b1 t1b p1 vdd gnd aoi21_x1
Xoai1 a1 b1 g1b p1b vdd gnd oai21_x1
Xnand2 a2 b2 g2b vdd gnd nand2_x1
Xnor2 a2 b2 t2b vdd gnd nor2_x1
Xaoi2 a2 b2 t2b p2 vdd gnd aoi21_x1
Xoai2 a2 b2 g2b p2b vdd gnd oai21_x1
Xnand3 a3 b3 g3b vdd gnd nand2_x1
Xnor3 a3 b3 t3b vdd gnd nor2_x1
Xaoi3 a3 b3 t3b p3 vdd gnd aoi21_x1
Xoai3 a3 b3 g3b p3b vdd gnd oai21_x1
Xinvc0 c0 c0b vdd gnd inv_x1
Xg10 t1b g0b g1b g1_0 vdd gnd oai21_x1
Xt10 t1b t0b t1_0 vdd gnd nor2_x1
Xg32 t3b g2b g3b g3_2 vdd gnd oai21_x1
Xt32 t3b t2b t3_2 vdd gnd nor2_x1
Xig2 g2b g2 vdd gnd inv_x1
Xit2 t2b t2 vdd gnd inv_x1
Xg30 t3_2 g1_0 g3_2 g3_0b vdd gnd aoi21_x1
Xt30 t3_2 t1_0 t3_0b vdd gnd nand2_x1
Xg20 t2 g1_0 g2 g2_0b vdd gnd aoi21_x1
Xt20 t2 t1_0 t2_0b vdd gnd nand2_x1
Xig10 g1_0 g1_0b vdd gnd inv_x1
Xit10 t1_0 t1_0b vdd gnd inv_x1
Xc1 t0b c0b g0b c1 vdd gnd oai21_x1
Xc2 t1_0b c0b g1_0b c2 vdd gnd oai21_x1
Xc3 t2_0b c0b g2_0b c3 vdd gnd oai21_x1
Xc4g t3_0b c0b g3_0b c4 vdd gnd oai21_x1
Xx0 p0 p0b c0 s0 vdd gnd xor_aoi22_x1
Xx1 p1 p1b c1 s1 vdd gnd xor_aoi22_x1
Xx2 p2 p2b c2 s2 vdd gnd xor_aoi22_x1
Xx3 p3 p3b c3 s3 vdd gnd xor_aoi22_x1
.ends cla_c4
.subckt tb_x1 a y vdd gnd
mp y a vdd vdd CMOSP W=1.8e-06 L=1.8e-07 AS=9.72e-13 PS=4.68e-06 AD=9.72e-13 PD=4.68e-06
mn y a gnd gnd CMOSN W=9.0e-07 L=1.8e-07 AS=4.86e-13 PS=2.88e-06 AD=4.86e-13 PD=2.88e-06
.ends
.subckt tb_x2 a y vdd gnd
mp y a vdd vdd CMOSP W=3.6e-06 L=1.8e-07 AS=1.944e-12 PS=8.28e-06 AD=1.944e-12 PD=8.28e-06
mn y a gnd gnd CMOSN W=1.8e-06 L=1.8e-07 AS=9.72e-13 PS=4.68e-06 AD=9.72e-13 PD=4.68e-06
.ends
Va0 src_a0 gnd PWL(
+ 0.00000e+00 0.000 9.80000e-08 0.000
+ )
Xs_a0 src_a0 drv_a0 vdd gnd tb_x1
Xd_a0 drv_a0 a0 vdd gnd tb_x2
Va1 src_a1 gnd PWL(
+ 0.00000e+00 0.000 9.80000e-08 0.000
+ )
Xs_a1 src_a1 drv_a1 vdd gnd tb_x1
Xd_a1 drv_a1 a1 vdd gnd tb_x2
Va2 src_a2 gnd PWL(
+ 0.00000e+00 0.000 9.80000e-08 0.000
+ )
Xs_a2 src_a2 drv_a2 vdd gnd tb_x1
Xd_a2 drv_a2 a2 vdd gnd tb_x2
Va3 src_a3 gnd PWL(
+ 0.00000e+00 0.000 9.80000e-08 0.000
+ )
Xs_a3 src_a3 drv_a3 vdd gnd tb_x1
Xd_a3 drv_a3 a3 vdd gnd tb_x2
Vb0 src_b0 gnd PWL(
+ 0.00000e+00 1.800 2.00000e-08 1.800 2.00200e-08 0.000 9.80000e-08 0.000
+ )
Xs_b0 src_b0 drv_b0 vdd gnd tb_x1
Xd_b0 drv_b0 b0 vdd gnd tb_x2
Vb1 src_b1 gnd PWL(
+ 0.00000e+00 1.800 7.00000e-08 1.800 7.00200e-08 0.000 9.80000e-08 0.000
+ )
Xs_b1 src_b1 drv_b1 vdd gnd tb_x1
Xd_b1 drv_b1 b1 vdd gnd tb_x2
Vb2 src_b2 gnd PWL(
+ 0.00000e+00 0.000 1.00000e-08 0.000 1.00200e-08 1.800 2.20000e-08 1.800 2.20200e-08 0.000 2.40000e-08 0.000
+ 2.40200e-08 1.800 2.80000e-08 1.800 2.80200e-08 0.000 3.00000e-08 0.000 3.00200e-08 1.800 3.60000e-08 1.800
+ 3.60200e-08 0.000 3.80000e-08 0.000 3.80200e-08 1.800 4.20000e-08 1.800 4.20200e-08 0.000 6.00000e-08 0.000
+ 6.00200e-08 1.800 8.80000e-08 1.800 8.80200e-08 0.000 9.80000e-08 0.000
+ )
Xs_b2 src_b2 drv_b2 vdd gnd tb_x1
Xd_b2 drv_b2 b2 vdd gnd tb_x2
Vb3 src_b3 gnd PWL(
+ 0.00000e+00 1.800 6.00000e-09 1.800 6.02000e-09 0.000 1.60000e-08 0.000 1.60200e-08 1.800 2.60000e-08 1.800
+ 2.60200e-08 0.000 3.20000e-08 0.000 3.20200e-08 1.800 4.00000e-08 1.800 4.00200e-08 0.000 4.40000e-08 0.000
+ 4.40200e-08 1.800 4.60000e-08 1.800 4.60200e-08 0.000 5.00000e-08 0.000 5.00200e-08 1.800 5.60000e-08 1.800
+ 5.60200e-08 0.000 6.60000e-08 0.000 6.60200e-08 1.800 7.20000e-08 1.800 7.20200e-08 0.000 7.40000e-08 0.000
+ 7.40200e-08 1.800 7.80000e-08 1.800 7.80200e-08 0.000 8.40000e-08 0.000 8.40200e-08 1.800 9.40000e-08 1.800
+ 9.40200e-08 0.000 9.80000e-08 0.000
+ )
Xs_b3 src_b3 drv_b3 vdd gnd tb_x1
Xd_b3 drv_b3 b3 vdd gnd tb_x2
Vc0 src_c0 gnd PWL(
+ 0.00000e+00 1.800 2.00000e-09 1.800 2.02000e-09 0.000 4.00000e-09 0.000 4.02000e-09 1.800 8.00000e-09 1.800
+ 8.02000e-09 0.000 1.20000e-08 0.000 1.20200e-08 1.800 1.40000e-08 1.800 1.40200e-08 0.000 1.80000e-08 0.000
+ 1.80200e-08 1.800 3.40000e-08 1.800 3.40200e-08 0.000 4.80000e-08 0.000 4.80200e-08 1.800 5.20000e-08 1.800
+ 5.20200e-08 0.000 5.40000e-08 0.000 5.40200e-08 1.800 5.80000e-08 1.800 5.80200e-08 0.000 6.20000e-08 0.000
+ 6.20200e-08 1.800 6.40000e-08 1.800 6.40200e-08 0.000 6.80000e-08 0.000 6.80200e-08 1.800 7.60000e-08 1.800
+ 7.60200e-08 0.000 8.00000e-08 0.000 8.00200e-08 1.800 8.20000e-08 1.800 8.20200e-08 0.000 8.60000e-08 0.000
+ 8.60200e-08 1.800 9.00000e-08 1.800 9.00200e-08 0.000 9.20000e-08 0.000 9.20200e-08 1.800 9.60000e-08 1.800
+ 9.60200e-08 0.000 9.80000e-08 0.000
+ )
Xs_c0 src_c0 drv_c0 vdd gnd tb_x1
Xd_c0 drv_c0 c0 vdd gnd tb_x2
Xl_s0 s0 lo_s0 vdd gnd tb_x1
Xl_s1 s1 lo_s1 vdd gnd tb_x1
Xl_s2 s2 lo_s2 vdd gnd tb_x1
Xl_s3 s3 lo_s3 vdd gnd tb_x1
Xl_c4 c4 lo_c4 vdd gnd tb_x1
X0 a0 a1 a2 a3 b0 b1 b2 b3 c0 s0 s1 s2 s3 c4 vdd gnd cla_c4
.tran 20p 9.80000e-08
.control
set wr_singlescale
set wr_vecnames
run
wrdata seg19.txt v(a0) v(a1) v(a2) v(a3) v(b0) v(b1) v(b2) v(b3) v(c0) v(drv_a0) v(drv_a1) v(drv_a2) v(drv_a3) v(drv_b0) v(drv_b1) v(drv_b2) v(drv_b3) v(drv_c0) v(s0) v(s1) v(s2) v(s3) v(c4)
quit
.endc
.end
