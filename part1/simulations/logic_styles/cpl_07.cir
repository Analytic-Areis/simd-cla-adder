* CPL {'k': 0.5, 'm': 2, 'restore': 1}
.include ../../spice/models/TSMC_180nm.txt
.options reltol=1e-4
VDD vdd_core gnd 1.8
Vsense vdd_core vdd 0
VTB vtb gnd 1.8
Vg g gnd 0
Vt t gnd 1.8
Vgb gb gnd 1.8
Vtbar tb gnd 0
Vp p gnd 1.8
Vpb pb gnd 0
Va a gnd 1.8
Vab ab gnd 0
Vs s gnd PWL(0 0 1n 0 1.015n 1.8 3n 1.8 3.015n 0 5n 0 5.015n 1.8 7n 1.8 7.015n 0 9n 0)
Vsb sb gnd PWL(0 1.8 1n 1.8 1.015n 0 3n 0 3.015n 1.8 5n 1.8 5.015n 0 7n 0 7.015n 1.8 9n 1.8)
MD0 s1 s vtb vtb CMOSP W=1.800u L=0.18u AS=0.8100p AD=0.8100p PS=4.500u PD=4.500u
MD1 s1 s gnd gnd CMOSN W=0.900u L=0.18u AS=0.4050p AD=0.4050p PS=2.700u PD=2.700u
MD2 c0 s1 vtb vtb CMOSP W=3.600u L=0.18u AS=1.6200p AD=1.6200p PS=8.100u PD=8.100u
MD3 c0 s1 gnd gnd CMOSN W=1.800u L=0.18u AS=0.8100p AD=0.8100p PS=4.500u PD=4.500u
MD4 sb1 sb vtb vtb CMOSP W=1.800u L=0.18u AS=0.8100p AD=0.8100p PS=4.500u PD=4.500u
MD5 sb1 sb gnd gnd CMOSN W=0.900u L=0.18u AS=0.4050p AD=0.4050p PS=2.700u PD=2.700u
MD6 c0b sb1 vtb vtb CMOSP W=3.600u L=0.18u AS=1.6200p AD=1.6200p PS=8.100u PD=8.100u
MD7 c0b sb1 gnd gnd CMOSN W=1.800u L=0.18u AS=0.8100p AD=0.8100p PS=4.500u PD=4.500u
MD8 ld0_0 c1 vtb vtb CMOSP W=1.800u L=0.18u AS=0.8100p AD=0.8100p PS=4.500u PD=4.500u
MD9 ld0_0 c1 gnd gnd CMOSN W=0.900u L=0.18u AS=0.4050p AD=0.4050p PS=2.700u PD=2.700u
MD10 ldb0_0 c1b vtb vtb CMOSP W=1.800u L=0.18u AS=0.8100p AD=0.8100p PS=4.500u PD=4.500u
MD11 ldb0_0 c1b gnd gnd CMOSN W=0.900u L=0.18u AS=0.4050p AD=0.4050p PS=2.700u PD=2.700u
MD12 ld1_0 c2 vtb vtb CMOSP W=1.800u L=0.18u AS=0.8100p AD=0.8100p PS=4.500u PD=4.500u
MD13 ld1_0 c2 gnd gnd CMOSN W=0.900u L=0.18u AS=0.4050p AD=0.4050p PS=2.700u PD=2.700u
MD14 ldb1_0 c2b vtb vtb CMOSP W=1.800u L=0.18u AS=0.8100p AD=0.8100p PS=4.500u PD=4.500u
MD15 ldb1_0 c2b gnd gnd CMOSN W=0.900u L=0.18u AS=0.4050p AD=0.4050p PS=2.700u PD=2.700u
MD16 ld2_0 c3 vtb vtb CMOSP W=1.800u L=0.18u AS=0.8100p AD=0.8100p PS=4.500u PD=4.500u
MD17 ld2_0 c3 gnd gnd CMOSN W=0.900u L=0.18u AS=0.4050p AD=0.4050p PS=2.700u PD=2.700u
MD18 ldb2_0 c3b vtb vtb CMOSP W=1.800u L=0.18u AS=0.8100p AD=0.8100p PS=4.500u PD=4.500u
MD19 ldb2_0 c3b gnd gnd CMOSN W=0.900u L=0.18u AS=0.4050p AD=0.4050p PS=2.700u PD=2.700u
MD20 ld3_0 c4 vtb vtb CMOSP W=1.800u L=0.18u AS=0.8100p AD=0.8100p PS=4.500u PD=4.500u
MD21 ld3_0 c4 gnd gnd CMOSN W=0.900u L=0.18u AS=0.4050p AD=0.4050p PS=2.700u PD=2.700u
MD22 ldb3_0 c4b vtb vtb CMOSP W=1.800u L=0.18u AS=0.8100p AD=0.8100p PS=4.500u PD=4.500u
MD23 ldb3_0 c4b gnd gnd CMOSN W=0.900u L=0.18u AS=0.4050p AD=0.4050p PS=2.700u PD=2.700u
MD24 ld3_1 c4 vtb vtb CMOSP W=1.800u L=0.18u AS=0.8100p AD=0.8100p PS=4.500u PD=4.500u
MD25 ld3_1 c4 gnd gnd CMOSN W=0.900u L=0.18u AS=0.4050p AD=0.4050p PS=2.700u PD=2.700u
MD26 ldb3_1 c4b vtb vtb CMOSP W=1.800u L=0.18u AS=0.8100p AD=0.8100p PS=4.500u PD=4.500u
MD27 ldb3_1 c4b gnd gnd CMOSN W=0.900u L=0.18u AS=0.4050p AD=0.4050p PS=2.700u PD=2.700u
MD28 ld3_2 c4 vtb vtb CMOSP W=1.800u L=0.18u AS=0.8100p AD=0.8100p PS=4.500u PD=4.500u
MD29 ld3_2 c4 gnd gnd CMOSN W=0.900u L=0.18u AS=0.4050p AD=0.4050p PS=2.700u PD=2.700u
MD30 ldb3_2 c4b vtb vtb CMOSP W=1.800u L=0.18u AS=0.8100p AD=0.8100p PS=4.500u PD=4.500u
MD31 ldb3_2 c4b gnd gnd CMOSN W=0.900u L=0.18u AS=0.4050p AD=0.4050p PS=2.700u PD=2.700u
MD32 ld3_3 c4 vtb vtb CMOSP W=1.800u L=0.18u AS=0.8100p AD=0.8100p PS=4.500u PD=4.500u
MD33 ld3_3 c4 gnd gnd CMOSN W=0.900u L=0.18u AS=0.4050p AD=0.4050p PS=2.700u PD=2.700u
MD34 ldb3_3 c4b vtb vtb CMOSP W=1.800u L=0.18u AS=0.8100p AD=0.8100p PS=4.500u PD=4.500u
MD35 ldb3_3 c4b gnd gnd CMOSN W=0.900u L=0.18u AS=0.4050p AD=0.4050p PS=2.700u PD=2.700u
M0 x0 p c0 gnd CMOSN W=0.450u L=0.18u AS=0.2025p AD=0.2025p PS=1.800u PD=1.800u
M1 x0 pb a gnd CMOSN W=0.450u L=0.18u AS=0.2025p AD=0.2025p PS=1.800u PD=1.800u
M2 xb0 p c0b gnd CMOSN W=0.450u L=0.18u AS=0.2025p AD=0.2025p PS=1.800u PD=1.800u
M3 xb0 pb ab gnd CMOSN W=0.450u L=0.18u AS=0.2025p AD=0.2025p PS=1.800u PD=1.800u
M4 x0 xb0 vdd vdd CMOSP W=0.270u L=0.18u AS=0.1215p AD=0.1215p PS=1.440u PD=1.440u
M5 xb0 x0 vdd vdd CMOSP W=0.270u L=0.18u AS=0.1215p AD=0.1215p PS=1.440u PD=1.440u
M6 c1 xb0 vdd vdd CMOSP W=3.600u L=0.18u AS=1.6200p AD=1.6200p PS=8.100u PD=8.100u
M7 c1 xb0 gnd gnd CMOSN W=1.800u L=0.18u AS=0.8100p AD=0.8100p PS=4.500u PD=4.500u
M8 c1b x0 vdd vdd CMOSP W=3.600u L=0.18u AS=1.6200p AD=1.6200p PS=8.100u PD=8.100u
M9 c1b x0 gnd gnd CMOSN W=1.800u L=0.18u AS=0.8100p AD=0.8100p PS=4.500u PD=4.500u
M10 x1 p c1 gnd CMOSN W=0.450u L=0.18u AS=0.2025p AD=0.2025p PS=1.800u PD=1.800u
M11 x1 pb a gnd CMOSN W=0.450u L=0.18u AS=0.2025p AD=0.2025p PS=1.800u PD=1.800u
M12 xb1 p c1b gnd CMOSN W=0.450u L=0.18u AS=0.2025p AD=0.2025p PS=1.800u PD=1.800u
M13 xb1 pb ab gnd CMOSN W=0.450u L=0.18u AS=0.2025p AD=0.2025p PS=1.800u PD=1.800u
M14 x1 xb1 vdd vdd CMOSP W=0.270u L=0.18u AS=0.1215p AD=0.1215p PS=1.440u PD=1.440u
M15 xb1 x1 vdd vdd CMOSP W=0.270u L=0.18u AS=0.1215p AD=0.1215p PS=1.440u PD=1.440u
M16 c2 xb1 vdd vdd CMOSP W=3.600u L=0.18u AS=1.6200p AD=1.6200p PS=8.100u PD=8.100u
M17 c2 xb1 gnd gnd CMOSN W=1.800u L=0.18u AS=0.8100p AD=0.8100p PS=4.500u PD=4.500u
M18 c2b x1 vdd vdd CMOSP W=3.600u L=0.18u AS=1.6200p AD=1.6200p PS=8.100u PD=8.100u
M19 c2b x1 gnd gnd CMOSN W=1.800u L=0.18u AS=0.8100p AD=0.8100p PS=4.500u PD=4.500u
M20 x2 p c2 gnd CMOSN W=0.450u L=0.18u AS=0.2025p AD=0.2025p PS=1.800u PD=1.800u
M21 x2 pb a gnd CMOSN W=0.450u L=0.18u AS=0.2025p AD=0.2025p PS=1.800u PD=1.800u
M22 xb2 p c2b gnd CMOSN W=0.450u L=0.18u AS=0.2025p AD=0.2025p PS=1.800u PD=1.800u
M23 xb2 pb ab gnd CMOSN W=0.450u L=0.18u AS=0.2025p AD=0.2025p PS=1.800u PD=1.800u
M24 x2 xb2 vdd vdd CMOSP W=0.270u L=0.18u AS=0.1215p AD=0.1215p PS=1.440u PD=1.440u
M25 xb2 x2 vdd vdd CMOSP W=0.270u L=0.18u AS=0.1215p AD=0.1215p PS=1.440u PD=1.440u
M26 c3 xb2 vdd vdd CMOSP W=3.600u L=0.18u AS=1.6200p AD=1.6200p PS=8.100u PD=8.100u
M27 c3 xb2 gnd gnd CMOSN W=1.800u L=0.18u AS=0.8100p AD=0.8100p PS=4.500u PD=4.500u
M28 c3b x2 vdd vdd CMOSP W=3.600u L=0.18u AS=1.6200p AD=1.6200p PS=8.100u PD=8.100u
M29 c3b x2 gnd gnd CMOSN W=1.800u L=0.18u AS=0.8100p AD=0.8100p PS=4.500u PD=4.500u
M30 x3 p c3 gnd CMOSN W=0.450u L=0.18u AS=0.2025p AD=0.2025p PS=1.800u PD=1.800u
M31 x3 pb a gnd CMOSN W=0.450u L=0.18u AS=0.2025p AD=0.2025p PS=1.800u PD=1.800u
M32 xb3 p c3b gnd CMOSN W=0.450u L=0.18u AS=0.2025p AD=0.2025p PS=1.800u PD=1.800u
M33 xb3 pb ab gnd CMOSN W=0.450u L=0.18u AS=0.2025p AD=0.2025p PS=1.800u PD=1.800u
M34 x3 xb3 vdd vdd CMOSP W=0.270u L=0.18u AS=0.1215p AD=0.1215p PS=1.440u PD=1.440u
M35 xb3 x3 vdd vdd CMOSP W=0.270u L=0.18u AS=0.1215p AD=0.1215p PS=1.440u PD=1.440u
M36 c4 xb3 vdd vdd CMOSP W=3.600u L=0.18u AS=1.6200p AD=1.6200p PS=8.100u PD=8.100u
M37 c4 xb3 gnd gnd CMOSN W=1.800u L=0.18u AS=0.8100p AD=0.8100p PS=4.500u PD=4.500u
M38 c4b x3 vdd vdd CMOSP W=3.600u L=0.18u AS=1.6200p AD=1.6200p PS=8.100u PD=8.100u
M39 c4b x3 gnd gnd CMOSN W=1.800u L=0.18u AS=0.8100p AD=0.8100p PS=4.500u PD=4.500u
.tran 2p 9n
.meas tran tpr TRIG v(c0) VAL=0.9 RISE=1 TARG v(c4) VAL=0.9 RISE=1
.meas tran pavg AVG i(Vsense) FROM=0.5n TO=8.5n
.meas tran tpf TRIG v(c0) VAL=0.9 FALL=1 TARG v(c4) VAL=0.9 FALL=1
.meas tran vlo FIND v(c4) AT=0.95n
.meas tran vhi FIND v(c4) AT=2.95n
.meas tran vlo2 FIND v(c4) AT=4.95n
.end
