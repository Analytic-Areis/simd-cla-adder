* NGSPICE file created from nand3_x1.ext - technology: scmos

.global Vdd Gnd

.subckt nand3_x1 i0 i1 i2 y vdd gnd
M1000 vdd i0 y vdd pfet w=1.8u l=0.18u
+  ad=0.567p pd=2.43u as=0.972p ps=4.68u
M1001 y i1 vdd vdd pfet w=1.8u l=0.18u
+  ad=0.567p pd=2.43u as=0.567p ps=2.43u
M1002 vdd i2 y vdd pfet w=1.8u l=0.18u
+  ad=0.81p pd=4.5u as=0.567p ps=2.43u
M1003 a_16_10# i0 y Gnd nfet w=2.7u l=0.18u
+  ad=0.8505p pd=3.33u as=1.458p ps=6.48u
M1004 a_25_10# i1 a_16_10# Gnd nfet w=2.7u l=0.18u
+  ad=0.8505p pd=3.33u as=0.8505p ps=3.33u
M1005 gnd i2 a_25_10# Gnd nfet w=2.7u l=0.18u
+  ad=1.215p pd=6.3u as=0.8505p ps=3.33u
C0 i2 gnd 0.0042f
C1 i0 y 0.21329f
C2 i1 i2 0.47499f
C3 vdd i1 0.02202f
C4 a_16_10# y 0
C5 y gnd 0.04128f
C6 i0 gnd 0.00105f
C7 i1 y 0.02203f
C8 a_16_10# gnd 0
C9 i0 i1 0.47479f
C10 vdd i2 0.02342f
C11 i2 y 0.00622f
C12 i1 gnd 0.00105f
C13 a_25_10# gnd 0.00101f
C14 vdd y 0.60204f
C15 i0 i2 0.00926f
C16 vdd i0 0.02222f
.ends
