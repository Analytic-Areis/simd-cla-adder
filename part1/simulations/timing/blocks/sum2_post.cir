* block timing sum2_post
.include ../../../spice/models/TSMC_180nm.txt
.options reltol=1e-4
VDD vdd gnd 1.8
* NGSPICE file created from sum2_b.ext - technology: scmos

.subckt sum2_b c2 p2 p2b s2 vdd gnd
M1000 x2_s1xp1 x2_cb s2 vdd CMOSP w=2.88u l=0.18u
+  ad=0.9072p pd=3.51u as=0.9072p ps=3.51u
M1001 gnd x2_cb a_34_10# Gnd CMOSN w=1.44u l=0.18u
+  ad=0.4212p pd=2.07u as=0.4536p ps=2.07u
M1002 vdd c2 x2_s1xp1 vdd CMOSP w=2.88u l=0.18u
+  ad=1.296p pd=6.66u as=0.9072p ps=3.51u
M1003 vdd c2 x2_cb vdd CMOSP w=2.25u l=0.18u
+  ad=0.8748p pd=3.51u as=1.215p ps=5.58u
M1004 a_16_10# c2 gnd Gnd CMOSN w=1.44u l=0.18u
+  ad=0.4536p pd=2.07u as=0.7776p ps=3.96u
M1005 x2_s1xp1 p2 vdd vdd CMOSP w=2.88u l=0.18u
+  ad=0.9072p pd=3.51u as=0.8748p ps=3.51u
M1006 s2 p2 a_16_10# Gnd CMOSN w=1.44u l=0.18u
+  ad=0.4536p pd=2.07u as=0.4536p ps=2.07u
M1007 x2_cb c2 gnd Gnd CMOSN w=1.08u l=0.18u
+  ad=0.486p pd=3.06u as=0.4212p ps=2.07u
M1008 s2 p2b x2_s1xp1 vdd CMOSP w=2.88u l=0.18u
+  ad=0.9072p pd=3.51u as=0.9072p ps=3.51u
M1009 a_34_10# p2b s2 Gnd CMOSN w=1.44u l=0.18u
+  ad=0.4536p pd=2.07u as=0.4536p ps=2.07u
C0 c2 gnd 0.00525f
C1 p2 s2 0.15887f
C2 p2b c2 0.01832f
C3 a_16_10# s2 0
C4 vdd p2b 0.02078f
C5 x2_s1xp1 p2b 0.27763f
C6 x2_cb c2 0.70628f
C7 x2_cb vdd 0.23853f
C8 x2_cb x2_s1xp1 0.01314f
C9 s2 gnd 0.04131f
C10 p2 gnd 0.00105f
C11 p2b s2 0.09333f
C12 a_34_10# s2 0
C13 a_16_10# gnd 0
C14 vdd c2 0.04483f
C15 p2 p2b 0.2539f
C16 x2_s1xp1 c2 0.00589f
C17 x2_cb s2 0.08434f
C18 x2_s1xp1 vdd 0.63524f
C19 x2_cb p2 0.01812f
C20 c2 s2 0.0228f
C21 p2b gnd 0.00105f
C22 vdd s2 0.05286f
C23 p2 c2 0.584f
C24 a_34_10# gnd 0
C25 x2_s1xp1 s2 0.92987f
C26 x2_cb gnd 0.10224f
C27 vdd p2 0.02306f
C28 x2_s1xp1 p2 0.00591f
C29 x2_cb p2b 0.26268f
.ends

.subckt sum2x_post c2 p2 p2b s2 vdd gnd
X0 c2 p2 p2b s2 vdd gnd sum2_b
.ends
.subckt tb_x1 a y vdd gnd
mp y a vdd vdd CMOSP W=1.8e-06 L=1.8e-07 AS=9.72e-13 PS=4.68e-06 AD=9.72e-13 PD=4.68e-06
mn y a gnd gnd CMOSN W=9.0e-07 L=1.8e-07 AS=4.86e-13 PS=2.88e-06 AD=4.86e-13 PD=2.88e-06
.ends
Vc2 src_c2 gnd PWL(
+ 0.00000e+00 1.800 2.00000e-09 1.800 2.02000e-09 0.000 4.00000e-09 0.000 4.02000e-09 1.800 8.00000e-09 1.800
+ 8.02000e-09 0.000 1.40000e-08 0.000 1.40200e-08 1.800 1.80000e-08 1.800
+ )
Xd_c2 src_c2 c2 vdd gnd tb_x1
Vp2 src_p2 gnd PWL(
+ 0.00000e+00 1.800 6.00000e-09 1.800 6.02000e-09 0.000 1.00000e-08 0.000 1.00200e-08 1.800 1.20000e-08 1.800
+ 1.20200e-08 0.000 1.60000e-08 0.000 1.60200e-08 1.800 1.80000e-08 1.800
+ )
Xd_p2 src_p2 p2 vdd gnd tb_x1
Vp2b src_p2b gnd PWL(
+ 0.00000e+00 0.000 6.00000e-09 0.000 6.02000e-09 1.800 1.00000e-08 1.800 1.00200e-08 0.000 1.20000e-08 0.000
+ 1.20200e-08 1.800 1.60000e-08 1.800 1.60200e-08 0.000 1.80000e-08 0.000
+ )
Xd_p2b src_p2b p2b vdd gnd tb_x1
Xl_s2 s2 lo_s2 vdd gnd tb_x1
X0 c2 p2 p2b s2 vdd gnd sum2x_post
.tran 20p 1.80000e-08
.control
set wr_singlescale
set wr_vecnames
run
wrdata sum2_post.txt v(c2) v(p2) v(p2b) v(s2)
quit
.endc
.end
