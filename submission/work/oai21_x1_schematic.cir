* oai21_x1_schematic
.include ../../part1/spice/models/TSMC_180nm.txt
.options reltol=1e-4
VDD vdd gnd 1.8
* oai21_x1: NOT((a + b) c)
* GENERATED from part1/cells/library.py. Do not edit by hand.
.subckt oai21_x1 a b c y vdd gnd
Mp1 xp1 a vdd vdd CMOSP W=3.6000e-06 L=1.8000e-07 AS=1.9440e-12 PS=8.2800e-06 AD=9.7200e-13 PD=7.7400e-06
Mp2 y b xp1 vdd CMOSP W=3.6000e-06 L=1.8000e-07 AS=9.7200e-13 PS=7.7400e-06 AD=1.9440e-12 PD=8.2800e-06
Mp3 y c vdd vdd CMOSP W=1.8000e-06 L=1.8000e-07 AS=9.7200e-13 PS=4.6800e-06 AD=9.7200e-13 PD=4.6800e-06
Mn1 y a xn1 gnd CMOSN W=1.8000e-06 L=1.8000e-07 AS=9.7200e-13 PS=4.6800e-06 AD=9.7200e-13 PD=4.6800e-06
Mn2 y b xn1 gnd CMOSN W=1.8000e-06 L=1.8000e-07 AS=9.7200e-13 PS=4.6800e-06 AD=9.7200e-13 PD=4.6800e-06
Mn3 xn1 c gnd gnd CMOSN W=1.8000e-06 L=1.8000e-07 AS=9.7200e-13 PS=4.6800e-06 AD=9.7200e-13 PD=4.6800e-06
.ends oai21_x1
.subckt tb_x1 a y vdd gnd
mp y a vdd vdd CMOSP W=1.8e-06 L=1.8e-07 AS=9.72e-13 PS=4.68e-06 AD=9.72e-13 PD=4.68e-06
mn y a gnd gnd CMOSN W=9.0e-07 L=1.8e-07 AS=4.86e-13 PS=2.88e-06 AD=4.86e-13 PD=2.88e-06
.ends
.subckt tb_x2 a y vdd gnd
mp y a vdd vdd CMOSP W=3.6e-06 L=1.8e-07 AS=1.944e-12 PS=8.28e-06 AD=1.944e-12 PD=8.28e-06
mn y a gnd gnd CMOSN W=1.8e-06 L=1.8e-07 AS=9.72e-13 PS=4.68e-06 AD=9.72e-13 PD=4.68e-06
.ends
Va src_a gnd PWL(
+ 0.00000e+00 0.000 1.00000e-09 0.000 1.02000e-09 1.800 2.00000e-09 1.800 2.02000e-09 0.000 4.00000e-09 0.000
+ 4.02000e-09 1.800 5.00000e-09 1.800 5.02000e-09 0.000 8.00000e-09 0.000 8.02000e-09 1.800 9.00000e-09 1.800
+ 9.02000e-09 0.000 1.10000e-08 0.000 1.10200e-08 1.800 2.00000e-08 1.800 2.00200e-08 0.000 2.50000e-08 0.000
+ )
Xs_a src_a drv_a vdd gnd tb_x1
Xd_a drv_a a vdd gnd tb_x2
Vb src_b gnd PWL(
+ 0.00000e+00 0.000 3.00000e-09 0.000 3.02000e-09 1.800 6.00000e-09 1.800 6.02000e-09 0.000 1.00000e-08 0.000
+ 1.00200e-08 1.800 1.20000e-08 1.800 1.20200e-08 0.000 1.30000e-08 0.000 1.30200e-08 1.800 1.50000e-08 1.800
+ 1.50200e-08 0.000 1.80000e-08 0.000 1.80200e-08 1.800 2.30000e-08 1.800 2.30200e-08 0.000 2.50000e-08 0.000
+ )
Xs_b src_b drv_b vdd gnd tb_x1
Xd_b drv_b b vdd gnd tb_x2
Vc src_c gnd PWL(
+ 0.00000e+00 0.000 7.00000e-09 0.000 7.02000e-09 1.800 1.40000e-08 1.800 1.40200e-08 0.000 1.60000e-08 0.000
+ 1.60200e-08 1.800 1.70000e-08 1.800 1.70200e-08 0.000 1.90000e-08 0.000 1.90200e-08 1.800 2.10000e-08 1.800
+ 2.10200e-08 0.000 2.20000e-08 0.000 2.20200e-08 1.800 2.40000e-08 1.800 2.40200e-08 0.000 2.50000e-08 0.000
+ )
Xs_c src_c drv_c vdd gnd tb_x1
Xd_c drv_c c vdd gnd tb_x2
Xl_y y lo_y vdd gnd tb_x1
X0 a b c y vdd gnd oai21_x1
.tran 5p 2.50000e-08
.control
set wr_singlescale
set wr_vecnames
run
wrdata oai21_x1_schematic.txt v(a) v(b) v(c) v(y)
quit
.endc
.end
