* NGSPICE file created from sum0_b.ext - technology: scmos

.global Vdd Gnd

.subckt sum0_b c0 p0 p0b s0 vdd gnd
M1000 x0_s1xp1 x0_cb s0 vdd pfet w=4.5u l=0.18u
+  ad=1.4175p pd=5.13u as=1.4175p ps=5.13u
M1001 gnd x0_cb a_34_10# Gnd nfet w=2.25u l=0.18u
+  ad=0.5427p pd=2.88u as=0.7047p ps=2.88u
M1002 vdd c0 x0_cb vdd pfet w=0.9u l=0.18u
+  ad=1.2555p pd=5.13u as=0.486p ps=2.88u
M1003 s0 p0b x0_s1xp1 vdd pfet w=4.5u l=0.18u
+  ad=1.4175p pd=5.13u as=1.4175p ps=5.13u
M1004 a_16_10# c0 gnd Gnd nfet w=2.25u l=0.18u
+  ad=0.7047p pd=2.88u as=1.215p ps=5.58u
M1005 vdd c0 x0_s1xp1 vdd pfet w=4.5u l=0.18u
+  ad=2.025p pd=9.9u as=1.4175p ps=5.13u
M1006 s0 p0 a_16_10# Gnd nfet w=2.25u l=0.18u
+  ad=0.7047p pd=2.88u as=0.7047p ps=2.88u
M1007 x0_cb c0 gnd Gnd nfet w=0.45u l=0.18u
+  ad=0.2025p pd=1.8u as=0.5427p ps=2.88u
M1008 x0_s1xp1 p0 vdd vdd pfet w=4.5u l=0.18u
+  ad=1.4175p pd=5.13u as=1.2555p ps=5.13u
M1009 a_34_10# p0b s0 Gnd nfet w=2.25u l=0.18u
+  ad=0.7047p pd=2.88u as=0.7047p ps=2.88u
C0 x0_s1xp1 s0 1.2274f
C1 x0_cb gnd 0.04512f
C2 vdd p0 0.02451f
C3 x0_s1xp1 p0 0.00737f
C4 x0_cb p0b 0.26268f
C5 c0 gnd 0.00492f
C6 p0 s0 0.1596f
C7 p0b c0 0.01832f
C8 a_16_10# s0 0
C9 vdd p0b 0.02078f
C10 x0_s1xp1 p0b 0.27909f
C11 x0_cb c0 0.7045f
C12 x0_cb vdd 0.11378f
C13 x0_cb x0_s1xp1 0.01459f
C14 s0 gnd 0.04131f
C15 p0 gnd 0.00105f
C16 p0b s0 0.09551f
C17 a_34_10# s0 0
C18 a_16_10# gnd 0
C19 vdd c0 0.04507f
C20 p0 p0b 0.2539f
C21 x0_s1xp1 c0 0.00735f
C22 x0_cb s0 0.0858f
C23 x0_s1xp1 vdd 0.93422f
C24 x0_cb p0 0.01812f
C25 c0 s0 0.0228f
C26 p0b gnd 0.00105f
C27 vdd s0 0.05358f
C28 p0 c0 0.584f
C29 a_34_10# gnd 0
.ends
