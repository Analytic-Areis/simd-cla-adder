* block timing carry_post
.include ../../../spice/models/TSMC_180nm.txt
.options reltol=1e-4
VDD vdd gnd 1.8
* NGSPICE file created from carry_b.ext - technology: scmos

.subckt carry_b c0 c1 c2 c3 c4 g0b g1b g2b g3b t0b t1b t2b t3b vdd gnd
M1000 a_34_148# t0b vdd vdd CMOSP w=1.8u l=0.18u
+  ad=0.567p pd=2.43u as=0.972p ps=4.68u
M1001 gnd t1_0 a_277_10# Gnd CMOSN w=2.25u l=0.18u
+  ad=1.0125p pd=5.4u as=0.7047p ps=2.88u
M1002 g32_xn1 g2b g3_2 Gnd CMOSN w=1.44u l=0.18u
+  ad=0.4536p pd=2.07u as=0.4536p ps=2.07u
M1003 t1_0 t0b a_106_148# vdd CMOSP w=5.58u l=0.18u
+  ad=2.511p pd=12.06u as=1.7577p ps=6.21u
M1004 c2 c0b a_169_148# vdd CMOSP w=4.5u l=0.18u
+  ad=1.215p pd=5.13u as=1.4175p ps=5.13u
M1005 g30_xp1 g3_2 vdd vdd CMOSP w=1.44u l=0.18u
+  ad=0.4536p pd=2.07u as=0.7776p ps=3.96u
M1006 a_466_148# c0b vdd vdd CMOSP w=2.88u l=0.18u
+  ad=0.9072p pd=3.51u as=1.5552p ps=6.84u
M1007 c2_xn1 c0b gnd Gnd CMOSN w=2.25u l=0.18u
+  ad=0.7047p pd=2.88u as=0.7047p ps=2.88u
M1008 c3 c0b a_304_148# vdd CMOSP w=4.5u l=0.18u
+  ad=1.215p pd=5.13u as=1.4175p ps=5.13u
M1009 a_376_148# t3b vdd vdd CMOSP w=2.88u l=0.18u
+  ad=0.9072p pd=3.51u as=1.5552p ps=6.84u
M1010 g2_0b g1_0 a_250_15# Gnd CMOSN w=1.8u l=0.18u
+  ad=0.81p pd=4.5u as=0.567p ps=2.43u
M1011 t1_0 t0b gnd Gnd CMOSN w=1.44u l=0.18u
+  ad=0.648p pd=3.78u as=0.4536p ps=2.07u
M1012 vdd g0b c1 vdd CMOSP w=0.9u l=0.18u
+  ad=0.405p pd=2.7u as=0.486p ps=2.43u
M1013 vdd t2b t2 vdd CMOSP w=3.51u l=0.18u
+  ad=1.5795p pd=7.92u as=1.8954p ps=8.1u
M1014 t2_0b t1_0 vdd vdd CMOSP w=2.25u l=0.18u
+  ad=1.0125p pd=5.4u as=0.7047p ps=2.88u
M1015 vdd g1_0 g1_0b vdd CMOSP w=1.8u l=0.18u
+  ad=0.81p pd=4.5u as=0.972p ps=4.68u
M1016 vdd g3_0b c4 vdd CMOSP w=1.44u l=0.18u
+  ad=0.648p pd=3.78u as=0.7776p ps=3.51u
M1017 g3_0b g1_0 a_412_27# Gnd CMOSN w=0.72u l=0.18u
+  ad=0.324p pd=2.34u as=0.2268p ps=1.35u
M1018 g30_xp1 g1_0 g3_0b vdd CMOSP w=1.44u l=0.18u
+  ad=0.648p pd=3.78u as=0.4536p ps=2.07u
M1019 gnd c0b c4g_xn1 Gnd CMOSN w=1.44u l=0.18u
+  ad=0.4536p pd=2.07u as=0.7776p ps=3.96u
M1020 c2 g1_0b c2_xn1 Gnd CMOSN w=2.25u l=0.18u
+  ad=1.0125p pd=5.4u as=0.7047p ps=2.88u
M1021 gnd g3b g32_xn1 Gnd CMOSN w=1.44u l=0.18u
+  ad=0.648p pd=3.78u as=0.4536p ps=2.07u
M1022 g20_xp1 g2 vdd vdd CMOSP w=3.6u l=0.18u
+  ad=1.134p pd=4.23u as=1.944p ps=8.28u
M1023 a_70_148# t1b vdd vdd CMOSP w=4.5u l=0.18u
+  ad=1.4175p pd=5.13u as=2.43p ps=10.08u
M1024 vdd t1_0 t1_0b vdd CMOSP w=2.79u l=0.18u
+  ad=1.2555p pd=6.48u as=1.5066p ps=6.66u
M1025 vdd t3_2 t3_0b vdd CMOSP w=0.72u l=0.18u
+  ad=0.2268p pd=1.35u as=0.3888p ps=2.52u
M1026 gnd t1b g10_xn1 Gnd CMOSN w=2.25u l=0.18u
+  ad=0.7047p pd=2.88u as=1.215p ps=5.58u
M1027 gnd g2b g2 Gnd CMOSN w=1.08u l=0.18u
+  ad=0.486p pd=3.06u as=0.5832p ps=3.24u
M1028 gnd g2 g2_0b Gnd CMOSN w=0.9u l=0.18u
+  ad=0.5265p pd=2.43u as=0.486p ps=2.88u
M1029 g3_2 g2b a_340_148# vdd CMOSP w=2.88u l=0.18u
+  ad=0.7776p pd=3.51u as=0.9072p ps=3.51u
M1030 c1 t0b c1_xn1 Gnd CMOSN w=0.9u l=0.18u
+  ad=0.2835p pd=1.53u as=0.486p ps=2.88u
M1031 g20_xp1 g1_0 g2_0b vdd CMOSP w=3.6u l=0.18u
+  ad=1.62p pd=8.1u as=1.134p ps=4.23u
M1032 gnd t2_0b c3_xn1 Gnd CMOSN w=2.25u l=0.18u
+  ad=0.7047p pd=2.88u as=1.215p ps=5.58u
M1033 c4g_xn1 t3_0b gnd Gnd CMOSN w=1.44u l=0.18u
+  ad=0.4536p pd=2.07u as=0.4536p ps=2.07u
M1034 vdd g1b g1_0 vdd CMOSP w=2.25u l=0.18u
+  ad=1.0125p pd=5.4u as=1.215p ps=5.13u
M1035 gnd t1_0 t1_0b Gnd CMOSN w=1.44u l=0.18u
+  ad=0.648p pd=3.78u as=0.7776p ps=3.96u
M1036 a_106_148# t1b vdd vdd CMOSP w=5.58u l=0.18u
+  ad=1.7577p pd=6.21u as=3.0132p ps=12.24u
M1037 a_169_148# t1_0b vdd vdd CMOSP w=4.5u l=0.18u
+  ad=1.4175p pd=5.13u as=2.43p ps=10.08u
M1038 a_412_27# t3_2 gnd Gnd CMOSN w=0.72u l=0.18u
+  ad=0.2268p pd=1.35u as=0.2106p ps=1.35u
M1039 a_304_148# t2_0b vdd vdd CMOSP w=4.5u l=0.18u
+  ad=1.4175p pd=5.13u as=2.43p ps=10.08u
M1040 vdd t2 t2_0b vdd CMOSP w=2.25u l=0.18u
+  ad=0.7047p pd=2.88u as=1.215p ps=5.58u
M1041 g10_xn1 g0b gnd Gnd CMOSN w=2.25u l=0.18u
+  ad=0.7047p pd=2.88u as=0.7047p ps=2.88u
M1042 c1 c0b a_34_148# vdd CMOSP w=1.8u l=0.18u
+  ad=0.486p pd=2.43u as=0.567p ps=2.43u
M1043 a_439_27# t3_2 t3_0b Gnd CMOSN w=0.72u l=0.18u
+  ad=0.2268p pd=1.35u as=0.3888p ps=2.52u
M1044 vdd g1_0b c2 vdd CMOSP w=2.25u l=0.18u
+  ad=1.0125p pd=5.4u as=1.215p ps=5.13u
M1045 g3_0b t3_2 g30_xp1 vdd CMOSP w=1.44u l=0.18u
+  ad=0.4536p pd=2.07u as=0.4536p ps=2.07u
M1046 c4 t3_0b a_466_148# vdd CMOSP w=2.88u l=0.18u
+  ad=0.7776p pd=3.51u as=0.9072p ps=3.51u
M1047 c1_xn1 c0b c1 Gnd CMOSN w=0.9u l=0.18u
+  ad=0.2835p pd=1.53u as=0.2835p ps=1.53u
M1048 vdd g2_0b c3 vdd CMOSP w=2.25u l=0.18u
+  ad=1.0125p pd=5.4u as=1.215p ps=5.13u
M1049 t3_2 t2b a_376_148# vdd CMOSP w=2.88u l=0.18u
+  ad=1.296p pd=6.66u as=0.9072p ps=3.51u
M1050 c3_xn1 c0b gnd Gnd CMOSN w=2.25u l=0.18u
+  ad=0.7047p pd=2.88u as=0.7047p ps=2.88u
M1051 c4 g3_0b c4g_xn1 Gnd CMOSN w=1.44u l=0.18u
+  ad=0.648p pd=3.78u as=0.4536p ps=2.07u
M1052 gnd t3b t3_2 Gnd CMOSN w=0.72u l=0.18u
+  ad=0.2268p pd=1.35u as=0.3888p ps=2.52u
M1053 g1_0 g1b g10_xn1 Gnd CMOSN w=2.25u l=0.18u
+  ad=1.0125p pd=5.4u as=0.7047p ps=2.88u
M1054 gnd t2b t2 Gnd CMOSN w=1.8u l=0.18u
+  ad=0.81p pd=4.5u as=0.972p ps=4.68u
M1055 a_277_10# t2 t2_0b Gnd CMOSN w=2.25u l=0.18u
+  ad=0.7047p pd=2.88u as=1.215p ps=5.58u
M1056 g3_2 t3b g32_xn1 Gnd CMOSN w=1.44u l=0.18u
+  ad=0.4536p pd=2.07u as=0.7776p ps=3.96u
M1057 gnd t1_0 a_439_27# Gnd CMOSN w=0.72u l=0.18u
+  ad=0.324p pd=2.34u as=0.2268p ps=1.35u
M1058 a_340_148# t3b vdd vdd CMOSP w=2.88u l=0.18u
+  ad=0.9072p pd=3.51u as=1.5552p ps=6.84u
M1059 gnd g0b c1_xn1 Gnd CMOSN w=0.9u l=0.18u
+  ad=0.405p pd=2.7u as=0.2835p ps=1.53u
M1060 gnd t1_0b c2_xn1 Gnd CMOSN w=2.25u l=0.18u
+  ad=0.7047p pd=2.88u as=1.215p ps=5.58u
M1061 c3 g2_0b c3_xn1 Gnd CMOSN w=2.25u l=0.18u
+  ad=1.0125p pd=5.4u as=0.7047p ps=2.88u
M1062 g2_0b t2 g20_xp1 vdd CMOSP w=3.6u l=0.18u
+  ad=1.134p pd=4.23u as=1.134p ps=4.23u
M1063 a_250_15# t2 gnd Gnd CMOSN w=1.8u l=0.18u
+  ad=0.567p pd=2.43u as=0.5265p ps=2.43u
M1064 t3_2 t2b gnd Gnd CMOSN w=0.72u l=0.18u
+  ad=0.324p pd=2.34u as=0.2268p ps=1.35u
M1065 vdd c0 c0b vdd CMOSP w=1.8u l=0.18u
+  ad=0.81p pd=4.5u as=0.972p ps=4.68u
M1066 g1_0 g0b a_70_148# vdd CMOSP w=4.5u l=0.18u
+  ad=1.215p pd=5.13u as=1.4175p ps=5.13u
M1067 gnd g1_0 g1_0b Gnd CMOSN w=0.9u l=0.18u
+  ad=0.405p pd=2.7u as=0.486p ps=2.88u
M1068 t3_0b t1_0 vdd vdd CMOSP w=0.72u l=0.18u
+  ad=0.324p pd=2.34u as=0.2268p ps=1.35u
M1069 gnd t1b t1_0 Gnd CMOSN w=1.44u l=0.18u
+  ad=0.4536p pd=2.07u as=0.7776p ps=3.96u
M1070 gnd g3_2 g3_0b Gnd CMOSN w=0.36u l=0.18u
+  ad=0.2106p pd=1.35u as=0.1944p ps=1.8u
M1071 vdd g3b g3_2 vdd CMOSP w=1.44u l=0.18u
+  ad=0.648p pd=3.78u as=0.7776p ps=3.51u
M1072 gnd c0 c0b Gnd CMOSN w=0.9u l=0.18u
+  ad=0.405p pd=2.7u as=0.486p ps=2.88u
M1073 vdd g2b g2 vdd CMOSP w=2.25u l=0.18u
+  ad=1.0125p pd=5.4u as=1.215p ps=5.58u
C0 t1_0 t3b 0.01787f
C1 g2 g1b 0.01874f
C2 a_340_148# vdd 0
C3 t2_0b g2b 0.40992f
C4 a_169_148# c2 0.00142f
C5 c1_xn1 c1 0.45573f
C6 g10_xn1 c0 0.25633f
C7 t3_0b t3_2 0.02286f
C8 t1_0 t2b 0.02701f
C9 t3_0b a_439_27# 0
C10 g3_2 g32_xn1 0.60189f
C11 g1_0 c3 0.01018f
C12 t2_0b g1b 0.02815f
C13 g2_0b vdd 0.03358f
C14 g10_xn1 t1b 0.01226f
C15 c1_xn1 t0b 0.21043f
C16 g3_0b c0 0.02841f
C17 g3b gnd 0.00202f
C18 c0b c3 0.085f
C19 g2 vdd 0.44752f
C20 g1_0 c2 0.0098f
C21 t1_0b c0 0.01874f
C22 a_466_148# vdd 0
C23 g2b gnd 0.0017f
C24 t3b g3b 0.01853f
C25 c0b c2 0.08507f
C26 t1_0 t0b 0.21833f
C27 t2_0b vdd 0.66659f
C28 g1_0 c0 0.03643f
C29 t3_2 g3_0b 0.73625f
C30 g20_xp1 g2_0b 1.17684f
C31 g1b gnd 0.00105f
C32 t2b g3b 0.0182f
C33 g2b t3b 0.553f
C34 a_106_148# vdd 0.00156f
C35 g1_0 t1b 0.01944f
C36 c0b c0 4.74401f
C37 t1_0 g3_2 0.01797f
C38 g2 g20_xp1 0.00652f
C39 g1_0 t3_2 0.4181f
C40 g1b t3b 0.01787f
C41 c0 c4 0.02319f
C42 g0b gnd 0.00533f
C43 t2b g2b 0.01787f
C44 a_34_148# vdd 0
C45 c0b t1b 0.01852f
C46 t2_0b a_277_10# 0
C47 t1_0 g32_xn1 0.25556f
C48 c0b t3_2 0.1748f
C49 t2_0b g20_xp1 0.3003f
C50 c0 c3 0.00903f
C51 g1b t2b 1.74088f
C52 t1_0b c2_xn1 0.12525f
C53 g1_0 c3_xn1 0.23789f
C54 g30_xp1 g3b 0.15641f
C55 g1_0 g2_0b 0.04581f
C56 t1_0 t2 0.41885f
C57 a_412_27# gnd 0
C58 c0 c2 0.00903f
C59 vdd t3b 0.04428f
C60 g1_0 c2_xn1 0.23789f
C61 c0b c3_xn1 0.16883f
C62 g3_2 g3b 0.53929f
C63 t3_0b gnd 0.00202f
C64 c0b g2_0b 0.55533f
C65 g1_0 g2 0.01874f
C66 t1_0 g1_0b 1.34505f
C67 g32_xn1 g3b 0.00463f
C68 t0b g1b 0.01852f
C69 a_277_10# gnd 0
C70 vdd t2b 0.04173f
C71 g0b c1 0.01929f
C72 c0b c2_xn1 0.16915f
C73 g30_xp1 g1b 0.01952f
C74 g3_2 g2b 0.0258f
C75 c0b g2 0.08731f
C76 g1_0 t2_0b 0.02853f
C77 g10_xn1 gnd 0.70201f
C78 vdd c1 0.17709f
C79 c3_xn1 c3 0.41817f
C80 t1b c0 0.01787f
C81 t0b g0b 0.01832f
C82 g32_xn1 g2b 0.20822f
C83 t3_2 c0 0.03689f
C84 g2_0b c3 0.12369f
C85 g3_2 g1b 0.01906f
C86 c0b t2_0b 0.47836f
C87 g3_0b gnd 0.03306f
C88 a_466_148# c4 0
C89 vdd t0b 0.04104f
C90 t1_0b gnd 0.26799f
C91 t2 g2b 0.70125f
C92 g30_xp1 vdd 0.15458f
C93 c2_xn1 c2 0.41817f
C94 c3_xn1 c0 0.01921f
C95 t2 g1b 0.02786f
C96 g3_2 vdd 0.29764f
C97 g2 c2 0.38138f
C98 g2_0b c0 0.02815f
C99 t1_0 g3b 0.01884f
C100 g1_0 gnd 0.04312f
C101 c2_xn1 c0 0.01921f
C102 t3_0b g30_xp1 0.27792f
C103 t3_0b c4g_xn1 0.01188f
C104 c0b gnd 0.09225f
C105 g1_0 t3b 0.44168f
C106 t1_0 g2b 0.02713f
C107 g1_0b g1b 0.01874f
C108 a_304_148# vdd 0.00113f
C109 g2 c0 0.01835f
C110 g10_xn1 t0b 0.23789f
C111 c1_xn1 g0b 0.00413f
C112 t1_0 g1b 0.03745f
C113 t2 vdd 0.69668f
C114 g1_0 t2b 0.02733f
C115 t2_0b c0 0.01835f
C116 c0b t3b 0.01852f
C117 c3 gnd 0.04126f
C118 g1_0b vdd 0.19837f
C119 g30_xp1 g3_0b 0.9464f
C120 g2_0b c3_xn1 0.00541f
C121 c0b t2b 0.02745f
C122 g3_0b c4g_xn1 0.00464f
C123 g2b g3b 0.38194f
C124 c2 gnd 0.04126f
C125 c0b c1 0.0924f
C126 t1_0 vdd 0.11961f
C127 g1_0 t0b 0.01944f
C128 g3_2 g3_0b 0.01092f
C129 g1_0 g30_xp1 0.21968f
C130 t2 g20_xp1 0.01377f
C131 g2 g2_0b 0.02101f
C132 t2b c3 0.01011f
C133 c0 gnd 0.00153f
C134 g1b g3b 0.00894f
C135 c0b t0b 0.41751f
C136 t2_0b c3_xn1 0.08187f
C137 a_70_148# vdd 0.00113f
C138 g1_0 g3_2 0.01906f
C139 t2_0b g2_0b 0.49971f
C140 t1_0 t3_0b 0.0211f
C141 c0 t3b 0.01787f
C142 t1b gnd 0.00582f
C143 g1b g2b 0.0182f
C144 c0b c4g_xn1 0.09002f
C145 t3_2 gnd 0.19959f
C146 c0b g3_2 0.08692f
C147 vdd g3b 0.02354f
C148 a_439_27# gnd 0
C149 c4g_xn1 c4 0.33835f
C150 c0 t2b 0.01807f
C151 c0b g32_xn1 0.15571f
C152 t3_2 t3b 0.01123f
C153 g1_0 t2 1.08743f
C154 t1_0b g1_0b 0.30772f
C155 vdd g2b 0.04047f
C156 g0b g1b 0.38194f
C157 c3_xn1 gnd 0.70201f
C158 c0 c1 0.00903f
C159 t1_0 g3_0b 0.02841f
C160 g2_0b gnd 0.16617f
C161 t3_2 t2b 0.01886f
C162 t3_0b g3b 0.16663f
C163 c0b t2 0.09675f
C164 t1_0 t1_0b 0.03519f
C165 g1_0 g1_0b 0.03416f
C166 g32_xn1 c3 0.29654f
C167 t0b c0 0.01787f
C168 vdd g1b 0.02164f
C169 c2_xn1 gnd 0.70201f
C170 c0b c1_xn1 0.16716f
C171 g2 gnd 0.10071f
C172 a_304_148# c3 0.00142f
C173 g1_0 t1_0 0.3289f
C174 c0b g1_0b 0.4769f
C175 c4g_xn1 c0 0.25672f
C176 t1b t0b 0.83274f
C177 vdd g0b 0.03912f
C178 t3_0b g1b 0.5036f
C179 t2_0b gnd 0.04508f
C180 g2_0b t2b 0.98003f
C181 g3_2 c0 0.01797f
C182 a_70_148# g1_0 0.00142f
C183 c0b t1_0 0.20187f
C184 g3_0b g3b 0.08763f
C185 t3_2 g30_xp1 0.01162f
C186 g32_xn1 c0 0.01845f
C187 g2 t2b 0.01807f
C188 a_376_148# vdd 0
C189 g3_2 t3_2 0.40038f
C190 g10_xn1 g1b 0.00534f
C191 t1_0 c3 0.00941f
C192 t3_0b vdd 0.23912f
C193 t2_0b t2b 0.02815f
C194 g1_0b c2 0.01953f
C195 t2 c0 0.02747f
C196 g1_0 g3b 0.01852f
C197 g3_0b g1b 0.019f
C198 c1_xn1 c0 0.25595f
C199 g10_xn1 g0b 0.01227f
C200 a_340_148# g3_2 0
C201 g1_0 g2b 0.02745f
C202 g20_xp1 vdd 0.35503f
C203 t1_0 c2 0.00934f
C204 c0b g3b 0.01884f
C205 g1_0b c0 0.01835f
C206 t1_0b g1b 0.01944f
C207 g3b c4 0.07882f
C208 t3b gnd 0.00137f
C209 g1_0 g1b 3.53264f
C210 c0b g2b 0.02758f
C211 a_169_148# vdd 0.00113f
C212 t1_0 c0 3.67575f
C213 g3_0b vdd 0.03188f
C214 t2b gnd 0.00404f
C215 c0b g1b 0.03631f
C216 a_34_148# c1 0
C217 t1_0 t1b 0.01154f
C218 t1_0b vdd 0.54765f
C219 g1_0 g0b 0.01786f
C220 g2_0b a_250_15# 0
C221 t1_0 t3_2 1.18118f
C222 t2 g2_0b 0.04213f
C223 g3_0b a_412_27# 0
C224 g2b c3 0.01018f
C225 t2b t3b 0.40925f
C226 g1b c4 0.01049f
C227 t3_0b g3_0b 0.65418f
C228 g1_0 vdd 0.48536f
C229 c0b g0b 0.39945f
C230 g2 t2 0.40008f
C231 g1b c3 0.0098f
C232 c0 g3b 0.00894f
C233 t0b gnd 0.00202f
C234 c0b vdd 0.2555f
C235 t1_0 c3_xn1 0.0196f
C236 g1_0b c2_xn1 0.02502f
C237 t1_0 g2_0b 0.03812f
C238 t2_0b t2 0.02524f
C239 vdd c4 0.27679f
C240 g1b c2 0.15423f
C241 c0 g2b 0.01787f
C242 c4g_xn1 gnd 0.39643f
C243 t1_0 c2_xn1 0.01921f
C244 t3_2 g3b 0.09739f
C245 g3_2 gnd 0.00105f
C246 c0b t3_0b 0.47836f
C247 t1_0 g2 0.49291f
C248 g1_0 g20_xp1 0.01377f
C249 c0 g1b 0.00926f
C250 g32_xn1 gnd 0.13223f
C251 vdd c3 0.42674f
C252 g1_0 g10_xn1 0.3477f
C253 t3_0b c4 0.00895f
C254 g3_2 t3b 0.0361f
C255 t1_0 t2_0b 0.41362f
C256 g0b c0 0.01799f
C257 t1b g1b 0.01852f
C258 a_250_15# gnd 0
C259 vdd c2 0.42634f
C260 t0b c1 0.1959f
C261 g32_xn1 t3b 0.01155f
C262 c0b g10_xn1 0.15648f
C263 g1_0 g3_0b 0.02348f
C264 t2 gnd 0.33396f
C265 t3_2 g1b 0.02842f
C266 g3_2 t2b 0.49368f
C267 g1_0 t1_0b 0.01912f
C268 a_106_148# t1_0 0.00176f
C269 c1_xn1 gnd 0.16512f
C270 t1b g0b 0.5537f
C271 vdd c0 0.02136f
C272 c3_xn1 g2b 0.25633f
C273 c0b g3_0b 0.16568f
C274 g1_0b gnd 0.08369f
C275 g2_0b g2b 0.02918f
C276 c0b t1_0b 0.47874f
C277 g3_0b c4 0.1291f
C278 vdd t1b 0.0492f
C279 t2 t2b 0.04899f
C280 t1_0 gnd 0.27166f
C281 g2_0b g1b 0.02815f
C282 g2 g2b 0.46233f
C283 t3_2 vdd 0.31536f
C284 t3_0b c0 0.01847f
C285 c0b g1_0 0.12311f
C286 g3_2 g30_xp1 0.00758f
C287 a_376_148# t3_2 0
.ends

.subckt carryx_post c0 g0b g1b g2b g3b t0b t1b t2b t3b c1 c2 c3 c4 vdd gnd
X0 c0 c1 c2 c3 c4 g0b g1b g2b g3b t0b t1b t2b t3b vdd gnd carry_b
.ends
.subckt tb_x1 a y vdd gnd
mp y a vdd vdd CMOSP W=1.8e-06 L=1.8e-07 AS=9.72e-13 PS=4.68e-06 AD=9.72e-13 PD=4.68e-06
mn y a gnd gnd CMOSN W=9.0e-07 L=1.8e-07 AS=4.86e-13 PS=2.88e-06 AD=4.86e-13 PD=2.88e-06
.ends
Vc0 src_c0 gnd PWL(
+ 0.00000e+00 1.800 2.00000e-09 1.800 2.02000e-09 0.000 4.00000e-09 0.000 4.02000e-09 1.800 8.00000e-09 1.800
+ 8.02000e-09 0.000 1.00000e-08 0.000 1.00200e-08 1.800 1.60000e-08 1.800 1.60200e-08 0.000 1.80000e-08 0.000
+ 1.80200e-08 1.800 2.20000e-08 1.800 2.20200e-08 0.000 2.40000e-08 0.000 2.40200e-08 1.800 3.20000e-08 1.800
+ 3.20200e-08 0.000 3.40000e-08 0.000 3.40200e-08 1.800 3.80000e-08 1.800 3.80200e-08 0.000 4.00000e-08 0.000
+ 4.00200e-08 1.800 4.60000e-08 1.800 4.60200e-08 0.000 4.80000e-08 0.000 4.80200e-08 1.800 5.20000e-08 1.800
+ 5.20200e-08 0.000 5.40000e-08 0.000 5.40200e-08 1.800 6.40000e-08 1.800 6.40200e-08 0.000 6.60000e-08 0.000
+ 6.60200e-08 1.800 7.00000e-08 1.800 7.00200e-08 0.000 7.20000e-08 0.000 7.20200e-08 1.800 7.80000e-08 1.800
+ 7.80200e-08 0.000 8.00000e-08 0.000 8.00200e-08 1.800 8.40000e-08 1.800 8.40200e-08 0.000 8.60000e-08 0.000
+ 8.60200e-08 1.800 9.40000e-08 1.800 9.40200e-08 0.000 9.60000e-08 0.000 9.60200e-08 1.800 1.00000e-07 1.800
+ 1.00020e-07 0.000 1.02000e-07 0.000 1.02020e-07 1.800 1.08000e-07 1.800 1.08020e-07 0.000 1.10000e-07 0.000
+ 1.10020e-07 1.800 1.14000e-07 1.800 1.14020e-07 0.000 1.16000e-07 0.000 1.16020e-07 1.800 1.28000e-07 1.800
+ 1.28020e-07 0.000 1.30000e-07 0.000 1.30020e-07 1.800 1.34000e-07 1.800 1.34020e-07 0.000 1.36000e-07 0.000
+ 1.36020e-07 1.800 1.42000e-07 1.800 1.42020e-07 0.000 1.44000e-07 0.000 1.44020e-07 1.800 1.48000e-07 1.800
+ 1.48020e-07 0.000 1.50000e-07 0.000 1.50020e-07 1.800 1.58000e-07 1.800 1.58020e-07 0.000 1.60000e-07 0.000
+ 1.60020e-07 1.800 1.64000e-07 1.800 1.64020e-07 0.000 1.66000e-07 0.000 1.66020e-07 1.800 1.72000e-07 1.800
+ 1.72020e-07 0.000 1.74000e-07 0.000 1.74020e-07 1.800 1.78000e-07 1.800 1.78020e-07 0.000 1.80000e-07 0.000
+ 1.80020e-07 1.800 1.90000e-07 1.800 1.90020e-07 0.000 1.92000e-07 0.000 1.92020e-07 1.800 1.96000e-07 1.800
+ 1.96020e-07 0.000 1.98000e-07 0.000 1.98020e-07 1.800 2.04000e-07 1.800 2.04020e-07 0.000 2.06000e-07 0.000
+ 2.06020e-07 1.800 2.10000e-07 1.800 2.10020e-07 0.000 2.12000e-07 0.000 2.12020e-07 1.800 2.20000e-07 1.800
+ 2.20020e-07 0.000 2.22000e-07 0.000 2.22020e-07 1.800 2.26000e-07 1.800 2.26020e-07 0.000 2.28000e-07 0.000
+ 2.28020e-07 1.800 2.34000e-07 1.800 2.34020e-07 0.000 2.36000e-07 0.000 2.36020e-07 1.800 2.40000e-07 1.800
+ 2.40020e-07 0.000 2.42000e-07 0.000 2.42020e-07 1.800 2.56000e-07 1.800 2.56020e-07 0.000 2.58000e-07 0.000
+ 2.58020e-07 1.800 2.62000e-07 1.800 2.62020e-07 0.000 2.64000e-07 0.000 2.64020e-07 1.800 2.70000e-07 1.800
+ 2.70020e-07 0.000 2.72000e-07 0.000 2.72020e-07 1.800 2.76000e-07 1.800 2.76020e-07 0.000 2.78000e-07 0.000
+ 2.78020e-07 1.800 2.86000e-07 1.800 2.86020e-07 0.000 2.88000e-07 0.000 2.88020e-07 1.800 2.92000e-07 1.800
+ 2.92020e-07 0.000 2.94000e-07 0.000 2.94020e-07 1.800 3.00000e-07 1.800 3.00020e-07 0.000 3.02000e-07 0.000
+ 3.02020e-07 1.800 3.06000e-07 1.800 3.06020e-07 0.000 3.08000e-07 0.000 3.08020e-07 1.800 3.18000e-07 1.800
+ 3.18020e-07 0.000 3.20000e-07 0.000 3.20020e-07 1.800 3.24000e-07 1.800 3.24020e-07 0.000 3.26000e-07 0.000
+ 3.26020e-07 1.800 3.32000e-07 1.800 3.32020e-07 0.000 3.34000e-07 0.000 3.34020e-07 1.800 3.38000e-07 1.800
+ 3.38020e-07 0.000 3.40000e-07 0.000 3.40020e-07 1.800 3.48000e-07 1.800 3.48020e-07 0.000 3.50000e-07 0.000
+ 3.50020e-07 1.800 3.54000e-07 1.800 3.54020e-07 0.000 3.56000e-07 0.000 3.56020e-07 1.800 3.62000e-07 1.800
+ 3.62020e-07 0.000 3.64000e-07 0.000 3.64020e-07 1.800 3.68000e-07 1.800 3.68020e-07 0.000 3.70000e-07 0.000
+ 3.70020e-07 1.800 3.82000e-07 1.800 3.82020e-07 0.000 3.84000e-07 0.000 3.84020e-07 1.800 3.88000e-07 1.800
+ 3.88020e-07 0.000 3.90000e-07 0.000 3.90020e-07 1.800 3.96000e-07 1.800 3.96020e-07 0.000 3.98000e-07 0.000
+ 3.98020e-07 1.800 4.02000e-07 1.800 4.02020e-07 0.000 4.04000e-07 0.000 4.04020e-07 1.800 4.12000e-07 1.800
+ 4.12020e-07 0.000 4.14000e-07 0.000 4.14020e-07 1.800 4.18000e-07 1.800 4.18020e-07 0.000 4.20000e-07 0.000
+ 4.20020e-07 1.800 4.26000e-07 1.800 4.26020e-07 0.000 4.28000e-07 0.000 4.28020e-07 1.800 4.32000e-07 1.800
+ 4.32020e-07 0.000 4.34000e-07 0.000 4.34020e-07 1.800 4.44000e-07 1.800 4.44020e-07 0.000 4.46000e-07 0.000
+ 4.46020e-07 1.800 4.50000e-07 1.800 4.50020e-07 0.000 4.52000e-07 0.000 4.52020e-07 1.800 4.58000e-07 1.800
+ 4.58020e-07 0.000 4.60000e-07 0.000 4.60020e-07 1.800 4.64000e-07 1.800 4.64020e-07 0.000 4.66000e-07 0.000
+ 4.66020e-07 1.800 4.74000e-07 1.800 4.74020e-07 0.000 4.76000e-07 0.000 4.76020e-07 1.800 4.80000e-07 1.800
+ 4.80020e-07 0.000 4.82000e-07 0.000 4.82020e-07 1.800 4.88000e-07 1.800 4.88020e-07 0.000 4.90000e-07 0.000
+ 4.90020e-07 1.800 4.94000e-07 1.800 4.94020e-07 0.000 4.96000e-07 0.000 4.96020e-07 1.800 5.12000e-07 1.800
+ 5.12020e-07 0.000 5.14000e-07 0.000 5.14020e-07 1.800 5.18000e-07 1.800 5.18020e-07 0.000 5.20000e-07 0.000
+ 5.20020e-07 1.800 5.26000e-07 1.800 5.26020e-07 0.000 5.28000e-07 0.000 5.28020e-07 1.800 5.32000e-07 1.800
+ 5.32020e-07 0.000 5.34000e-07 0.000 5.34020e-07 1.800 5.42000e-07 1.800 5.42020e-07 0.000 5.44000e-07 0.000
+ 5.44020e-07 1.800 5.48000e-07 1.800 5.48020e-07 0.000 5.50000e-07 0.000 5.50020e-07 1.800 5.56000e-07 1.800
+ 5.56020e-07 0.000 5.58000e-07 0.000 5.58020e-07 1.800 5.62000e-07 1.800 5.62020e-07 0.000 5.64000e-07 0.000
+ 5.64020e-07 1.800 5.74000e-07 1.800 5.74020e-07 0.000 5.76000e-07 0.000 5.76020e-07 1.800 5.80000e-07 1.800
+ 5.80020e-07 0.000 5.82000e-07 0.000 5.82020e-07 1.800 5.88000e-07 1.800 5.88020e-07 0.000 5.90000e-07 0.000
+ 5.90020e-07 1.800 5.94000e-07 1.800 5.94020e-07 0.000 5.96000e-07 0.000 5.96020e-07 1.800 6.04000e-07 1.800
+ 6.04020e-07 0.000 6.06000e-07 0.000 6.06020e-07 1.800 6.10000e-07 1.800 6.10020e-07 0.000 6.12000e-07 0.000
+ 6.12020e-07 1.800 6.18000e-07 1.800 6.18020e-07 0.000 6.20000e-07 0.000 6.20020e-07 1.800 6.24000e-07 1.800
+ 6.24020e-07 0.000 6.26000e-07 0.000 6.26020e-07 1.800 6.38000e-07 1.800 6.38020e-07 0.000 6.40000e-07 0.000
+ 6.40020e-07 1.800 6.44000e-07 1.800 6.44020e-07 0.000 6.46000e-07 0.000 6.46020e-07 1.800 6.52000e-07 1.800
+ 6.52020e-07 0.000 6.54000e-07 0.000 6.54020e-07 1.800 6.58000e-07 1.800 6.58020e-07 0.000 6.60000e-07 0.000
+ 6.60020e-07 1.800 6.68000e-07 1.800 6.68020e-07 0.000 6.70000e-07 0.000 6.70020e-07 1.800 6.74000e-07 1.800
+ 6.74020e-07 0.000 6.76000e-07 0.000 6.76020e-07 1.800 6.82000e-07 1.800 6.82020e-07 0.000 6.84000e-07 0.000
+ 6.84020e-07 1.800 6.88000e-07 1.800 6.88020e-07 0.000 6.90000e-07 0.000 6.90020e-07 1.800 7.00000e-07 1.800
+ 7.00020e-07 0.000 7.02000e-07 0.000 7.02020e-07 1.800 7.06000e-07 1.800 7.06020e-07 0.000 7.08000e-07 0.000
+ 7.08020e-07 1.800 7.14000e-07 1.800 7.14020e-07 0.000 7.16000e-07 0.000 7.16020e-07 1.800 7.20000e-07 1.800
+ 7.20020e-07 0.000 7.22000e-07 0.000 7.22020e-07 1.800 7.30000e-07 1.800 7.30020e-07 0.000 7.32000e-07 0.000
+ 7.32020e-07 1.800 7.36000e-07 1.800 7.36020e-07 0.000 7.38000e-07 0.000 7.38020e-07 1.800 7.44000e-07 1.800
+ 7.44020e-07 0.000 7.46000e-07 0.000 7.46020e-07 1.800 7.50000e-07 1.800 7.50020e-07 0.000 7.52000e-07 0.000
+ 7.52020e-07 1.800 7.66000e-07 1.800 7.66020e-07 0.000 7.68000e-07 0.000 7.68020e-07 1.800 7.72000e-07 1.800
+ 7.72020e-07 0.000 7.74000e-07 0.000 7.74020e-07 1.800 7.80000e-07 1.800 7.80020e-07 0.000 7.82000e-07 0.000
+ 7.82020e-07 1.800 7.86000e-07 1.800 7.86020e-07 0.000 7.88000e-07 0.000 7.88020e-07 1.800 7.96000e-07 1.800
+ 7.96020e-07 0.000 7.98000e-07 0.000 7.98020e-07 1.800 8.02000e-07 1.800 8.02020e-07 0.000 8.04000e-07 0.000
+ 8.04020e-07 1.800 8.10000e-07 1.800 8.10020e-07 0.000 8.12000e-07 0.000 8.12020e-07 1.800 8.16000e-07 1.800
+ 8.16020e-07 0.000 8.18000e-07 0.000 8.18020e-07 1.800 8.28000e-07 1.800 8.28020e-07 0.000 8.30000e-07 0.000
+ 8.30020e-07 1.800 8.34000e-07 1.800 8.34020e-07 0.000 8.36000e-07 0.000 8.36020e-07 1.800 8.42000e-07 1.800
+ 8.42020e-07 0.000 8.44000e-07 0.000 8.44020e-07 1.800 8.48000e-07 1.800 8.48020e-07 0.000 8.50000e-07 0.000
+ 8.50020e-07 1.800 8.58000e-07 1.800 8.58020e-07 0.000 8.60000e-07 0.000 8.60020e-07 1.800 8.64000e-07 1.800
+ 8.64020e-07 0.000 8.66000e-07 0.000 8.66020e-07 1.800 8.72000e-07 1.800 8.72020e-07 0.000 8.74000e-07 0.000
+ 8.74020e-07 1.800 8.78000e-07 1.800 8.78020e-07 0.000 8.80000e-07 0.000 8.80020e-07 1.800 8.92000e-07 1.800
+ 8.92020e-07 0.000 8.94000e-07 0.000 8.94020e-07 1.800 8.98000e-07 1.800 8.98020e-07 0.000 9.00000e-07 0.000
+ 9.00020e-07 1.800 9.06000e-07 1.800 9.06020e-07 0.000 9.08000e-07 0.000 9.08020e-07 1.800 9.12000e-07 1.800
+ 9.12020e-07 0.000 9.14000e-07 0.000 9.14020e-07 1.800 9.22000e-07 1.800 9.22020e-07 0.000 9.24000e-07 0.000
+ 9.24020e-07 1.800 9.28000e-07 1.800 9.28020e-07 0.000 9.30000e-07 0.000 9.30020e-07 1.800 9.36000e-07 1.800
+ 9.36020e-07 0.000 9.38000e-07 0.000 9.38020e-07 1.800 9.42000e-07 1.800 9.42020e-07 0.000 9.44000e-07 0.000
+ 9.44020e-07 1.800 9.54000e-07 1.800 9.54020e-07 0.000 9.56000e-07 0.000 9.56020e-07 1.800 9.60000e-07 1.800
+ 9.60020e-07 0.000 9.62000e-07 0.000 9.62020e-07 1.800 9.68000e-07 1.800 9.68020e-07 0.000 9.70000e-07 0.000
+ 9.70020e-07 1.800 9.74000e-07 1.800 9.74020e-07 0.000 9.76000e-07 0.000 9.76020e-07 1.800 9.84000e-07 1.800
+ 9.84020e-07 0.000 9.86000e-07 0.000 9.86020e-07 1.800 9.90000e-07 1.800 9.90020e-07 0.000 9.92000e-07 0.000
+ 9.92020e-07 1.800 9.98000e-07 1.800 9.98020e-07 0.000 1.00000e-06 0.000 1.00002e-06 1.800 1.00400e-06 1.800
+ 1.00402e-06 0.000 1.00600e-06 0.000 1.00602e-06 1.800 1.02400e-06 1.800 1.02402e-06 0.000 1.02600e-06 0.000
+ 1.02602e-06 1.800 1.03000e-06 1.800 1.03002e-06 0.000 1.03200e-06 0.000 1.03202e-06 1.800 1.03800e-06 1.800
+ 1.03802e-06 0.000 1.04000e-06 0.000 1.04002e-06 1.800 1.04400e-06 1.800 1.04402e-06 0.000 1.04600e-06 0.000
+ 1.04602e-06 1.800 1.05400e-06 1.800 1.05402e-06 0.000 1.05600e-06 0.000 1.05602e-06 1.800 1.06000e-06 1.800
+ 1.06002e-06 0.000 1.06200e-06 0.000 1.06202e-06 1.800 1.06800e-06 1.800 1.06802e-06 0.000 1.07000e-06 0.000
+ 1.07002e-06 1.800 1.07400e-06 1.800 1.07402e-06 0.000 1.07600e-06 0.000 1.07602e-06 1.800 1.08600e-06 1.800
+ 1.08602e-06 0.000 1.08800e-06 0.000 1.08802e-06 1.800 1.09200e-06 1.800 1.09202e-06 0.000 1.09400e-06 0.000
+ 1.09402e-06 1.800 1.10000e-06 1.800 1.10002e-06 0.000 1.10200e-06 0.000 1.10202e-06 1.800 1.10600e-06 1.800
+ 1.10602e-06 0.000 1.10800e-06 0.000 1.10802e-06 1.800 1.11600e-06 1.800 1.11602e-06 0.000 1.11800e-06 0.000
+ 1.11802e-06 1.800 1.12200e-06 1.800 1.12202e-06 0.000 1.12400e-06 0.000 1.12402e-06 1.800 1.13000e-06 1.800
+ 1.13002e-06 0.000 1.13200e-06 0.000 1.13202e-06 1.800 1.13600e-06 1.800 1.13602e-06 0.000 1.13800e-06 0.000
+ 1.13802e-06 1.800 1.15000e-06 1.800 1.15002e-06 0.000 1.15200e-06 0.000 1.15202e-06 1.800 1.15600e-06 1.800
+ 1.15602e-06 0.000 1.15800e-06 0.000 1.15802e-06 1.800 1.16400e-06 1.800 1.16402e-06 0.000 1.16600e-06 0.000
+ 1.16602e-06 1.800 1.17000e-06 1.800 1.17002e-06 0.000 1.17200e-06 0.000 1.17202e-06 1.800 1.18000e-06 1.800
+ 1.18002e-06 0.000 1.18200e-06 0.000 1.18202e-06 1.800 1.18600e-06 1.800 1.18602e-06 0.000 1.18800e-06 0.000
+ 1.18802e-06 1.800 1.19400e-06 1.800 1.19402e-06 0.000 1.19600e-06 0.000 1.19602e-06 1.800 1.20000e-06 1.800
+ 1.20002e-06 0.000 1.20200e-06 0.000 1.20202e-06 1.800 1.21200e-06 1.800 1.21202e-06 0.000 1.21400e-06 0.000
+ 1.21402e-06 1.800 1.21800e-06 1.800 1.21802e-06 0.000 1.22000e-06 0.000 1.22002e-06 1.800 1.22600e-06 1.800
+ 1.22602e-06 0.000 1.22800e-06 0.000 1.22802e-06 1.800 1.23200e-06 1.800 1.23202e-06 0.000 1.23400e-06 0.000
+ 1.23402e-06 1.800 1.24200e-06 1.800 1.24202e-06 0.000 1.24400e-06 0.000 1.24402e-06 1.800 1.24800e-06 1.800
+ 1.24802e-06 0.000 1.25000e-06 0.000 1.25002e-06 1.800 1.25600e-06 1.800 1.25602e-06 0.000 1.25800e-06 0.000
+ 1.25802e-06 1.800 1.26200e-06 1.800 1.26202e-06 0.000 1.26400e-06 0.000 1.26402e-06 1.800 1.27800e-06 1.800
+ 1.27802e-06 0.000 1.28000e-06 0.000 1.28002e-06 1.800 1.28400e-06 1.800 1.28402e-06 0.000 1.28600e-06 0.000
+ 1.28602e-06 1.800 1.29200e-06 1.800 1.29202e-06 0.000 1.29400e-06 0.000 1.29402e-06 1.800 1.29800e-06 1.800
+ 1.29802e-06 0.000 1.30000e-06 0.000 1.30002e-06 1.800 1.30800e-06 1.800 1.30802e-06 0.000 1.31000e-06 0.000
+ 1.31002e-06 1.800 1.31400e-06 1.800 1.31402e-06 0.000 1.31600e-06 0.000 1.31602e-06 1.800 1.32200e-06 1.800
+ 1.32202e-06 0.000 1.32400e-06 0.000 1.32402e-06 1.800 1.32800e-06 1.800 1.32802e-06 0.000 1.33000e-06 0.000
+ 1.33002e-06 1.800 1.34000e-06 1.800 1.34002e-06 0.000 1.34200e-06 0.000 1.34202e-06 1.800 1.34600e-06 1.800
+ 1.34602e-06 0.000 1.34800e-06 0.000 1.34802e-06 1.800 1.35400e-06 1.800 1.35402e-06 0.000 1.35600e-06 0.000
+ 1.35602e-06 1.800 1.36000e-06 1.800 1.36002e-06 0.000 1.36200e-06 0.000 1.36202e-06 1.800 1.37000e-06 1.800
+ 1.37002e-06 0.000 1.37200e-06 0.000 1.37202e-06 1.800 1.37600e-06 1.800 1.37602e-06 0.000 1.37800e-06 0.000
+ 1.37802e-06 1.800 1.38400e-06 1.800 1.38402e-06 0.000 1.38600e-06 0.000 1.38602e-06 1.800 1.39000e-06 1.800
+ 1.39002e-06 0.000 1.39200e-06 0.000 1.39202e-06 1.800 1.40400e-06 1.800 1.40402e-06 0.000 1.40600e-06 0.000
+ 1.40602e-06 1.800 1.41000e-06 1.800 1.41002e-06 0.000 1.41200e-06 0.000 1.41202e-06 1.800 1.41800e-06 1.800
+ 1.41802e-06 0.000 1.42000e-06 0.000 1.42002e-06 1.800 1.42400e-06 1.800 1.42402e-06 0.000 1.42600e-06 0.000
+ 1.42602e-06 1.800 1.43400e-06 1.800 1.43402e-06 0.000 1.43600e-06 0.000 1.43602e-06 1.800 1.44000e-06 1.800
+ 1.44002e-06 0.000 1.44200e-06 0.000 1.44202e-06 1.800 1.44800e-06 1.800 1.44802e-06 0.000 1.45000e-06 0.000
+ 1.45002e-06 1.800 1.45400e-06 1.800 1.45402e-06 0.000 1.45600e-06 0.000 1.45602e-06 1.800 1.46600e-06 1.800
+ 1.46602e-06 0.000 1.46800e-06 0.000 1.46802e-06 1.800 1.47200e-06 1.800 1.47202e-06 0.000 1.47400e-06 0.000
+ 1.47402e-06 1.800 1.48000e-06 1.800 1.48002e-06 0.000 1.48200e-06 0.000 1.48202e-06 1.800 1.48600e-06 1.800
+ 1.48602e-06 0.000 1.48800e-06 0.000 1.48802e-06 1.800 1.49600e-06 1.800 1.49602e-06 0.000 1.49800e-06 0.000
+ 1.49802e-06 1.800 1.50200e-06 1.800 1.50202e-06 0.000 1.50400e-06 0.000 1.50402e-06 1.800 1.51000e-06 1.800
+ 1.51002e-06 0.000 1.51200e-06 0.000 1.51202e-06 1.800 1.51600e-06 1.800 1.51602e-06 0.000 1.51800e-06 0.000
+ 1.51802e-06 1.800 1.53400e-06 1.800 1.53402e-06 0.000 1.53600e-06 0.000 1.53602e-06 1.800 1.54000e-06 1.800
+ 1.54002e-06 0.000 1.54200e-06 0.000 1.54202e-06 1.800 1.54800e-06 1.800 1.54802e-06 0.000 1.55000e-06 0.000
+ 1.55002e-06 1.800 1.55400e-06 1.800 1.55402e-06 0.000 1.55600e-06 0.000 1.55602e-06 1.800 1.56400e-06 1.800
+ 1.56402e-06 0.000 1.56600e-06 0.000 1.56602e-06 1.800 1.57000e-06 1.800 1.57002e-06 0.000 1.57200e-06 0.000
+ 1.57202e-06 1.800 1.57800e-06 1.800 1.57802e-06 0.000 1.58000e-06 0.000 1.58002e-06 1.800 1.58400e-06 1.800
+ 1.58402e-06 0.000 1.58600e-06 0.000 1.58602e-06 1.800 1.59600e-06 1.800 1.59602e-06 0.000 1.59800e-06 0.000
+ 1.59802e-06 1.800 1.60200e-06 1.800 1.60202e-06 0.000 1.60400e-06 0.000 1.60402e-06 1.800 1.61000e-06 1.800
+ 1.61002e-06 0.000 1.61200e-06 0.000 1.61202e-06 1.800 1.61600e-06 1.800 1.61602e-06 0.000 1.61800e-06 0.000
+ 1.61802e-06 1.800 1.62600e-06 1.800 1.62602e-06 0.000 1.62800e-06 0.000 1.62802e-06 1.800 1.63200e-06 1.800
+ 1.63202e-06 0.000 1.63400e-06 0.000 1.63402e-06 1.800 1.64000e-06 1.800 1.64002e-06 0.000 1.64200e-06 0.000
+ 1.64202e-06 1.800 1.64600e-06 1.800 1.64602e-06 0.000 1.64800e-06 0.000 1.64802e-06 1.800 1.66000e-06 1.800
+ 1.66002e-06 0.000 1.66200e-06 0.000 1.66202e-06 1.800 1.66600e-06 1.800 1.66602e-06 0.000 1.66800e-06 0.000
+ 1.66802e-06 1.800 1.67400e-06 1.800 1.67402e-06 0.000 1.67600e-06 0.000 1.67602e-06 1.800 1.68000e-06 1.800
+ 1.68002e-06 0.000 1.68200e-06 0.000 1.68202e-06 1.800 1.69000e-06 1.800 1.69002e-06 0.000 1.69200e-06 0.000
+ 1.69202e-06 1.800 1.69600e-06 1.800 1.69602e-06 0.000 1.69800e-06 0.000 1.69802e-06 1.800 1.70400e-06 1.800
+ 1.70402e-06 0.000 1.70600e-06 0.000 1.70602e-06 1.800 1.71000e-06 1.800 1.71002e-06 0.000 1.71200e-06 0.000
+ 1.71202e-06 1.800 1.72200e-06 1.800 1.72202e-06 0.000 1.72400e-06 0.000 1.72402e-06 1.800 1.72800e-06 1.800
+ 1.72802e-06 0.000 1.73000e-06 0.000 1.73002e-06 1.800 1.73600e-06 1.800 1.73602e-06 0.000 1.73800e-06 0.000
+ 1.73802e-06 1.800 1.74200e-06 1.800 1.74202e-06 0.000 1.74400e-06 0.000 1.74402e-06 1.800 1.75200e-06 1.800
+ 1.75202e-06 0.000 1.75400e-06 0.000 1.75402e-06 1.800 1.75800e-06 1.800 1.75802e-06 0.000 1.76000e-06 0.000
+ 1.76002e-06 1.800 1.76600e-06 1.800 1.76602e-06 0.000 1.76800e-06 0.000 1.76802e-06 1.800 1.77200e-06 1.800
+ 1.77202e-06 0.000 1.77400e-06 0.000 1.77402e-06 1.800 1.78800e-06 1.800 1.78802e-06 0.000 1.79000e-06 0.000
+ 1.79002e-06 1.800 1.79400e-06 1.800 1.79402e-06 0.000 1.79600e-06 0.000 1.79602e-06 1.800 1.80200e-06 1.800
+ 1.80202e-06 0.000 1.80400e-06 0.000 1.80402e-06 1.800 1.80800e-06 1.800 1.80802e-06 0.000 1.81000e-06 0.000
+ 1.81002e-06 1.800 1.81800e-06 1.800 1.81802e-06 0.000 1.82000e-06 0.000 1.82002e-06 1.800 1.82400e-06 1.800
+ 1.82402e-06 0.000 1.82600e-06 0.000 1.82602e-06 1.800 1.83200e-06 1.800 1.83202e-06 0.000 1.83400e-06 0.000
+ 1.83402e-06 1.800 1.83800e-06 1.800 1.83802e-06 0.000 1.84000e-06 0.000 1.84002e-06 1.800 1.85000e-06 1.800
+ 1.85002e-06 0.000 1.85200e-06 0.000 1.85202e-06 1.800 1.85600e-06 1.800 1.85602e-06 0.000 1.85800e-06 0.000
+ 1.85802e-06 1.800 1.86400e-06 1.800 1.86402e-06 0.000 1.86600e-06 0.000 1.86602e-06 1.800 1.87000e-06 1.800
+ 1.87002e-06 0.000 1.87200e-06 0.000 1.87202e-06 1.800 1.88000e-06 1.800 1.88002e-06 0.000 1.88200e-06 0.000
+ 1.88202e-06 1.800 1.88600e-06 1.800 1.88602e-06 0.000 1.88800e-06 0.000 1.88802e-06 1.800 1.89400e-06 1.800
+ 1.89402e-06 0.000 1.89600e-06 0.000 1.89602e-06 1.800 1.90000e-06 1.800 1.90002e-06 0.000 1.90200e-06 0.000
+ 1.90202e-06 1.800 1.91400e-06 1.800 1.91402e-06 0.000 1.91600e-06 0.000 1.91602e-06 1.800 1.92000e-06 1.800
+ 1.92002e-06 0.000 1.92200e-06 0.000 1.92202e-06 1.800 1.92800e-06 1.800 1.92802e-06 0.000 1.93000e-06 0.000
+ 1.93002e-06 1.800 1.93400e-06 1.800 1.93402e-06 0.000 1.93600e-06 0.000 1.93602e-06 1.800 1.94400e-06 1.800
+ 1.94402e-06 0.000 1.94600e-06 0.000 1.94602e-06 1.800 1.95000e-06 1.800 1.95002e-06 0.000 1.95200e-06 0.000
+ 1.95202e-06 1.800 1.95800e-06 1.800 1.95802e-06 0.000 1.96000e-06 0.000 1.96002e-06 1.800 1.96400e-06 1.800
+ 1.96402e-06 0.000 1.96600e-06 0.000 1.96602e-06 1.800 1.97600e-06 1.800 1.97602e-06 0.000 1.97800e-06 0.000
+ 1.97802e-06 1.800 1.98200e-06 1.800 1.98202e-06 0.000 1.98400e-06 0.000 1.98402e-06 1.800 1.99000e-06 1.800
+ 1.99002e-06 0.000 1.99200e-06 0.000 1.99202e-06 1.800 1.99600e-06 1.800 1.99602e-06 0.000 1.99800e-06 0.000
+ 1.99802e-06 1.800 2.00600e-06 1.800 2.00602e-06 0.000 2.00800e-06 0.000 2.00802e-06 1.800 2.01200e-06 1.800
+ 2.01202e-06 0.000 2.01400e-06 0.000 2.01402e-06 1.800 2.02000e-06 1.800 2.02002e-06 0.000 2.02200e-06 0.000
+ 2.02202e-06 1.800 2.02600e-06 1.800 2.02602e-06 0.000 6.12400e-06 0.000 6.12402e-06 1.800 9.21800e-06 1.800
+ )
Xd_c0 src_c0 c0 vdd gnd tb_x1
Vg0b src_g0b gnd PWL(
+ 0.00000e+00 1.800 6.00000e-09 1.800 6.02000e-09 0.000 1.20000e-08 0.000 1.20200e-08 1.800 2.00000e-08 1.800
+ 2.00200e-08 0.000 2.60000e-08 0.000 2.60200e-08 1.800 3.60000e-08 1.800 3.60200e-08 0.000 4.20000e-08 0.000
+ 4.20200e-08 1.800 5.00000e-08 1.800 5.00200e-08 0.000 5.60000e-08 0.000 5.60200e-08 1.800 6.80000e-08 1.800
+ 6.80200e-08 0.000 7.40000e-08 0.000 7.40200e-08 1.800 8.20000e-08 1.800 8.20200e-08 0.000 8.80000e-08 0.000
+ 8.80200e-08 1.800 9.80000e-08 1.800 9.80200e-08 0.000 1.04000e-07 0.000 1.04020e-07 1.800 1.12000e-07 1.800
+ 1.12020e-07 0.000 1.18000e-07 0.000 1.18020e-07 1.800 1.32000e-07 1.800 1.32020e-07 0.000 1.38000e-07 0.000
+ 1.38020e-07 1.800 1.46000e-07 1.800 1.46020e-07 0.000 1.52000e-07 0.000 1.52020e-07 1.800 1.62000e-07 1.800
+ 1.62020e-07 0.000 1.68000e-07 0.000 1.68020e-07 1.800 1.76000e-07 1.800 1.76020e-07 0.000 1.82000e-07 0.000
+ 1.82020e-07 1.800 1.94000e-07 1.800 1.94020e-07 0.000 2.00000e-07 0.000 2.00020e-07 1.800 2.08000e-07 1.800
+ 2.08020e-07 0.000 2.14000e-07 0.000 2.14020e-07 1.800 2.24000e-07 1.800 2.24020e-07 0.000 2.30000e-07 0.000
+ 2.30020e-07 1.800 2.38000e-07 1.800 2.38020e-07 0.000 2.44000e-07 0.000 2.44020e-07 1.800 2.60000e-07 1.800
+ 2.60020e-07 0.000 2.66000e-07 0.000 2.66020e-07 1.800 2.74000e-07 1.800 2.74020e-07 0.000 2.80000e-07 0.000
+ 2.80020e-07 1.800 2.90000e-07 1.800 2.90020e-07 0.000 2.96000e-07 0.000 2.96020e-07 1.800 3.04000e-07 1.800
+ 3.04020e-07 0.000 3.10000e-07 0.000 3.10020e-07 1.800 3.22000e-07 1.800 3.22020e-07 0.000 3.28000e-07 0.000
+ 3.28020e-07 1.800 3.36000e-07 1.800 3.36020e-07 0.000 3.42000e-07 0.000 3.42020e-07 1.800 3.52000e-07 1.800
+ 3.52020e-07 0.000 3.58000e-07 0.000 3.58020e-07 1.800 3.66000e-07 1.800 3.66020e-07 0.000 3.72000e-07 0.000
+ 3.72020e-07 1.800 3.86000e-07 1.800 3.86020e-07 0.000 3.92000e-07 0.000 3.92020e-07 1.800 4.00000e-07 1.800
+ 4.00020e-07 0.000 4.06000e-07 0.000 4.06020e-07 1.800 4.16000e-07 1.800 4.16020e-07 0.000 4.22000e-07 0.000
+ 4.22020e-07 1.800 4.30000e-07 1.800 4.30020e-07 0.000 4.36000e-07 0.000 4.36020e-07 1.800 4.48000e-07 1.800
+ 4.48020e-07 0.000 4.54000e-07 0.000 4.54020e-07 1.800 4.62000e-07 1.800 4.62020e-07 0.000 4.68000e-07 0.000
+ 4.68020e-07 1.800 4.78000e-07 1.800 4.78020e-07 0.000 4.84000e-07 0.000 4.84020e-07 1.800 4.92000e-07 1.800
+ 4.92020e-07 0.000 4.98000e-07 0.000 4.98020e-07 1.800 5.16000e-07 1.800 5.16020e-07 0.000 5.22000e-07 0.000
+ 5.22020e-07 1.800 5.30000e-07 1.800 5.30020e-07 0.000 5.36000e-07 0.000 5.36020e-07 1.800 5.46000e-07 1.800
+ 5.46020e-07 0.000 5.52000e-07 0.000 5.52020e-07 1.800 5.60000e-07 1.800 5.60020e-07 0.000 5.66000e-07 0.000
+ 5.66020e-07 1.800 5.78000e-07 1.800 5.78020e-07 0.000 5.84000e-07 0.000 5.84020e-07 1.800 5.92000e-07 1.800
+ 5.92020e-07 0.000 5.98000e-07 0.000 5.98020e-07 1.800 6.08000e-07 1.800 6.08020e-07 0.000 6.14000e-07 0.000
+ 6.14020e-07 1.800 6.22000e-07 1.800 6.22020e-07 0.000 6.28000e-07 0.000 6.28020e-07 1.800 6.42000e-07 1.800
+ 6.42020e-07 0.000 6.48000e-07 0.000 6.48020e-07 1.800 6.56000e-07 1.800 6.56020e-07 0.000 6.62000e-07 0.000
+ 6.62020e-07 1.800 6.72000e-07 1.800 6.72020e-07 0.000 6.78000e-07 0.000 6.78020e-07 1.800 6.86000e-07 1.800
+ 6.86020e-07 0.000 6.92000e-07 0.000 6.92020e-07 1.800 7.04000e-07 1.800 7.04020e-07 0.000 7.10000e-07 0.000
+ 7.10020e-07 1.800 7.18000e-07 1.800 7.18020e-07 0.000 7.24000e-07 0.000 7.24020e-07 1.800 7.34000e-07 1.800
+ 7.34020e-07 0.000 7.40000e-07 0.000 7.40020e-07 1.800 7.48000e-07 1.800 7.48020e-07 0.000 7.54000e-07 0.000
+ 7.54020e-07 1.800 7.70000e-07 1.800 7.70020e-07 0.000 7.76000e-07 0.000 7.76020e-07 1.800 7.84000e-07 1.800
+ 7.84020e-07 0.000 7.90000e-07 0.000 7.90020e-07 1.800 8.00000e-07 1.800 8.00020e-07 0.000 8.06000e-07 0.000
+ 8.06020e-07 1.800 8.14000e-07 1.800 8.14020e-07 0.000 8.20000e-07 0.000 8.20020e-07 1.800 8.32000e-07 1.800
+ 8.32020e-07 0.000 8.38000e-07 0.000 8.38020e-07 1.800 8.46000e-07 1.800 8.46020e-07 0.000 8.52000e-07 0.000
+ 8.52020e-07 1.800 8.62000e-07 1.800 8.62020e-07 0.000 8.68000e-07 0.000 8.68020e-07 1.800 8.76000e-07 1.800
+ 8.76020e-07 0.000 8.82000e-07 0.000 8.82020e-07 1.800 8.96000e-07 1.800 8.96020e-07 0.000 9.02000e-07 0.000
+ 9.02020e-07 1.800 9.10000e-07 1.800 9.10020e-07 0.000 9.16000e-07 0.000 9.16020e-07 1.800 9.26000e-07 1.800
+ 9.26020e-07 0.000 9.32000e-07 0.000 9.32020e-07 1.800 9.40000e-07 1.800 9.40020e-07 0.000 9.46000e-07 0.000
+ 9.46020e-07 1.800 9.58000e-07 1.800 9.58020e-07 0.000 9.64000e-07 0.000 9.64020e-07 1.800 9.72000e-07 1.800
+ 9.72020e-07 0.000 9.78000e-07 0.000 9.78020e-07 1.800 9.88000e-07 1.800 9.88020e-07 0.000 9.94000e-07 0.000
+ 9.94020e-07 1.800 1.00200e-06 1.800 1.00202e-06 0.000 1.00800e-06 0.000 1.00802e-06 1.800 1.02800e-06 1.800
+ 1.02802e-06 0.000 1.03400e-06 0.000 1.03402e-06 1.800 1.04200e-06 1.800 1.04202e-06 0.000 1.04800e-06 0.000
+ 1.04802e-06 1.800 1.05800e-06 1.800 1.05802e-06 0.000 1.06400e-06 0.000 1.06402e-06 1.800 1.07200e-06 1.800
+ 1.07202e-06 0.000 1.07800e-06 0.000 1.07802e-06 1.800 1.09000e-06 1.800 1.09002e-06 0.000 1.09600e-06 0.000
+ 1.09602e-06 1.800 1.10400e-06 1.800 1.10402e-06 0.000 1.11000e-06 0.000 1.11002e-06 1.800 1.12000e-06 1.800
+ 1.12002e-06 0.000 1.12600e-06 0.000 1.12602e-06 1.800 1.13400e-06 1.800 1.13402e-06 0.000 1.14000e-06 0.000
+ 1.14002e-06 1.800 1.15400e-06 1.800 1.15402e-06 0.000 1.16000e-06 0.000 1.16002e-06 1.800 1.16800e-06 1.800
+ 1.16802e-06 0.000 1.17400e-06 0.000 1.17402e-06 1.800 1.18400e-06 1.800 1.18402e-06 0.000 1.19000e-06 0.000
+ 1.19002e-06 1.800 1.19800e-06 1.800 1.19802e-06 0.000 1.20400e-06 0.000 1.20402e-06 1.800 1.21600e-06 1.800
+ 1.21602e-06 0.000 1.22200e-06 0.000 1.22202e-06 1.800 1.23000e-06 1.800 1.23002e-06 0.000 1.23600e-06 0.000
+ 1.23602e-06 1.800 1.24600e-06 1.800 1.24602e-06 0.000 1.25200e-06 0.000 1.25202e-06 1.800 1.26000e-06 1.800
+ 1.26002e-06 0.000 1.26600e-06 0.000 1.26602e-06 1.800 1.28200e-06 1.800 1.28202e-06 0.000 1.28800e-06 0.000
+ 1.28802e-06 1.800 1.29600e-06 1.800 1.29602e-06 0.000 1.30200e-06 0.000 1.30202e-06 1.800 1.31200e-06 1.800
+ 1.31202e-06 0.000 1.31800e-06 0.000 1.31802e-06 1.800 1.32600e-06 1.800 1.32602e-06 0.000 1.33200e-06 0.000
+ 1.33202e-06 1.800 1.34400e-06 1.800 1.34402e-06 0.000 1.35000e-06 0.000 1.35002e-06 1.800 1.35800e-06 1.800
+ 1.35802e-06 0.000 1.36400e-06 0.000 1.36402e-06 1.800 1.37400e-06 1.800 1.37402e-06 0.000 1.38000e-06 0.000
+ 1.38002e-06 1.800 1.38800e-06 1.800 1.38802e-06 0.000 1.39400e-06 0.000 1.39402e-06 1.800 1.40800e-06 1.800
+ 1.40802e-06 0.000 1.41400e-06 0.000 1.41402e-06 1.800 1.42200e-06 1.800 1.42202e-06 0.000 1.42800e-06 0.000
+ 1.42802e-06 1.800 1.43800e-06 1.800 1.43802e-06 0.000 1.44400e-06 0.000 1.44402e-06 1.800 1.45200e-06 1.800
+ 1.45202e-06 0.000 1.45800e-06 0.000 1.45802e-06 1.800 1.47000e-06 1.800 1.47002e-06 0.000 1.47600e-06 0.000
+ 1.47602e-06 1.800 1.48400e-06 1.800 1.48402e-06 0.000 1.49000e-06 0.000 1.49002e-06 1.800 1.50000e-06 1.800
+ 1.50002e-06 0.000 1.50600e-06 0.000 1.50602e-06 1.800 1.51400e-06 1.800 1.51402e-06 0.000 1.52000e-06 0.000
+ 1.52002e-06 1.800 1.53800e-06 1.800 1.53802e-06 0.000 1.54400e-06 0.000 1.54402e-06 1.800 1.55200e-06 1.800
+ 1.55202e-06 0.000 1.55800e-06 0.000 1.55802e-06 1.800 1.56800e-06 1.800 1.56802e-06 0.000 1.57400e-06 0.000
+ 1.57402e-06 1.800 1.58200e-06 1.800 1.58202e-06 0.000 1.58800e-06 0.000 1.58802e-06 1.800 1.60000e-06 1.800
+ 1.60002e-06 0.000 1.60600e-06 0.000 1.60602e-06 1.800 1.61400e-06 1.800 1.61402e-06 0.000 1.62000e-06 0.000
+ 1.62002e-06 1.800 1.63000e-06 1.800 1.63002e-06 0.000 1.63600e-06 0.000 1.63602e-06 1.800 1.64400e-06 1.800
+ 1.64402e-06 0.000 1.65000e-06 0.000 1.65002e-06 1.800 1.66400e-06 1.800 1.66402e-06 0.000 1.67000e-06 0.000
+ 1.67002e-06 1.800 1.67800e-06 1.800 1.67802e-06 0.000 1.68400e-06 0.000 1.68402e-06 1.800 1.69400e-06 1.800
+ 1.69402e-06 0.000 1.70000e-06 0.000 1.70002e-06 1.800 1.70800e-06 1.800 1.70802e-06 0.000 1.71400e-06 0.000
+ 1.71402e-06 1.800 1.72600e-06 1.800 1.72602e-06 0.000 1.73200e-06 0.000 1.73202e-06 1.800 1.74000e-06 1.800
+ 1.74002e-06 0.000 1.74600e-06 0.000 1.74602e-06 1.800 1.75600e-06 1.800 1.75602e-06 0.000 1.76200e-06 0.000
+ 1.76202e-06 1.800 1.77000e-06 1.800 1.77002e-06 0.000 1.77600e-06 0.000 1.77602e-06 1.800 1.79200e-06 1.800
+ 1.79202e-06 0.000 1.79800e-06 0.000 1.79802e-06 1.800 1.80600e-06 1.800 1.80602e-06 0.000 1.81200e-06 0.000
+ 1.81202e-06 1.800 1.82200e-06 1.800 1.82202e-06 0.000 1.82800e-06 0.000 1.82802e-06 1.800 1.83600e-06 1.800
+ 1.83602e-06 0.000 1.84200e-06 0.000 1.84202e-06 1.800 1.85400e-06 1.800 1.85402e-06 0.000 1.86000e-06 0.000
+ 1.86002e-06 1.800 1.86800e-06 1.800 1.86802e-06 0.000 1.87400e-06 0.000 1.87402e-06 1.800 1.88400e-06 1.800
+ 1.88402e-06 0.000 1.89000e-06 0.000 1.89002e-06 1.800 1.89800e-06 1.800 1.89802e-06 0.000 1.90400e-06 0.000
+ 1.90402e-06 1.800 1.91800e-06 1.800 1.91802e-06 0.000 1.92400e-06 0.000 1.92402e-06 1.800 1.93200e-06 1.800
+ 1.93202e-06 0.000 1.93800e-06 0.000 1.93802e-06 1.800 1.94800e-06 1.800 1.94802e-06 0.000 1.95400e-06 0.000
+ 1.95402e-06 1.800 1.96200e-06 1.800 1.96202e-06 0.000 1.96800e-06 0.000 1.96802e-06 1.800 1.98000e-06 1.800
+ 1.98002e-06 0.000 1.98600e-06 0.000 1.98602e-06 1.800 1.99400e-06 1.800 1.99402e-06 0.000 2.00000e-06 0.000
+ 2.00002e-06 1.800 2.01000e-06 1.800 2.01002e-06 0.000 2.01600e-06 0.000 2.01602e-06 1.800 2.02400e-06 1.800
+ 2.02402e-06 0.000 2.02800e-06 0.000 2.02802e-06 1.800 2.03000e-06 1.800 2.03002e-06 0.000 2.03400e-06 0.000
+ 2.03402e-06 1.800 2.03600e-06 1.800 2.03602e-06 0.000 2.04200e-06 0.000 2.04202e-06 1.800 2.04400e-06 1.800
+ 2.04402e-06 0.000 2.04800e-06 0.000 2.04802e-06 1.800 2.05000e-06 1.800 2.05002e-06 0.000 2.05800e-06 0.000
+ 2.05802e-06 1.800 2.06000e-06 1.800 2.06002e-06 0.000 2.06400e-06 0.000 2.06402e-06 1.800 2.06600e-06 1.800
+ 2.06602e-06 0.000 2.07200e-06 0.000 2.07202e-06 1.800 2.07400e-06 1.800 2.07402e-06 0.000 2.07800e-06 0.000
+ 2.07802e-06 1.800 2.08000e-06 1.800 2.08002e-06 0.000 2.09000e-06 0.000 2.09002e-06 1.800 2.09200e-06 1.800
+ 2.09202e-06 0.000 2.09600e-06 0.000 2.09602e-06 1.800 2.09800e-06 1.800 2.09802e-06 0.000 2.10400e-06 0.000
+ 2.10402e-06 1.800 2.10600e-06 1.800 2.10602e-06 0.000 2.11000e-06 0.000 2.11002e-06 1.800 2.11200e-06 1.800
+ 2.11202e-06 0.000 2.12000e-06 0.000 2.12002e-06 1.800 2.12200e-06 1.800 2.12202e-06 0.000 2.12600e-06 0.000
+ 2.12602e-06 1.800 2.12800e-06 1.800 2.12802e-06 0.000 2.13400e-06 0.000 2.13402e-06 1.800 2.13600e-06 1.800
+ 2.13602e-06 0.000 2.14000e-06 0.000 2.14002e-06 1.800 2.14200e-06 1.800 2.14202e-06 0.000 2.15400e-06 0.000
+ 2.15402e-06 1.800 2.15600e-06 1.800 2.15602e-06 0.000 2.16000e-06 0.000 2.16002e-06 1.800 2.16200e-06 1.800
+ 2.16202e-06 0.000 2.16800e-06 0.000 2.16802e-06 1.800 2.17000e-06 1.800 2.17002e-06 0.000 2.17400e-06 0.000
+ 2.17402e-06 1.800 2.17600e-06 1.800 2.17602e-06 0.000 2.18400e-06 0.000 2.18402e-06 1.800 2.18600e-06 1.800
+ 2.18602e-06 0.000 2.19000e-06 0.000 2.19002e-06 1.800 2.19200e-06 1.800 2.19202e-06 0.000 2.19800e-06 0.000
+ 2.19802e-06 1.800 2.20000e-06 1.800 2.20002e-06 0.000 2.20400e-06 0.000 2.20402e-06 1.800 2.20600e-06 1.800
+ 2.20602e-06 0.000 2.21600e-06 0.000 2.21602e-06 1.800 2.21800e-06 1.800 2.21802e-06 0.000 2.22200e-06 0.000
+ 2.22202e-06 1.800 2.22400e-06 1.800 2.22402e-06 0.000 2.23000e-06 0.000 2.23002e-06 1.800 2.23200e-06 1.800
+ 2.23202e-06 0.000 2.23600e-06 0.000 2.23602e-06 1.800 2.23800e-06 1.800 2.23802e-06 0.000 2.24600e-06 0.000
+ 2.24602e-06 1.800 2.24800e-06 1.800 2.24802e-06 0.000 2.25200e-06 0.000 2.25202e-06 1.800 2.25400e-06 1.800
+ 2.25402e-06 0.000 2.26000e-06 0.000 2.26002e-06 1.800 2.26200e-06 1.800 2.26202e-06 0.000 2.26600e-06 0.000
+ 2.26602e-06 1.800 2.26800e-06 1.800 2.26802e-06 0.000 2.28200e-06 0.000 2.28202e-06 1.800 2.28400e-06 1.800
+ 2.28402e-06 0.000 2.28800e-06 0.000 2.28802e-06 1.800 2.29000e-06 1.800 2.29002e-06 0.000 2.29600e-06 0.000
+ 2.29602e-06 1.800 2.29800e-06 1.800 2.29802e-06 0.000 2.30200e-06 0.000 2.30202e-06 1.800 2.30400e-06 1.800
+ 2.30402e-06 0.000 2.31200e-06 0.000 2.31202e-06 1.800 2.31400e-06 1.800 2.31402e-06 0.000 2.31800e-06 0.000
+ 2.31802e-06 1.800 2.32000e-06 1.800 2.32002e-06 0.000 2.32600e-06 0.000 2.32602e-06 1.800 2.32800e-06 1.800
+ 2.32802e-06 0.000 2.33200e-06 0.000 2.33202e-06 1.800 2.33400e-06 1.800 2.33402e-06 0.000 2.34400e-06 0.000
+ 2.34402e-06 1.800 2.34600e-06 1.800 2.34602e-06 0.000 2.35000e-06 0.000 2.35002e-06 1.800 2.35200e-06 1.800
+ 2.35202e-06 0.000 2.35800e-06 0.000 2.35802e-06 1.800 2.36000e-06 1.800 2.36002e-06 0.000 2.36400e-06 0.000
+ 2.36402e-06 1.800 2.36600e-06 1.800 2.36602e-06 0.000 2.37400e-06 0.000 2.37402e-06 1.800 2.37600e-06 1.800
+ 2.37602e-06 0.000 2.38000e-06 0.000 2.38002e-06 1.800 2.38200e-06 1.800 2.38202e-06 0.000 2.38800e-06 0.000
+ 2.38802e-06 1.800 2.39000e-06 1.800 2.39002e-06 0.000 2.39400e-06 0.000 2.39402e-06 1.800 2.39600e-06 1.800
+ 2.39602e-06 0.000 2.40800e-06 0.000 2.40802e-06 1.800 2.41000e-06 1.800 2.41002e-06 0.000 2.41400e-06 0.000
+ 2.41402e-06 1.800 2.41600e-06 1.800 2.41602e-06 0.000 2.42200e-06 0.000 2.42202e-06 1.800 2.42400e-06 1.800
+ 2.42402e-06 0.000 2.42800e-06 0.000 2.42802e-06 1.800 2.43000e-06 1.800 2.43002e-06 0.000 2.43800e-06 0.000
+ 2.43802e-06 1.800 2.44000e-06 1.800 2.44002e-06 0.000 2.44400e-06 0.000 2.44402e-06 1.800 2.44600e-06 1.800
+ 2.44602e-06 0.000 2.45200e-06 0.000 2.45202e-06 1.800 2.45400e-06 1.800 2.45402e-06 0.000 2.45800e-06 0.000
+ 2.45802e-06 1.800 2.46000e-06 1.800 2.46002e-06 0.000 2.47000e-06 0.000 2.47002e-06 1.800 2.47200e-06 1.800
+ 2.47202e-06 0.000 2.47600e-06 0.000 2.47602e-06 1.800 2.47800e-06 1.800 2.47802e-06 0.000 2.48400e-06 0.000
+ 2.48402e-06 1.800 2.48600e-06 1.800 2.48602e-06 0.000 2.49000e-06 0.000 2.49002e-06 1.800 2.49200e-06 1.800
+ 2.49202e-06 0.000 2.50000e-06 0.000 2.50002e-06 1.800 2.50200e-06 1.800 2.50202e-06 0.000 2.50600e-06 0.000
+ 2.50602e-06 1.800 2.50800e-06 1.800 2.50802e-06 0.000 2.51400e-06 0.000 2.51402e-06 1.800 2.51600e-06 1.800
+ 2.51602e-06 0.000 2.52000e-06 0.000 2.52002e-06 1.800 2.52200e-06 1.800 2.52202e-06 0.000 2.53800e-06 0.000
+ 2.53802e-06 1.800 2.54000e-06 1.800 2.54002e-06 0.000 2.54400e-06 0.000 2.54402e-06 1.800 2.54600e-06 1.800
+ 2.54602e-06 0.000 2.55200e-06 0.000 2.55202e-06 1.800 2.55400e-06 1.800 2.55402e-06 0.000 2.55800e-06 0.000
+ 2.55802e-06 1.800 2.56000e-06 1.800 2.56002e-06 0.000 2.56800e-06 0.000 2.56802e-06 1.800 2.57000e-06 1.800
+ 2.57002e-06 0.000 2.57400e-06 0.000 2.57402e-06 1.800 2.57600e-06 1.800 2.57602e-06 0.000 2.58200e-06 0.000
+ 2.58202e-06 1.800 2.58400e-06 1.800 2.58402e-06 0.000 2.58800e-06 0.000 2.58802e-06 1.800 2.59000e-06 1.800
+ 2.59002e-06 0.000 2.60000e-06 0.000 2.60002e-06 1.800 2.60200e-06 1.800 2.60202e-06 0.000 2.60600e-06 0.000
+ 2.60602e-06 1.800 2.60800e-06 1.800 2.60802e-06 0.000 2.61400e-06 0.000 2.61402e-06 1.800 2.61600e-06 1.800
+ 2.61602e-06 0.000 2.62000e-06 0.000 2.62002e-06 1.800 2.62200e-06 1.800 2.62202e-06 0.000 2.63000e-06 0.000
+ 2.63002e-06 1.800 2.63200e-06 1.800 2.63202e-06 0.000 2.63600e-06 0.000 2.63602e-06 1.800 2.63800e-06 1.800
+ 2.63802e-06 0.000 2.64400e-06 0.000 2.64402e-06 1.800 2.64600e-06 1.800 2.64602e-06 0.000 2.65000e-06 0.000
+ 2.65002e-06 1.800 2.65200e-06 1.800 2.65202e-06 0.000 2.66400e-06 0.000 2.66402e-06 1.800 2.66600e-06 1.800
+ 2.66602e-06 0.000 2.67000e-06 0.000 2.67002e-06 1.800 2.67200e-06 1.800 2.67202e-06 0.000 2.67800e-06 0.000
+ 2.67802e-06 1.800 2.68000e-06 1.800 2.68002e-06 0.000 2.68400e-06 0.000 2.68402e-06 1.800 2.68600e-06 1.800
+ 2.68602e-06 0.000 2.69400e-06 0.000 2.69402e-06 1.800 2.69600e-06 1.800 2.69602e-06 0.000 2.70000e-06 0.000
+ 2.70002e-06 1.800 2.70200e-06 1.800 2.70202e-06 0.000 2.70800e-06 0.000 2.70802e-06 1.800 2.71000e-06 1.800
+ 2.71002e-06 0.000 2.71400e-06 0.000 2.71402e-06 1.800 2.71600e-06 1.800 2.71602e-06 0.000 2.72600e-06 0.000
+ 2.72602e-06 1.800 2.72800e-06 1.800 2.72802e-06 0.000 2.73200e-06 0.000 2.73202e-06 1.800 2.73400e-06 1.800
+ 2.73402e-06 0.000 2.74000e-06 0.000 2.74002e-06 1.800 2.74200e-06 1.800 2.74202e-06 0.000 2.74600e-06 0.000
+ 2.74602e-06 1.800 2.74800e-06 1.800 2.74802e-06 0.000 2.75600e-06 0.000 2.75602e-06 1.800 2.75800e-06 1.800
+ 2.75802e-06 0.000 2.76200e-06 0.000 2.76202e-06 1.800 2.76400e-06 1.800 2.76402e-06 0.000 2.77000e-06 0.000
+ 2.77002e-06 1.800 2.77200e-06 1.800 2.77202e-06 0.000 2.77600e-06 0.000 2.77602e-06 1.800 2.77800e-06 1.800
+ 2.77802e-06 0.000 2.79200e-06 0.000 2.79202e-06 1.800 2.79400e-06 1.800 2.79402e-06 0.000 2.79800e-06 0.000
+ 2.79802e-06 1.800 2.80000e-06 1.800 2.80002e-06 0.000 2.80600e-06 0.000 2.80602e-06 1.800 2.80800e-06 1.800
+ 2.80802e-06 0.000 2.81200e-06 0.000 2.81202e-06 1.800 2.81400e-06 1.800 2.81402e-06 0.000 2.82200e-06 0.000
+ 2.82202e-06 1.800 2.82400e-06 1.800 2.82402e-06 0.000 2.82800e-06 0.000 2.82802e-06 1.800 2.83000e-06 1.800
+ 2.83002e-06 0.000 2.83600e-06 0.000 2.83602e-06 1.800 2.83800e-06 1.800 2.83802e-06 0.000 2.84200e-06 0.000
+ 2.84202e-06 1.800 2.84400e-06 1.800 2.84402e-06 0.000 2.85400e-06 0.000 2.85402e-06 1.800 2.85600e-06 1.800
+ 2.85602e-06 0.000 2.86000e-06 0.000 2.86002e-06 1.800 2.86200e-06 1.800 2.86202e-06 0.000 2.86800e-06 0.000
+ 2.86802e-06 1.800 2.87000e-06 1.800 2.87002e-06 0.000 2.87400e-06 0.000 2.87402e-06 1.800 2.87600e-06 1.800
+ 2.87602e-06 0.000 2.88400e-06 0.000 2.88402e-06 1.800 2.88600e-06 1.800 2.88602e-06 0.000 2.89000e-06 0.000
+ 2.89002e-06 1.800 2.89200e-06 1.800 2.89202e-06 0.000 2.89800e-06 0.000 2.89802e-06 1.800 2.90000e-06 1.800
+ 2.90002e-06 0.000 2.90400e-06 0.000 2.90402e-06 1.800 2.90600e-06 1.800 2.90602e-06 0.000 2.91800e-06 0.000
+ 2.91802e-06 1.800 2.92000e-06 1.800 2.92002e-06 0.000 2.92400e-06 0.000 2.92402e-06 1.800 2.92600e-06 1.800
+ 2.92602e-06 0.000 2.93200e-06 0.000 2.93202e-06 1.800 2.93400e-06 1.800 2.93402e-06 0.000 2.93800e-06 0.000
+ 2.93802e-06 1.800 2.94000e-06 1.800 2.94002e-06 0.000 2.94800e-06 0.000 2.94802e-06 1.800 2.95000e-06 1.800
+ 2.95002e-06 0.000 2.95400e-06 0.000 2.95402e-06 1.800 2.95600e-06 1.800 2.95602e-06 0.000 2.96200e-06 0.000
+ 2.96202e-06 1.800 2.96400e-06 1.800 2.96402e-06 0.000 2.96800e-06 0.000 2.96802e-06 1.800 2.97000e-06 1.800
+ 2.97002e-06 0.000 2.98000e-06 0.000 2.98002e-06 1.800 2.98200e-06 1.800 2.98202e-06 0.000 2.98600e-06 0.000
+ 2.98602e-06 1.800 2.98800e-06 1.800 2.98802e-06 0.000 2.99400e-06 0.000 2.99402e-06 1.800 2.99600e-06 1.800
+ 2.99602e-06 0.000 3.00000e-06 0.000 3.00002e-06 1.800 3.00200e-06 1.800 3.00202e-06 0.000 3.01000e-06 0.000
+ 3.01002e-06 1.800 3.01200e-06 1.800 3.01202e-06 0.000 3.01600e-06 0.000 3.01602e-06 1.800 3.01800e-06 1.800
+ 3.01802e-06 0.000 3.02400e-06 0.000 3.02402e-06 1.800 3.02600e-06 1.800 3.02602e-06 0.000 3.03000e-06 0.000
+ 3.03002e-06 1.800 4.82400e-06 1.800 4.82402e-06 0.000 7.91800e-06 0.000 7.91802e-06 1.800 9.21800e-06 1.800
+ )
Xd_g0b src_g0b g0b vdd gnd tb_x1
Vg1b src_g1b gnd PWL(
+ 0.00000e+00 1.800 1.40000e-08 1.800 1.40200e-08 0.000 2.80000e-08 0.000 2.80200e-08 1.800 4.40000e-08 1.800
+ 4.40200e-08 0.000 5.80000e-08 0.000 5.80200e-08 1.800 7.60000e-08 1.800 7.60200e-08 0.000 9.00000e-08 0.000
+ 9.00200e-08 1.800 1.06000e-07 1.800 1.06020e-07 0.000 1.20000e-07 0.000 1.20020e-07 1.800 1.40000e-07 1.800
+ 1.40020e-07 0.000 1.54000e-07 0.000 1.54020e-07 1.800 1.70000e-07 1.800 1.70020e-07 0.000 1.84000e-07 0.000
+ 1.84020e-07 1.800 2.02000e-07 1.800 2.02020e-07 0.000 2.16000e-07 0.000 2.16020e-07 1.800 2.32000e-07 1.800
+ 2.32020e-07 0.000 2.46000e-07 0.000 2.46020e-07 1.800 2.68000e-07 1.800 2.68020e-07 0.000 2.82000e-07 0.000
+ 2.82020e-07 1.800 2.98000e-07 1.800 2.98020e-07 0.000 3.12000e-07 0.000 3.12020e-07 1.800 3.30000e-07 1.800
+ 3.30020e-07 0.000 3.44000e-07 0.000 3.44020e-07 1.800 3.60000e-07 1.800 3.60020e-07 0.000 3.74000e-07 0.000
+ 3.74020e-07 1.800 3.94000e-07 1.800 3.94020e-07 0.000 4.08000e-07 0.000 4.08020e-07 1.800 4.24000e-07 1.800
+ 4.24020e-07 0.000 4.38000e-07 0.000 4.38020e-07 1.800 4.56000e-07 1.800 4.56020e-07 0.000 4.70000e-07 0.000
+ 4.70020e-07 1.800 4.86000e-07 1.800 4.86020e-07 0.000 5.00000e-07 0.000 5.00020e-07 1.800 5.24000e-07 1.800
+ 5.24020e-07 0.000 5.38000e-07 0.000 5.38020e-07 1.800 5.54000e-07 1.800 5.54020e-07 0.000 5.68000e-07 0.000
+ 5.68020e-07 1.800 5.86000e-07 1.800 5.86020e-07 0.000 6.00000e-07 0.000 6.00020e-07 1.800 6.16000e-07 1.800
+ 6.16020e-07 0.000 6.30000e-07 0.000 6.30020e-07 1.800 6.50000e-07 1.800 6.50020e-07 0.000 6.64000e-07 0.000
+ 6.64020e-07 1.800 6.80000e-07 1.800 6.80020e-07 0.000 6.94000e-07 0.000 6.94020e-07 1.800 7.12000e-07 1.800
+ 7.12020e-07 0.000 7.26000e-07 0.000 7.26020e-07 1.800 7.42000e-07 1.800 7.42020e-07 0.000 7.56000e-07 0.000
+ 7.56020e-07 1.800 7.78000e-07 1.800 7.78020e-07 0.000 7.92000e-07 0.000 7.92020e-07 1.800 8.08000e-07 1.800
+ 8.08020e-07 0.000 8.22000e-07 0.000 8.22020e-07 1.800 8.40000e-07 1.800 8.40020e-07 0.000 8.54000e-07 0.000
+ 8.54020e-07 1.800 8.70000e-07 1.800 8.70020e-07 0.000 8.84000e-07 0.000 8.84020e-07 1.800 9.04000e-07 1.800
+ 9.04020e-07 0.000 9.18000e-07 0.000 9.18020e-07 1.800 9.34000e-07 1.800 9.34020e-07 0.000 9.48000e-07 0.000
+ 9.48020e-07 1.800 9.66000e-07 1.800 9.66020e-07 0.000 9.80000e-07 0.000 9.80020e-07 1.800 9.96000e-07 1.800
+ 9.96020e-07 0.000 1.01000e-06 0.000 1.01002e-06 1.800 1.03600e-06 1.800 1.03602e-06 0.000 1.05000e-06 0.000
+ 1.05002e-06 1.800 1.06600e-06 1.800 1.06602e-06 0.000 1.08000e-06 0.000 1.08002e-06 1.800 1.09800e-06 1.800
+ 1.09802e-06 0.000 1.11200e-06 0.000 1.11202e-06 1.800 1.12800e-06 1.800 1.12802e-06 0.000 1.14200e-06 0.000
+ 1.14202e-06 1.800 1.16200e-06 1.800 1.16202e-06 0.000 1.17600e-06 0.000 1.17602e-06 1.800 1.19200e-06 1.800
+ 1.19202e-06 0.000 1.20600e-06 0.000 1.20602e-06 1.800 1.22400e-06 1.800 1.22402e-06 0.000 1.23800e-06 0.000
+ 1.23802e-06 1.800 1.25400e-06 1.800 1.25402e-06 0.000 1.26800e-06 0.000 1.26802e-06 1.800 1.29000e-06 1.800
+ 1.29002e-06 0.000 1.30400e-06 0.000 1.30402e-06 1.800 1.32000e-06 1.800 1.32002e-06 0.000 1.33400e-06 0.000
+ 1.33402e-06 1.800 1.35200e-06 1.800 1.35202e-06 0.000 1.36600e-06 0.000 1.36602e-06 1.800 1.38200e-06 1.800
+ 1.38202e-06 0.000 1.39600e-06 0.000 1.39602e-06 1.800 1.41600e-06 1.800 1.41602e-06 0.000 1.43000e-06 0.000
+ 1.43002e-06 1.800 1.44600e-06 1.800 1.44602e-06 0.000 1.46000e-06 0.000 1.46002e-06 1.800 1.47800e-06 1.800
+ 1.47802e-06 0.000 1.49200e-06 0.000 1.49202e-06 1.800 1.50800e-06 1.800 1.50802e-06 0.000 1.52200e-06 0.000
+ 1.52202e-06 1.800 1.54600e-06 1.800 1.54602e-06 0.000 1.56000e-06 0.000 1.56002e-06 1.800 1.57600e-06 1.800
+ 1.57602e-06 0.000 1.59000e-06 0.000 1.59002e-06 1.800 1.60800e-06 1.800 1.60802e-06 0.000 1.62200e-06 0.000
+ 1.62202e-06 1.800 1.63800e-06 1.800 1.63802e-06 0.000 1.65200e-06 0.000 1.65202e-06 1.800 1.67200e-06 1.800
+ 1.67202e-06 0.000 1.68600e-06 0.000 1.68602e-06 1.800 1.70200e-06 1.800 1.70202e-06 0.000 1.71600e-06 0.000
+ 1.71602e-06 1.800 1.73400e-06 1.800 1.73402e-06 0.000 1.74800e-06 0.000 1.74802e-06 1.800 1.76400e-06 1.800
+ 1.76402e-06 0.000 1.77800e-06 0.000 1.77802e-06 1.800 1.80000e-06 1.800 1.80002e-06 0.000 1.81400e-06 0.000
+ 1.81402e-06 1.800 1.83000e-06 1.800 1.83002e-06 0.000 1.84400e-06 0.000 1.84402e-06 1.800 1.86200e-06 1.800
+ 1.86202e-06 0.000 1.87600e-06 0.000 1.87602e-06 1.800 1.89200e-06 1.800 1.89202e-06 0.000 1.90600e-06 0.000
+ 1.90602e-06 1.800 1.92600e-06 1.800 1.92602e-06 0.000 1.94000e-06 0.000 1.94002e-06 1.800 1.95600e-06 1.800
+ 1.95602e-06 0.000 1.97000e-06 0.000 1.97002e-06 1.800 1.98800e-06 1.800 1.98802e-06 0.000 2.00200e-06 0.000
+ 2.00202e-06 1.800 2.01800e-06 1.800 2.01802e-06 0.000 2.03200e-06 0.000 2.03202e-06 1.800 2.03800e-06 1.800
+ 2.03802e-06 0.000 2.04600e-06 0.000 2.04602e-06 1.800 2.05200e-06 1.800 2.05202e-06 0.000 2.06200e-06 0.000
+ 2.06202e-06 1.800 2.06800e-06 1.800 2.06802e-06 0.000 2.07600e-06 0.000 2.07602e-06 1.800 2.08200e-06 1.800
+ 2.08202e-06 0.000 2.09400e-06 0.000 2.09402e-06 1.800 2.10000e-06 1.800 2.10002e-06 0.000 2.10800e-06 0.000
+ 2.10802e-06 1.800 2.11400e-06 1.800 2.11402e-06 0.000 2.12400e-06 0.000 2.12402e-06 1.800 2.13000e-06 1.800
+ 2.13002e-06 0.000 2.13800e-06 0.000 2.13802e-06 1.800 2.14400e-06 1.800 2.14402e-06 0.000 2.15800e-06 0.000
+ 2.15802e-06 1.800 2.16400e-06 1.800 2.16402e-06 0.000 2.17200e-06 0.000 2.17202e-06 1.800 2.17800e-06 1.800
+ 2.17802e-06 0.000 2.18800e-06 0.000 2.18802e-06 1.800 2.19400e-06 1.800 2.19402e-06 0.000 2.20200e-06 0.000
+ 2.20202e-06 1.800 2.20800e-06 1.800 2.20802e-06 0.000 2.22000e-06 0.000 2.22002e-06 1.800 2.22600e-06 1.800
+ 2.22602e-06 0.000 2.23400e-06 0.000 2.23402e-06 1.800 2.24000e-06 1.800 2.24002e-06 0.000 2.25000e-06 0.000
+ 2.25002e-06 1.800 2.25600e-06 1.800 2.25602e-06 0.000 2.26400e-06 0.000 2.26402e-06 1.800 2.27000e-06 1.800
+ 2.27002e-06 0.000 2.28600e-06 0.000 2.28602e-06 1.800 2.29200e-06 1.800 2.29202e-06 0.000 2.30000e-06 0.000
+ 2.30002e-06 1.800 2.30600e-06 1.800 2.30602e-06 0.000 2.31600e-06 0.000 2.31602e-06 1.800 2.32200e-06 1.800
+ 2.32202e-06 0.000 2.33000e-06 0.000 2.33002e-06 1.800 2.33600e-06 1.800 2.33602e-06 0.000 2.34800e-06 0.000
+ 2.34802e-06 1.800 2.35400e-06 1.800 2.35402e-06 0.000 2.36200e-06 0.000 2.36202e-06 1.800 2.36800e-06 1.800
+ 2.36802e-06 0.000 2.37800e-06 0.000 2.37802e-06 1.800 2.38400e-06 1.800 2.38402e-06 0.000 2.39200e-06 0.000
+ 2.39202e-06 1.800 2.39800e-06 1.800 2.39802e-06 0.000 2.41200e-06 0.000 2.41202e-06 1.800 2.41800e-06 1.800
+ 2.41802e-06 0.000 2.42600e-06 0.000 2.42602e-06 1.800 2.43200e-06 1.800 2.43202e-06 0.000 2.44200e-06 0.000
+ 2.44202e-06 1.800 2.44800e-06 1.800 2.44802e-06 0.000 2.45600e-06 0.000 2.45602e-06 1.800 2.46200e-06 1.800
+ 2.46202e-06 0.000 2.47400e-06 0.000 2.47402e-06 1.800 2.48000e-06 1.800 2.48002e-06 0.000 2.48800e-06 0.000
+ 2.48802e-06 1.800 2.49400e-06 1.800 2.49402e-06 0.000 2.50400e-06 0.000 2.50402e-06 1.800 2.51000e-06 1.800
+ 2.51002e-06 0.000 2.51800e-06 0.000 2.51802e-06 1.800 2.52400e-06 1.800 2.52402e-06 0.000 2.54200e-06 0.000
+ 2.54202e-06 1.800 2.54800e-06 1.800 2.54802e-06 0.000 2.55600e-06 0.000 2.55602e-06 1.800 2.56200e-06 1.800
+ 2.56202e-06 0.000 2.57200e-06 0.000 2.57202e-06 1.800 2.57800e-06 1.800 2.57802e-06 0.000 2.58600e-06 0.000
+ 2.58602e-06 1.800 2.59200e-06 1.800 2.59202e-06 0.000 2.60400e-06 0.000 2.60402e-06 1.800 2.61000e-06 1.800
+ 2.61002e-06 0.000 2.61800e-06 0.000 2.61802e-06 1.800 2.62400e-06 1.800 2.62402e-06 0.000 2.63400e-06 0.000
+ 2.63402e-06 1.800 2.64000e-06 1.800 2.64002e-06 0.000 2.64800e-06 0.000 2.64802e-06 1.800 2.65400e-06 1.800
+ 2.65402e-06 0.000 2.66800e-06 0.000 2.66802e-06 1.800 2.67400e-06 1.800 2.67402e-06 0.000 2.68200e-06 0.000
+ 2.68202e-06 1.800 2.68800e-06 1.800 2.68802e-06 0.000 2.69800e-06 0.000 2.69802e-06 1.800 2.70400e-06 1.800
+ 2.70402e-06 0.000 2.71200e-06 0.000 2.71202e-06 1.800 2.71800e-06 1.800 2.71802e-06 0.000 2.73000e-06 0.000
+ 2.73002e-06 1.800 2.73600e-06 1.800 2.73602e-06 0.000 2.74400e-06 0.000 2.74402e-06 1.800 2.75000e-06 1.800
+ 2.75002e-06 0.000 2.76000e-06 0.000 2.76002e-06 1.800 2.76600e-06 1.800 2.76602e-06 0.000 2.77400e-06 0.000
+ 2.77402e-06 1.800 2.78000e-06 1.800 2.78002e-06 0.000 2.79600e-06 0.000 2.79602e-06 1.800 2.80200e-06 1.800
+ 2.80202e-06 0.000 2.81000e-06 0.000 2.81002e-06 1.800 2.81600e-06 1.800 2.81602e-06 0.000 2.82600e-06 0.000
+ 2.82602e-06 1.800 2.83200e-06 1.800 2.83202e-06 0.000 2.84000e-06 0.000 2.84002e-06 1.800 2.84600e-06 1.800
+ 2.84602e-06 0.000 2.85800e-06 0.000 2.85802e-06 1.800 2.86400e-06 1.800 2.86402e-06 0.000 2.87200e-06 0.000
+ 2.87202e-06 1.800 2.87800e-06 1.800 2.87802e-06 0.000 2.88800e-06 0.000 2.88802e-06 1.800 2.89400e-06 1.800
+ 2.89402e-06 0.000 2.90200e-06 0.000 2.90202e-06 1.800 2.90800e-06 1.800 2.90802e-06 0.000 2.92200e-06 0.000
+ 2.92202e-06 1.800 2.92800e-06 1.800 2.92802e-06 0.000 2.93600e-06 0.000 2.93602e-06 1.800 2.94200e-06 1.800
+ 2.94202e-06 0.000 2.95200e-06 0.000 2.95202e-06 1.800 2.95800e-06 1.800 2.95802e-06 0.000 2.96600e-06 0.000
+ 2.96602e-06 1.800 2.97200e-06 1.800 2.97202e-06 0.000 2.98400e-06 0.000 2.98402e-06 1.800 2.99000e-06 1.800
+ 2.99002e-06 0.000 2.99800e-06 0.000 2.99802e-06 1.800 3.00400e-06 1.800 3.00402e-06 0.000 3.01400e-06 0.000
+ 3.01402e-06 1.800 3.02000e-06 1.800 3.02002e-06 0.000 3.02800e-06 0.000 3.02802e-06 1.800 3.03200e-06 1.800
+ 3.03202e-06 0.000 3.03400e-06 0.000 3.03402e-06 1.800 3.03800e-06 1.800 3.03802e-06 0.000 3.04000e-06 0.000
+ 3.04002e-06 1.800 3.04600e-06 1.800 3.04602e-06 0.000 3.04800e-06 0.000 3.04802e-06 1.800 3.05200e-06 1.800
+ 3.05202e-06 0.000 3.05400e-06 0.000 3.05402e-06 1.800 3.06200e-06 1.800 3.06202e-06 0.000 3.06400e-06 0.000
+ 3.06402e-06 1.800 3.06800e-06 1.800 3.06802e-06 0.000 3.07000e-06 0.000 3.07002e-06 1.800 3.07600e-06 1.800
+ 3.07602e-06 0.000 3.07800e-06 0.000 3.07802e-06 1.800 3.08200e-06 1.800 3.08202e-06 0.000 3.08400e-06 0.000
+ 3.08402e-06 1.800 3.09400e-06 1.800 3.09402e-06 0.000 3.09600e-06 0.000 3.09602e-06 1.800 3.10000e-06 1.800
+ 3.10002e-06 0.000 3.10200e-06 0.000 3.10202e-06 1.800 3.10800e-06 1.800 3.10802e-06 0.000 3.11000e-06 0.000
+ 3.11002e-06 1.800 3.11400e-06 1.800 3.11402e-06 0.000 3.11600e-06 0.000 3.11602e-06 1.800 3.12400e-06 1.800
+ 3.12402e-06 0.000 3.12600e-06 0.000 3.12602e-06 1.800 3.13000e-06 1.800 3.13002e-06 0.000 3.13200e-06 0.000
+ 3.13202e-06 1.800 3.13800e-06 1.800 3.13802e-06 0.000 3.14000e-06 0.000 3.14002e-06 1.800 3.14400e-06 1.800
+ 3.14402e-06 0.000 3.14600e-06 0.000 3.14602e-06 1.800 3.15800e-06 1.800 3.15802e-06 0.000 3.16000e-06 0.000
+ 3.16002e-06 1.800 3.16400e-06 1.800 3.16402e-06 0.000 3.16600e-06 0.000 3.16602e-06 1.800 3.17200e-06 1.800
+ 3.17202e-06 0.000 3.17400e-06 0.000 3.17402e-06 1.800 3.17800e-06 1.800 3.17802e-06 0.000 3.18000e-06 0.000
+ 3.18002e-06 1.800 3.18800e-06 1.800 3.18802e-06 0.000 3.19000e-06 0.000 3.19002e-06 1.800 3.19400e-06 1.800
+ 3.19402e-06 0.000 3.19600e-06 0.000 3.19602e-06 1.800 3.20200e-06 1.800 3.20202e-06 0.000 3.20400e-06 0.000
+ 3.20402e-06 1.800 3.20800e-06 1.800 3.20802e-06 0.000 3.21000e-06 0.000 3.21002e-06 1.800 3.22000e-06 1.800
+ 3.22002e-06 0.000 3.22200e-06 0.000 3.22202e-06 1.800 3.22600e-06 1.800 3.22602e-06 0.000 3.22800e-06 0.000
+ 3.22802e-06 1.800 3.23400e-06 1.800 3.23402e-06 0.000 3.23600e-06 0.000 3.23602e-06 1.800 3.24000e-06 1.800
+ 3.24002e-06 0.000 3.24200e-06 0.000 3.24202e-06 1.800 3.25000e-06 1.800 3.25002e-06 0.000 3.25200e-06 0.000
+ 3.25202e-06 1.800 3.25600e-06 1.800 3.25602e-06 0.000 3.25800e-06 0.000 3.25802e-06 1.800 3.26400e-06 1.800
+ 3.26402e-06 0.000 3.26600e-06 0.000 3.26602e-06 1.800 3.27000e-06 1.800 3.27002e-06 0.000 3.27200e-06 0.000
+ 3.27202e-06 1.800 3.28600e-06 1.800 3.28602e-06 0.000 3.28800e-06 0.000 3.28802e-06 1.800 3.29200e-06 1.800
+ 3.29202e-06 0.000 3.29400e-06 0.000 3.29402e-06 1.800 3.30000e-06 1.800 3.30002e-06 0.000 3.30200e-06 0.000
+ 3.30202e-06 1.800 3.30600e-06 1.800 3.30602e-06 0.000 3.30800e-06 0.000 3.30802e-06 1.800 3.31600e-06 1.800
+ 3.31602e-06 0.000 3.31800e-06 0.000 3.31802e-06 1.800 3.32200e-06 1.800 3.32202e-06 0.000 3.32400e-06 0.000
+ 3.32402e-06 1.800 3.33000e-06 1.800 3.33002e-06 0.000 3.33200e-06 0.000 3.33202e-06 1.800 3.33600e-06 1.800
+ 3.33602e-06 0.000 3.33800e-06 0.000 3.33802e-06 1.800 3.34800e-06 1.800 3.34802e-06 0.000 3.35000e-06 0.000
+ 3.35002e-06 1.800 3.35400e-06 1.800 3.35402e-06 0.000 3.35600e-06 0.000 3.35602e-06 1.800 3.36200e-06 1.800
+ 3.36202e-06 0.000 3.36400e-06 0.000 3.36402e-06 1.800 3.36800e-06 1.800 3.36802e-06 0.000 3.37000e-06 0.000
+ 3.37002e-06 1.800 3.37800e-06 1.800 3.37802e-06 0.000 3.38000e-06 0.000 3.38002e-06 1.800 3.38400e-06 1.800
+ 3.38402e-06 0.000 3.38600e-06 0.000 3.38602e-06 1.800 3.39200e-06 1.800 3.39202e-06 0.000 3.39400e-06 0.000
+ 3.39402e-06 1.800 3.39800e-06 1.800 3.39802e-06 0.000 3.40000e-06 0.000 3.40002e-06 1.800 3.41200e-06 1.800
+ 3.41202e-06 0.000 3.41400e-06 0.000 3.41402e-06 1.800 3.41800e-06 1.800 3.41802e-06 0.000 3.42000e-06 0.000
+ 3.42002e-06 1.800 3.42600e-06 1.800 3.42602e-06 0.000 3.42800e-06 0.000 3.42802e-06 1.800 3.43200e-06 1.800
+ 3.43202e-06 0.000 3.43400e-06 0.000 3.43402e-06 1.800 3.44200e-06 1.800 3.44202e-06 0.000 3.44400e-06 0.000
+ 3.44402e-06 1.800 3.44800e-06 1.800 3.44802e-06 0.000 3.45000e-06 0.000 3.45002e-06 1.800 3.45600e-06 1.800
+ 3.45602e-06 0.000 3.45800e-06 0.000 3.45802e-06 1.800 3.46200e-06 1.800 3.46202e-06 0.000 3.46400e-06 0.000
+ 3.46402e-06 1.800 3.47400e-06 1.800 3.47402e-06 0.000 3.47600e-06 0.000 3.47602e-06 1.800 3.48000e-06 1.800
+ 3.48002e-06 0.000 3.48200e-06 0.000 3.48202e-06 1.800 3.48800e-06 1.800 3.48802e-06 0.000 3.49000e-06 0.000
+ 3.49002e-06 1.800 3.49400e-06 1.800 3.49402e-06 0.000 3.49600e-06 0.000 3.49602e-06 1.800 3.50400e-06 1.800
+ 3.50402e-06 0.000 3.50600e-06 0.000 3.50602e-06 1.800 3.51000e-06 1.800 3.51002e-06 0.000 3.51200e-06 0.000
+ 3.51202e-06 1.800 3.51800e-06 1.800 3.51802e-06 0.000 3.52000e-06 0.000 3.52002e-06 1.800 3.52400e-06 1.800
+ 3.52402e-06 0.000 4.29400e-06 0.000 4.29402e-06 1.800 5.59400e-06 1.800 5.59402e-06 0.000 6.12600e-06 0.000
+ 6.12602e-06 1.800 6.12800e-06 1.800 6.12802e-06 0.000 6.13200e-06 0.000 6.13202e-06 1.800 6.13400e-06 1.800
+ 6.13402e-06 0.000 6.14000e-06 0.000 6.14002e-06 1.800 6.14200e-06 1.800 6.14202e-06 0.000 6.14600e-06 0.000
+ 6.14602e-06 1.800 6.14800e-06 1.800 6.14802e-06 0.000 6.15600e-06 0.000 6.15602e-06 1.800 6.15800e-06 1.800
+ 6.15802e-06 0.000 6.16200e-06 0.000 6.16202e-06 1.800 6.16400e-06 1.800 6.16402e-06 0.000 6.17000e-06 0.000
+ 6.17002e-06 1.800 6.17200e-06 1.800 6.17202e-06 0.000 6.17600e-06 0.000 6.17602e-06 1.800 6.17800e-06 1.800
+ 6.17802e-06 0.000 6.18800e-06 0.000 6.18802e-06 1.800 6.19000e-06 1.800 6.19002e-06 0.000 6.19400e-06 0.000
+ 6.19402e-06 1.800 6.19600e-06 1.800 6.19602e-06 0.000 6.20200e-06 0.000 6.20202e-06 1.800 6.20400e-06 1.800
+ 6.20402e-06 0.000 6.20800e-06 0.000 6.20802e-06 1.800 6.21000e-06 1.800 6.21002e-06 0.000 6.21800e-06 0.000
+ 6.21802e-06 1.800 6.22000e-06 1.800 6.22002e-06 0.000 6.22400e-06 0.000 6.22402e-06 1.800 6.22600e-06 1.800
+ 6.22602e-06 0.000 6.23200e-06 0.000 6.23202e-06 1.800 6.23400e-06 1.800 6.23402e-06 0.000 6.23800e-06 0.000
+ 6.23802e-06 1.800 6.24000e-06 1.800 6.24002e-06 0.000 6.25200e-06 0.000 6.25202e-06 1.800 6.25400e-06 1.800
+ 6.25402e-06 0.000 6.25800e-06 0.000 6.25802e-06 1.800 6.26000e-06 1.800 6.26002e-06 0.000 6.26600e-06 0.000
+ 6.26602e-06 1.800 6.26800e-06 1.800 6.26802e-06 0.000 6.27200e-06 0.000 6.27202e-06 1.800 6.27400e-06 1.800
+ 6.27402e-06 0.000 6.28200e-06 0.000 6.28202e-06 1.800 6.28400e-06 1.800 6.28402e-06 0.000 6.28800e-06 0.000
+ 6.28802e-06 1.800 6.29000e-06 1.800 6.29002e-06 0.000 6.29600e-06 0.000 6.29602e-06 1.800 6.29800e-06 1.800
+ 6.29802e-06 0.000 6.30200e-06 0.000 6.30202e-06 1.800 6.30400e-06 1.800 6.30402e-06 0.000 6.31400e-06 0.000
+ 6.31402e-06 1.800 6.31600e-06 1.800 6.31602e-06 0.000 6.32000e-06 0.000 6.32002e-06 1.800 6.32200e-06 1.800
+ 6.32202e-06 0.000 6.32800e-06 0.000 6.32802e-06 1.800 6.33000e-06 1.800 6.33002e-06 0.000 6.33400e-06 0.000
+ 6.33402e-06 1.800 6.33600e-06 1.800 6.33602e-06 0.000 6.34400e-06 0.000 6.34402e-06 1.800 6.34600e-06 1.800
+ 6.34602e-06 0.000 6.35000e-06 0.000 6.35002e-06 1.800 6.35200e-06 1.800 6.35202e-06 0.000 6.35800e-06 0.000
+ 6.35802e-06 1.800 6.36000e-06 1.800 6.36002e-06 0.000 6.36400e-06 0.000 6.36402e-06 1.800 6.36600e-06 1.800
+ 6.36602e-06 0.000 6.38000e-06 0.000 6.38002e-06 1.800 6.38200e-06 1.800 6.38202e-06 0.000 6.38600e-06 0.000
+ 6.38602e-06 1.800 6.38800e-06 1.800 6.38802e-06 0.000 6.39400e-06 0.000 6.39402e-06 1.800 6.39600e-06 1.800
+ 6.39602e-06 0.000 6.40000e-06 0.000 6.40002e-06 1.800 6.40200e-06 1.800 6.40202e-06 0.000 6.41000e-06 0.000
+ 6.41002e-06 1.800 6.41200e-06 1.800 6.41202e-06 0.000 6.41600e-06 0.000 6.41602e-06 1.800 6.41800e-06 1.800
+ 6.41802e-06 0.000 6.42400e-06 0.000 6.42402e-06 1.800 6.42600e-06 1.800 6.42602e-06 0.000 6.43000e-06 0.000
+ 6.43002e-06 1.800 6.43200e-06 1.800 6.43202e-06 0.000 6.44200e-06 0.000 6.44202e-06 1.800 6.44400e-06 1.800
+ 6.44402e-06 0.000 6.44800e-06 0.000 6.44802e-06 1.800 6.45000e-06 1.800 6.45002e-06 0.000 6.45600e-06 0.000
+ 6.45602e-06 1.800 6.45800e-06 1.800 6.45802e-06 0.000 6.46200e-06 0.000 6.46202e-06 1.800 6.46400e-06 1.800
+ 6.46402e-06 0.000 6.47200e-06 0.000 6.47202e-06 1.800 6.47400e-06 1.800 6.47402e-06 0.000 6.47800e-06 0.000
+ 6.47802e-06 1.800 6.48000e-06 1.800 6.48002e-06 0.000 6.48600e-06 0.000 6.48602e-06 1.800 6.48800e-06 1.800
+ 6.48802e-06 0.000 6.49200e-06 0.000 6.49202e-06 1.800 6.49400e-06 1.800 6.49402e-06 0.000 6.50600e-06 0.000
+ 6.50602e-06 1.800 6.50800e-06 1.800 6.50802e-06 0.000 6.51200e-06 0.000 6.51202e-06 1.800 6.51400e-06 1.800
+ 6.51402e-06 0.000 6.52000e-06 0.000 6.52002e-06 1.800 6.52200e-06 1.800 6.52202e-06 0.000 6.52600e-06 0.000
+ 6.52602e-06 1.800 6.52800e-06 1.800 6.52802e-06 0.000 6.53600e-06 0.000 6.53602e-06 1.800 6.53800e-06 1.800
+ 6.53802e-06 0.000 6.54200e-06 0.000 6.54202e-06 1.800 6.54400e-06 1.800 6.54402e-06 0.000 6.55000e-06 0.000
+ 6.55002e-06 1.800 6.55200e-06 1.800 6.55202e-06 0.000 6.55600e-06 0.000 6.55602e-06 1.800 6.55800e-06 1.800
+ 6.55802e-06 0.000 6.56800e-06 0.000 6.56802e-06 1.800 6.57000e-06 1.800 6.57002e-06 0.000 6.57400e-06 0.000
+ 6.57402e-06 1.800 6.57600e-06 1.800 6.57602e-06 0.000 6.58200e-06 0.000 6.58202e-06 1.800 6.58400e-06 1.800
+ 6.58402e-06 0.000 6.58800e-06 0.000 6.58802e-06 1.800 6.59000e-06 1.800 6.59002e-06 0.000 6.59800e-06 0.000
+ 6.59802e-06 1.800 6.60000e-06 1.800 6.60002e-06 0.000 6.60400e-06 0.000 6.60402e-06 1.800 6.60600e-06 1.800
+ 6.60602e-06 0.000 6.61200e-06 0.000 6.61202e-06 1.800 6.61400e-06 1.800 6.61402e-06 0.000 6.61800e-06 0.000
+ 6.61802e-06 1.800 7.38800e-06 1.800 7.38802e-06 0.000 8.68800e-06 0.000 8.68802e-06 1.800 9.21800e-06 1.800
+ )
Xd_g1b src_g1b g1b vdd gnd tb_x1
Vg2b src_g2b gnd PWL(
+ 0.00000e+00 1.800 3.00000e-08 1.800 3.00200e-08 0.000 6.00000e-08 0.000 6.00200e-08 1.800 9.20000e-08 1.800
+ 9.20200e-08 0.000 1.22000e-07 0.000 1.22020e-07 1.800 1.56000e-07 1.800 1.56020e-07 0.000 1.86000e-07 0.000
+ 1.86020e-07 1.800 2.18000e-07 1.800 2.18020e-07 0.000 2.48000e-07 0.000 2.48020e-07 1.800 2.84000e-07 1.800
+ 2.84020e-07 0.000 3.14000e-07 0.000 3.14020e-07 1.800 3.46000e-07 1.800 3.46020e-07 0.000 3.76000e-07 0.000
+ 3.76020e-07 1.800 4.10000e-07 1.800 4.10020e-07 0.000 4.40000e-07 0.000 4.40020e-07 1.800 4.72000e-07 1.800
+ 4.72020e-07 0.000 5.02000e-07 0.000 5.02020e-07 1.800 5.40000e-07 1.800 5.40020e-07 0.000 5.70000e-07 0.000
+ 5.70020e-07 1.800 6.02000e-07 1.800 6.02020e-07 0.000 6.32000e-07 0.000 6.32020e-07 1.800 6.66000e-07 1.800
+ 6.66020e-07 0.000 6.96000e-07 0.000 6.96020e-07 1.800 7.28000e-07 1.800 7.28020e-07 0.000 7.58000e-07 0.000
+ 7.58020e-07 1.800 7.94000e-07 1.800 7.94020e-07 0.000 8.24000e-07 0.000 8.24020e-07 1.800 8.56000e-07 1.800
+ 8.56020e-07 0.000 8.86000e-07 0.000 8.86020e-07 1.800 9.20000e-07 1.800 9.20020e-07 0.000 9.50000e-07 0.000
+ 9.50020e-07 1.800 9.82000e-07 1.800 9.82020e-07 0.000 1.01200e-06 0.000 1.01202e-06 1.800 1.05200e-06 1.800
+ 1.05202e-06 0.000 1.08200e-06 0.000 1.08202e-06 1.800 1.11400e-06 1.800 1.11402e-06 0.000 1.14400e-06 0.000
+ 1.14402e-06 1.800 1.17800e-06 1.800 1.17802e-06 0.000 1.20800e-06 0.000 1.20802e-06 1.800 1.24000e-06 1.800
+ 1.24002e-06 0.000 1.27000e-06 0.000 1.27002e-06 1.800 1.30600e-06 1.800 1.30602e-06 0.000 1.33600e-06 0.000
+ 1.33602e-06 1.800 1.36800e-06 1.800 1.36802e-06 0.000 1.39800e-06 0.000 1.39802e-06 1.800 1.43200e-06 1.800
+ 1.43202e-06 0.000 1.46200e-06 0.000 1.46202e-06 1.800 1.49400e-06 1.800 1.49402e-06 0.000 1.52400e-06 0.000
+ 1.52402e-06 1.800 1.56200e-06 1.800 1.56202e-06 0.000 1.59200e-06 0.000 1.59202e-06 1.800 1.62400e-06 1.800
+ 1.62402e-06 0.000 1.65400e-06 0.000 1.65402e-06 1.800 1.68800e-06 1.800 1.68802e-06 0.000 1.71800e-06 0.000
+ 1.71802e-06 1.800 1.75000e-06 1.800 1.75002e-06 0.000 1.78000e-06 0.000 1.78002e-06 1.800 1.81600e-06 1.800
+ 1.81602e-06 0.000 1.84600e-06 0.000 1.84602e-06 1.800 1.87800e-06 1.800 1.87802e-06 0.000 1.90800e-06 0.000
+ 1.90802e-06 1.800 1.94200e-06 1.800 1.94202e-06 0.000 1.97200e-06 0.000 1.97202e-06 1.800 2.00400e-06 1.800
+ 2.00402e-06 0.000 2.04000e-06 0.000 2.04002e-06 1.800 2.05400e-06 1.800 2.05402e-06 0.000 2.07000e-06 0.000
+ 2.07002e-06 1.800 2.08400e-06 1.800 2.08402e-06 0.000 2.10200e-06 0.000 2.10202e-06 1.800 2.11600e-06 1.800
+ 2.11602e-06 0.000 2.13200e-06 0.000 2.13202e-06 1.800 2.14600e-06 1.800 2.14602e-06 0.000 2.16600e-06 0.000
+ 2.16602e-06 1.800 2.18000e-06 1.800 2.18002e-06 0.000 2.19600e-06 0.000 2.19602e-06 1.800 2.21000e-06 1.800
+ 2.21002e-06 0.000 2.22800e-06 0.000 2.22802e-06 1.800 2.24200e-06 1.800 2.24202e-06 0.000 2.25800e-06 0.000
+ 2.25802e-06 1.800 2.27200e-06 1.800 2.27202e-06 0.000 2.29400e-06 0.000 2.29402e-06 1.800 2.30800e-06 1.800
+ 2.30802e-06 0.000 2.32400e-06 0.000 2.32402e-06 1.800 2.33800e-06 1.800 2.33802e-06 0.000 2.35600e-06 0.000
+ 2.35602e-06 1.800 2.37000e-06 1.800 2.37002e-06 0.000 2.38600e-06 0.000 2.38602e-06 1.800 2.40000e-06 1.800
+ 2.40002e-06 0.000 2.42000e-06 0.000 2.42002e-06 1.800 2.43400e-06 1.800 2.43402e-06 0.000 2.45000e-06 0.000
+ 2.45002e-06 1.800 2.46400e-06 1.800 2.46402e-06 0.000 2.48200e-06 0.000 2.48202e-06 1.800 2.49600e-06 1.800
+ 2.49602e-06 0.000 2.51200e-06 0.000 2.51202e-06 1.800 2.52600e-06 1.800 2.52602e-06 0.000 2.55000e-06 0.000
+ 2.55002e-06 1.800 2.56400e-06 1.800 2.56402e-06 0.000 2.58000e-06 0.000 2.58002e-06 1.800 2.59400e-06 1.800
+ 2.59402e-06 0.000 2.61200e-06 0.000 2.61202e-06 1.800 2.62600e-06 1.800 2.62602e-06 0.000 2.64200e-06 0.000
+ 2.64202e-06 1.800 2.65600e-06 1.800 2.65602e-06 0.000 2.67600e-06 0.000 2.67602e-06 1.800 2.69000e-06 1.800
+ 2.69002e-06 0.000 2.70600e-06 0.000 2.70602e-06 1.800 2.72000e-06 1.800 2.72002e-06 0.000 2.73800e-06 0.000
+ 2.73802e-06 1.800 2.75200e-06 1.800 2.75202e-06 0.000 2.76800e-06 0.000 2.76802e-06 1.800 2.78200e-06 1.800
+ 2.78202e-06 0.000 2.80400e-06 0.000 2.80402e-06 1.800 2.81800e-06 1.800 2.81802e-06 0.000 2.83400e-06 0.000
+ 2.83402e-06 1.800 2.84800e-06 1.800 2.84802e-06 0.000 2.86600e-06 0.000 2.86602e-06 1.800 2.88000e-06 1.800
+ 2.88002e-06 0.000 2.89600e-06 0.000 2.89602e-06 1.800 2.91000e-06 1.800 2.91002e-06 0.000 2.93000e-06 0.000
+ 2.93002e-06 1.800 2.94400e-06 1.800 2.94402e-06 0.000 2.96000e-06 0.000 2.96002e-06 1.800 2.97400e-06 1.800
+ 2.97402e-06 0.000 2.99200e-06 0.000 2.99202e-06 1.800 3.00600e-06 1.800 3.00602e-06 0.000 3.02200e-06 0.000
+ 3.02202e-06 1.800 3.03600e-06 1.800 3.03602e-06 0.000 3.04200e-06 0.000 3.04202e-06 1.800 3.05000e-06 1.800
+ 3.05002e-06 0.000 3.05600e-06 0.000 3.05602e-06 1.800 3.06600e-06 1.800 3.06602e-06 0.000 3.07200e-06 0.000
+ 3.07202e-06 1.800 3.08000e-06 1.800 3.08002e-06 0.000 3.08600e-06 0.000 3.08602e-06 1.800 3.09800e-06 1.800
+ 3.09802e-06 0.000 3.10400e-06 0.000 3.10402e-06 1.800 3.11200e-06 1.800 3.11202e-06 0.000 3.11800e-06 0.000
+ 3.11802e-06 1.800 3.12800e-06 1.800 3.12802e-06 0.000 3.13400e-06 0.000 3.13402e-06 1.800 3.14200e-06 1.800
+ 3.14202e-06 0.000 3.14800e-06 0.000 3.14802e-06 1.800 3.16200e-06 1.800 3.16202e-06 0.000 3.16800e-06 0.000
+ 3.16802e-06 1.800 3.17600e-06 1.800 3.17602e-06 0.000 3.18200e-06 0.000 3.18202e-06 1.800 3.19200e-06 1.800
+ 3.19202e-06 0.000 3.19800e-06 0.000 3.19802e-06 1.800 3.20600e-06 1.800 3.20602e-06 0.000 3.21200e-06 0.000
+ 3.21202e-06 1.800 3.22400e-06 1.800 3.22402e-06 0.000 3.23000e-06 0.000 3.23002e-06 1.800 3.23800e-06 1.800
+ 3.23802e-06 0.000 3.24400e-06 0.000 3.24402e-06 1.800 3.25400e-06 1.800 3.25402e-06 0.000 3.26000e-06 0.000
+ 3.26002e-06 1.800 3.26800e-06 1.800 3.26802e-06 0.000 3.27400e-06 0.000 3.27402e-06 1.800 3.29000e-06 1.800
+ 3.29002e-06 0.000 3.29600e-06 0.000 3.29602e-06 1.800 3.30400e-06 1.800 3.30402e-06 0.000 3.31000e-06 0.000
+ 3.31002e-06 1.800 3.32000e-06 1.800 3.32002e-06 0.000 3.32600e-06 0.000 3.32602e-06 1.800 3.33400e-06 1.800
+ 3.33402e-06 0.000 3.34000e-06 0.000 3.34002e-06 1.800 3.35200e-06 1.800 3.35202e-06 0.000 3.35800e-06 0.000
+ 3.35802e-06 1.800 3.36600e-06 1.800 3.36602e-06 0.000 3.37200e-06 0.000 3.37202e-06 1.800 3.38200e-06 1.800
+ 3.38202e-06 0.000 3.38800e-06 0.000 3.38802e-06 1.800 3.39600e-06 1.800 3.39602e-06 0.000 3.40200e-06 0.000
+ 3.40202e-06 1.800 3.41600e-06 1.800 3.41602e-06 0.000 3.42200e-06 0.000 3.42202e-06 1.800 3.43000e-06 1.800
+ 3.43002e-06 0.000 3.43600e-06 0.000 3.43602e-06 1.800 3.44600e-06 1.800 3.44602e-06 0.000 3.45200e-06 0.000
+ 3.45202e-06 1.800 3.46000e-06 1.800 3.46002e-06 0.000 3.46600e-06 0.000 3.46602e-06 1.800 3.47800e-06 1.800
+ 3.47802e-06 0.000 3.48400e-06 0.000 3.48402e-06 1.800 3.49200e-06 1.800 3.49202e-06 0.000 3.49800e-06 0.000
+ 3.49802e-06 1.800 3.50800e-06 1.800 3.50802e-06 0.000 3.51400e-06 0.000 3.51402e-06 1.800 3.52200e-06 1.800
+ 3.52202e-06 0.000 3.52600e-06 0.000 3.52602e-06 1.800 3.52800e-06 1.800 3.52802e-06 0.000 3.53200e-06 0.000
+ 3.53202e-06 1.800 3.53400e-06 1.800 3.53402e-06 0.000 3.54000e-06 0.000 3.54002e-06 1.800 3.54200e-06 1.800
+ 3.54202e-06 0.000 3.54600e-06 0.000 3.54602e-06 1.800 3.54800e-06 1.800 3.54802e-06 0.000 3.55600e-06 0.000
+ 3.55602e-06 1.800 3.55800e-06 1.800 3.55802e-06 0.000 3.56200e-06 0.000 3.56202e-06 1.800 3.56400e-06 1.800
+ 3.56402e-06 0.000 3.57000e-06 0.000 3.57002e-06 1.800 3.57200e-06 1.800 3.57202e-06 0.000 3.57600e-06 0.000
+ 3.57602e-06 1.800 3.57800e-06 1.800 3.57802e-06 0.000 3.58800e-06 0.000 3.58802e-06 1.800 3.59000e-06 1.800
+ 3.59002e-06 0.000 3.59400e-06 0.000 3.59402e-06 1.800 3.59600e-06 1.800 3.59602e-06 0.000 3.60200e-06 0.000
+ 3.60202e-06 1.800 3.60400e-06 1.800 3.60402e-06 0.000 3.60800e-06 0.000 3.60802e-06 1.800 3.61000e-06 1.800
+ 3.61002e-06 0.000 3.61800e-06 0.000 3.61802e-06 1.800 3.62000e-06 1.800 3.62002e-06 0.000 3.62400e-06 0.000
+ 3.62402e-06 1.800 3.62600e-06 1.800 3.62602e-06 0.000 3.63200e-06 0.000 3.63202e-06 1.800 3.63400e-06 1.800
+ 3.63402e-06 0.000 3.63800e-06 0.000 3.63802e-06 1.800 3.64000e-06 1.800 3.64002e-06 0.000 3.65200e-06 0.000
+ 3.65202e-06 1.800 3.65400e-06 1.800 3.65402e-06 0.000 3.65800e-06 0.000 3.65802e-06 1.800 3.66000e-06 1.800
+ 3.66002e-06 0.000 3.66600e-06 0.000 3.66602e-06 1.800 3.66800e-06 1.800 3.66802e-06 0.000 3.67200e-06 0.000
+ 3.67202e-06 1.800 3.67400e-06 1.800 3.67402e-06 0.000 3.68200e-06 0.000 3.68202e-06 1.800 3.68400e-06 1.800
+ 3.68402e-06 0.000 3.68800e-06 0.000 3.68802e-06 1.800 3.69000e-06 1.800 3.69002e-06 0.000 3.69600e-06 0.000
+ 3.69602e-06 1.800 3.69800e-06 1.800 3.69802e-06 0.000 3.70200e-06 0.000 3.70202e-06 1.800 3.70400e-06 1.800
+ 3.70402e-06 0.000 3.71400e-06 0.000 3.71402e-06 1.800 3.71600e-06 1.800 3.71602e-06 0.000 3.72000e-06 0.000
+ 3.72002e-06 1.800 3.72200e-06 1.800 3.72202e-06 0.000 3.72800e-06 0.000 3.72802e-06 1.800 3.73000e-06 1.800
+ 3.73002e-06 0.000 3.73400e-06 0.000 3.73402e-06 1.800 3.73600e-06 1.800 3.73602e-06 0.000 3.74400e-06 0.000
+ 3.74402e-06 1.800 3.74600e-06 1.800 3.74602e-06 0.000 3.75000e-06 0.000 3.75002e-06 1.800 3.75200e-06 1.800
+ 3.75202e-06 0.000 3.75800e-06 0.000 3.75802e-06 1.800 3.76000e-06 1.800 3.76002e-06 0.000 3.76400e-06 0.000
+ 3.76402e-06 1.800 4.08600e-06 1.800 4.08602e-06 0.000 4.61600e-06 0.000 4.61602e-06 1.800 4.82600e-06 1.800
+ 4.82602e-06 0.000 4.82800e-06 0.000 4.82802e-06 1.800 4.83200e-06 1.800 4.83202e-06 0.000 4.83400e-06 0.000
+ 4.83402e-06 1.800 4.84000e-06 1.800 4.84002e-06 0.000 4.84200e-06 0.000 4.84202e-06 1.800 4.84600e-06 1.800
+ 4.84602e-06 0.000 4.84800e-06 0.000 4.84802e-06 1.800 4.85600e-06 1.800 4.85602e-06 0.000 4.85800e-06 0.000
+ 4.85802e-06 1.800 4.86200e-06 1.800 4.86202e-06 0.000 4.86400e-06 0.000 4.86402e-06 1.800 4.87000e-06 1.800
+ 4.87002e-06 0.000 4.87200e-06 0.000 4.87202e-06 1.800 4.87600e-06 1.800 4.87602e-06 0.000 4.87800e-06 0.000
+ 4.87802e-06 1.800 4.88800e-06 1.800 4.88802e-06 0.000 4.89000e-06 0.000 4.89002e-06 1.800 4.89400e-06 1.800
+ 4.89402e-06 0.000 4.89600e-06 0.000 4.89602e-06 1.800 4.90200e-06 1.800 4.90202e-06 0.000 4.90400e-06 0.000
+ 4.90402e-06 1.800 4.90800e-06 1.800 4.90802e-06 0.000 4.91000e-06 0.000 4.91002e-06 1.800 4.91800e-06 1.800
+ 4.91802e-06 0.000 4.92000e-06 0.000 4.92002e-06 1.800 4.92400e-06 1.800 4.92402e-06 0.000 4.92600e-06 0.000
+ 4.92602e-06 1.800 4.93200e-06 1.800 4.93202e-06 0.000 4.93400e-06 0.000 4.93402e-06 1.800 4.93800e-06 1.800
+ 4.93802e-06 0.000 4.94000e-06 0.000 4.94002e-06 1.800 4.95200e-06 1.800 4.95202e-06 0.000 4.95400e-06 0.000
+ 4.95402e-06 1.800 4.95800e-06 1.800 4.95802e-06 0.000 4.96000e-06 0.000 4.96002e-06 1.800 4.96600e-06 1.800
+ 4.96602e-06 0.000 4.96800e-06 0.000 4.96802e-06 1.800 4.97200e-06 1.800 4.97202e-06 0.000 4.97400e-06 0.000
+ 4.97402e-06 1.800 4.98200e-06 1.800 4.98202e-06 0.000 4.98400e-06 0.000 4.98402e-06 1.800 4.98800e-06 1.800
+ 4.98802e-06 0.000 4.99000e-06 0.000 4.99002e-06 1.800 4.99600e-06 1.800 4.99602e-06 0.000 4.99800e-06 0.000
+ 4.99802e-06 1.800 5.00200e-06 1.800 5.00202e-06 0.000 5.00400e-06 0.000 5.00402e-06 1.800 5.01400e-06 1.800
+ 5.01402e-06 0.000 5.01600e-06 0.000 5.01602e-06 1.800 5.02000e-06 1.800 5.02002e-06 0.000 5.02200e-06 0.000
+ 5.02202e-06 1.800 5.02800e-06 1.800 5.02802e-06 0.000 5.03000e-06 0.000 5.03002e-06 1.800 5.03400e-06 1.800
+ 5.03402e-06 0.000 5.03600e-06 0.000 5.03602e-06 1.800 5.04400e-06 1.800 5.04402e-06 0.000 5.04600e-06 0.000
+ 5.04602e-06 1.800 5.05000e-06 1.800 5.05002e-06 0.000 5.05200e-06 0.000 5.05202e-06 1.800 5.05800e-06 1.800
+ 5.05802e-06 0.000 5.06000e-06 0.000 5.06002e-06 1.800 5.06400e-06 1.800 5.06402e-06 0.000 5.38600e-06 0.000
+ 5.38602e-06 1.800 5.91600e-06 1.800 5.91602e-06 0.000 6.13000e-06 0.000 6.13002e-06 1.800 6.13600e-06 1.800
+ 6.13602e-06 0.000 6.14400e-06 0.000 6.14402e-06 1.800 6.15000e-06 1.800 6.15002e-06 0.000 6.16000e-06 0.000
+ 6.16002e-06 1.800 6.16600e-06 1.800 6.16602e-06 0.000 6.17400e-06 0.000 6.17402e-06 1.800 6.18000e-06 1.800
+ 6.18002e-06 0.000 6.19200e-06 0.000 6.19202e-06 1.800 6.19800e-06 1.800 6.19802e-06 0.000 6.20600e-06 0.000
+ 6.20602e-06 1.800 6.21200e-06 1.800 6.21202e-06 0.000 6.22200e-06 0.000 6.22202e-06 1.800 6.22800e-06 1.800
+ 6.22802e-06 0.000 6.23600e-06 0.000 6.23602e-06 1.800 6.24200e-06 1.800 6.24202e-06 0.000 6.25600e-06 0.000
+ 6.25602e-06 1.800 6.26200e-06 1.800 6.26202e-06 0.000 6.27000e-06 0.000 6.27002e-06 1.800 6.27600e-06 1.800
+ 6.27602e-06 0.000 6.28600e-06 0.000 6.28602e-06 1.800 6.29200e-06 1.800 6.29202e-06 0.000 6.30000e-06 0.000
+ 6.30002e-06 1.800 6.30600e-06 1.800 6.30602e-06 0.000 6.31800e-06 0.000 6.31802e-06 1.800 6.32400e-06 1.800
+ 6.32402e-06 0.000 6.33200e-06 0.000 6.33202e-06 1.800 6.33800e-06 1.800 6.33802e-06 0.000 6.34800e-06 0.000
+ 6.34802e-06 1.800 6.35400e-06 1.800 6.35402e-06 0.000 6.36200e-06 0.000 6.36202e-06 1.800 6.36800e-06 1.800
+ 6.36802e-06 0.000 6.38400e-06 0.000 6.38402e-06 1.800 6.39000e-06 1.800 6.39002e-06 0.000 6.39800e-06 0.000
+ 6.39802e-06 1.800 6.40400e-06 1.800 6.40402e-06 0.000 6.41400e-06 0.000 6.41402e-06 1.800 6.42000e-06 1.800
+ 6.42002e-06 0.000 6.42800e-06 0.000 6.42802e-06 1.800 6.43400e-06 1.800 6.43402e-06 0.000 6.44600e-06 0.000
+ 6.44602e-06 1.800 6.45200e-06 1.800 6.45202e-06 0.000 6.46000e-06 0.000 6.46002e-06 1.800 6.46600e-06 1.800
+ 6.46602e-06 0.000 6.47600e-06 0.000 6.47602e-06 1.800 6.48200e-06 1.800 6.48202e-06 0.000 6.49000e-06 0.000
+ 6.49002e-06 1.800 6.49600e-06 1.800 6.49602e-06 0.000 6.51000e-06 0.000 6.51002e-06 1.800 6.51600e-06 1.800
+ 6.51602e-06 0.000 6.52400e-06 0.000 6.52402e-06 1.800 6.53000e-06 1.800 6.53002e-06 0.000 6.54000e-06 0.000
+ 6.54002e-06 1.800 6.54600e-06 1.800 6.54602e-06 0.000 6.55400e-06 0.000 6.55402e-06 1.800 6.56000e-06 1.800
+ 6.56002e-06 0.000 6.57200e-06 0.000 6.57202e-06 1.800 6.57800e-06 1.800 6.57802e-06 0.000 6.58600e-06 0.000
+ 6.58602e-06 1.800 6.59200e-06 1.800 6.59202e-06 0.000 6.60200e-06 0.000 6.60202e-06 1.800 6.60800e-06 1.800
+ 6.60802e-06 0.000 6.61600e-06 0.000 6.61602e-06 1.800 6.62000e-06 1.800 6.62002e-06 0.000 6.62200e-06 0.000
+ 6.62202e-06 1.800 6.62600e-06 1.800 6.62602e-06 0.000 6.62800e-06 0.000 6.62802e-06 1.800 6.63400e-06 1.800
+ 6.63402e-06 0.000 6.63600e-06 0.000 6.63602e-06 1.800 6.64000e-06 1.800 6.64002e-06 0.000 6.64200e-06 0.000
+ 6.64202e-06 1.800 6.65000e-06 1.800 6.65002e-06 0.000 6.65200e-06 0.000 6.65202e-06 1.800 6.65600e-06 1.800
+ 6.65602e-06 0.000 6.65800e-06 0.000 6.65802e-06 1.800 6.66400e-06 1.800 6.66402e-06 0.000 6.66600e-06 0.000
+ 6.66602e-06 1.800 6.67000e-06 1.800 6.67002e-06 0.000 6.67200e-06 0.000 6.67202e-06 1.800 6.68200e-06 1.800
+ 6.68202e-06 0.000 6.68400e-06 0.000 6.68402e-06 1.800 6.68800e-06 1.800 6.68802e-06 0.000 6.69000e-06 0.000
+ 6.69002e-06 1.800 6.69600e-06 1.800 6.69602e-06 0.000 6.69800e-06 0.000 6.69802e-06 1.800 6.70200e-06 1.800
+ 6.70202e-06 0.000 6.70400e-06 0.000 6.70402e-06 1.800 6.71200e-06 1.800 6.71202e-06 0.000 6.71400e-06 0.000
+ 6.71402e-06 1.800 6.71800e-06 1.800 6.71802e-06 0.000 6.72000e-06 0.000 6.72002e-06 1.800 6.72600e-06 1.800
+ 6.72602e-06 0.000 6.72800e-06 0.000 6.72802e-06 1.800 6.73200e-06 1.800 6.73202e-06 0.000 6.73400e-06 0.000
+ 6.73402e-06 1.800 6.74600e-06 1.800 6.74602e-06 0.000 6.74800e-06 0.000 6.74802e-06 1.800 6.75200e-06 1.800
+ 6.75202e-06 0.000 6.75400e-06 0.000 6.75402e-06 1.800 6.76000e-06 1.800 6.76002e-06 0.000 6.76200e-06 0.000
+ 6.76202e-06 1.800 6.76600e-06 1.800 6.76602e-06 0.000 6.76800e-06 0.000 6.76802e-06 1.800 6.77600e-06 1.800
+ 6.77602e-06 0.000 6.77800e-06 0.000 6.77802e-06 1.800 6.78200e-06 1.800 6.78202e-06 0.000 6.78400e-06 0.000
+ 6.78402e-06 1.800 6.79000e-06 1.800 6.79002e-06 0.000 6.79200e-06 0.000 6.79202e-06 1.800 6.79600e-06 1.800
+ 6.79602e-06 0.000 6.79800e-06 0.000 6.79802e-06 1.800 6.80800e-06 1.800 6.80802e-06 0.000 6.81000e-06 0.000
+ 6.81002e-06 1.800 6.81400e-06 1.800 6.81402e-06 0.000 6.81600e-06 0.000 6.81602e-06 1.800 6.82200e-06 1.800
+ 6.82202e-06 0.000 6.82400e-06 0.000 6.82402e-06 1.800 6.82800e-06 1.800 6.82802e-06 0.000 6.83000e-06 0.000
+ 6.83002e-06 1.800 6.83800e-06 1.800 6.83802e-06 0.000 6.84000e-06 0.000 6.84002e-06 1.800 6.84400e-06 1.800
+ 6.84402e-06 0.000 6.84600e-06 0.000 6.84602e-06 1.800 6.85200e-06 1.800 6.85202e-06 0.000 6.85400e-06 0.000
+ 6.85402e-06 1.800 6.85800e-06 1.800 6.85802e-06 0.000 7.18000e-06 0.000 7.18002e-06 1.800 7.71000e-06 1.800
+ 7.71002e-06 0.000 7.92000e-06 0.000 7.92002e-06 1.800 7.92200e-06 1.800 7.92202e-06 0.000 7.92600e-06 0.000
+ 7.92602e-06 1.800 7.92800e-06 1.800 7.92802e-06 0.000 7.93400e-06 0.000 7.93402e-06 1.800 7.93600e-06 1.800
+ 7.93602e-06 0.000 7.94000e-06 0.000 7.94002e-06 1.800 7.94200e-06 1.800 7.94202e-06 0.000 7.95000e-06 0.000
+ 7.95002e-06 1.800 7.95200e-06 1.800 7.95202e-06 0.000 7.95600e-06 0.000 7.95602e-06 1.800 7.95800e-06 1.800
+ 7.95802e-06 0.000 7.96400e-06 0.000 7.96402e-06 1.800 7.96600e-06 1.800 7.96602e-06 0.000 7.97000e-06 0.000
+ 7.97002e-06 1.800 7.97200e-06 1.800 7.97202e-06 0.000 7.98200e-06 0.000 7.98202e-06 1.800 7.98400e-06 1.800
+ 7.98402e-06 0.000 7.98800e-06 0.000 7.98802e-06 1.800 7.99000e-06 1.800 7.99002e-06 0.000 7.99600e-06 0.000
+ 7.99602e-06 1.800 7.99800e-06 1.800 7.99802e-06 0.000 8.00200e-06 0.000 8.00202e-06 1.800 8.00400e-06 1.800
+ 8.00402e-06 0.000 8.01200e-06 0.000 8.01202e-06 1.800 8.01400e-06 1.800 8.01402e-06 0.000 8.01800e-06 0.000
+ 8.01802e-06 1.800 8.02000e-06 1.800 8.02002e-06 0.000 8.02600e-06 0.000 8.02602e-06 1.800 8.02800e-06 1.800
+ 8.02802e-06 0.000 8.03200e-06 0.000 8.03202e-06 1.800 8.03400e-06 1.800 8.03402e-06 0.000 8.04600e-06 0.000
+ 8.04602e-06 1.800 8.04800e-06 1.800 8.04802e-06 0.000 8.05200e-06 0.000 8.05202e-06 1.800 8.05400e-06 1.800
+ 8.05402e-06 0.000 8.06000e-06 0.000 8.06002e-06 1.800 8.06200e-06 1.800 8.06202e-06 0.000 8.06600e-06 0.000
+ 8.06602e-06 1.800 8.06800e-06 1.800 8.06802e-06 0.000 8.07600e-06 0.000 8.07602e-06 1.800 8.07800e-06 1.800
+ 8.07802e-06 0.000 8.08200e-06 0.000 8.08202e-06 1.800 8.08400e-06 1.800 8.08402e-06 0.000 8.09000e-06 0.000
+ 8.09002e-06 1.800 8.09200e-06 1.800 8.09202e-06 0.000 8.09600e-06 0.000 8.09602e-06 1.800 8.09800e-06 1.800
+ 8.09802e-06 0.000 8.10800e-06 0.000 8.10802e-06 1.800 8.11000e-06 1.800 8.11002e-06 0.000 8.11400e-06 0.000
+ 8.11402e-06 1.800 8.11600e-06 1.800 8.11602e-06 0.000 8.12200e-06 0.000 8.12202e-06 1.800 8.12400e-06 1.800
+ 8.12402e-06 0.000 8.12800e-06 0.000 8.12802e-06 1.800 8.13000e-06 1.800 8.13002e-06 0.000 8.13800e-06 0.000
+ 8.13802e-06 1.800 8.14000e-06 1.800 8.14002e-06 0.000 8.14400e-06 0.000 8.14402e-06 1.800 8.14600e-06 1.800
+ 8.14602e-06 0.000 8.15200e-06 0.000 8.15202e-06 1.800 8.15400e-06 1.800 8.15402e-06 0.000 8.15800e-06 0.000
+ 8.15802e-06 1.800 8.48000e-06 1.800 8.48002e-06 0.000 9.01000e-06 0.000 9.01002e-06 1.800 9.21800e-06 1.800
+ )
Xd_g2b src_g2b g2b vdd gnd tb_x1
Vg3b src_g3b gnd PWL(
+ 0.00000e+00 1.800 6.20000e-08 1.800 6.20200e-08 0.000 1.24000e-07 0.000 1.24020e-07 1.800 1.88000e-07 1.800
+ 1.88020e-07 0.000 2.50000e-07 0.000 2.50020e-07 1.800 3.16000e-07 1.800 3.16020e-07 0.000 3.78000e-07 0.000
+ 3.78020e-07 1.800 4.42000e-07 1.800 4.42020e-07 0.000 5.04000e-07 0.000 5.04020e-07 1.800 5.72000e-07 1.800
+ 5.72020e-07 0.000 6.34000e-07 0.000 6.34020e-07 1.800 6.98000e-07 1.800 6.98020e-07 0.000 7.60000e-07 0.000
+ 7.60020e-07 1.800 8.26000e-07 1.800 8.26020e-07 0.000 8.88000e-07 0.000 8.88020e-07 1.800 9.52000e-07 1.800
+ 9.52020e-07 0.000 1.01400e-06 0.000 1.01402e-06 1.800 1.08400e-06 1.800 1.08402e-06 0.000 1.14600e-06 0.000
+ 1.14602e-06 1.800 1.21000e-06 1.800 1.21002e-06 0.000 1.27200e-06 0.000 1.27202e-06 1.800 1.33800e-06 1.800
+ 1.33802e-06 0.000 1.40000e-06 0.000 1.40002e-06 1.800 1.46400e-06 1.800 1.46402e-06 0.000 1.52600e-06 0.000
+ 1.52602e-06 1.800 1.59400e-06 1.800 1.59402e-06 0.000 1.65600e-06 0.000 1.65602e-06 1.800 1.72000e-06 1.800
+ 1.72002e-06 0.000 1.78200e-06 0.000 1.78202e-06 1.800 1.84800e-06 1.800 1.84802e-06 0.000 1.91000e-06 0.000
+ 1.91002e-06 1.800 1.97400e-06 1.800 1.97402e-06 0.000 2.05600e-06 0.000 2.05602e-06 1.800 2.08600e-06 1.800
+ 2.08602e-06 0.000 2.11800e-06 0.000 2.11802e-06 1.800 2.14800e-06 1.800 2.14802e-06 0.000 2.18200e-06 0.000
+ 2.18202e-06 1.800 2.21200e-06 1.800 2.21202e-06 0.000 2.24400e-06 0.000 2.24402e-06 1.800 2.27400e-06 1.800
+ 2.27402e-06 0.000 2.31000e-06 0.000 2.31002e-06 1.800 2.34000e-06 1.800 2.34002e-06 0.000 2.37200e-06 0.000
+ 2.37202e-06 1.800 2.40200e-06 1.800 2.40202e-06 0.000 2.43600e-06 0.000 2.43602e-06 1.800 2.46600e-06 1.800
+ 2.46602e-06 0.000 2.49800e-06 0.000 2.49802e-06 1.800 2.52800e-06 1.800 2.52802e-06 0.000 2.56600e-06 0.000
+ 2.56602e-06 1.800 2.59600e-06 1.800 2.59602e-06 0.000 2.62800e-06 0.000 2.62802e-06 1.800 2.65800e-06 1.800
+ 2.65802e-06 0.000 2.69200e-06 0.000 2.69202e-06 1.800 2.72200e-06 1.800 2.72202e-06 0.000 2.75400e-06 0.000
+ 2.75402e-06 1.800 2.78400e-06 1.800 2.78402e-06 0.000 2.82000e-06 0.000 2.82002e-06 1.800 2.85000e-06 1.800
+ 2.85002e-06 0.000 2.88200e-06 0.000 2.88202e-06 1.800 2.91200e-06 1.800 2.91202e-06 0.000 2.94600e-06 0.000
+ 2.94602e-06 1.800 2.97600e-06 1.800 2.97602e-06 0.000 3.00800e-06 0.000 3.00802e-06 1.800 3.04400e-06 1.800
+ 3.04402e-06 0.000 3.05800e-06 0.000 3.05802e-06 1.800 3.07400e-06 1.800 3.07402e-06 0.000 3.08800e-06 0.000
+ 3.08802e-06 1.800 3.10600e-06 1.800 3.10602e-06 0.000 3.12000e-06 0.000 3.12002e-06 1.800 3.13600e-06 1.800
+ 3.13602e-06 0.000 3.15000e-06 0.000 3.15002e-06 1.800 3.17000e-06 1.800 3.17002e-06 0.000 3.18400e-06 0.000
+ 3.18402e-06 1.800 3.20000e-06 1.800 3.20002e-06 0.000 3.21400e-06 0.000 3.21402e-06 1.800 3.23200e-06 1.800
+ 3.23202e-06 0.000 3.24600e-06 0.000 3.24602e-06 1.800 3.26200e-06 1.800 3.26202e-06 0.000 3.27600e-06 0.000
+ 3.27602e-06 1.800 3.29800e-06 1.800 3.29802e-06 0.000 3.31200e-06 0.000 3.31202e-06 1.800 3.32800e-06 1.800
+ 3.32802e-06 0.000 3.34200e-06 0.000 3.34202e-06 1.800 3.36000e-06 1.800 3.36002e-06 0.000 3.37400e-06 0.000
+ 3.37402e-06 1.800 3.39000e-06 1.800 3.39002e-06 0.000 3.40400e-06 0.000 3.40402e-06 1.800 3.42400e-06 1.800
+ 3.42402e-06 0.000 3.43800e-06 0.000 3.43802e-06 1.800 3.45400e-06 1.800 3.45402e-06 0.000 3.46800e-06 0.000
+ 3.46802e-06 1.800 3.48600e-06 1.800 3.48602e-06 0.000 3.50000e-06 0.000 3.50002e-06 1.800 3.51600e-06 1.800
+ 3.51602e-06 0.000 3.53000e-06 0.000 3.53002e-06 1.800 3.53600e-06 1.800 3.53602e-06 0.000 3.54400e-06 0.000
+ 3.54402e-06 1.800 3.55000e-06 1.800 3.55002e-06 0.000 3.56000e-06 0.000 3.56002e-06 1.800 3.56600e-06 1.800
+ 3.56602e-06 0.000 3.57400e-06 0.000 3.57402e-06 1.800 3.58000e-06 1.800 3.58002e-06 0.000 3.59200e-06 0.000
+ 3.59202e-06 1.800 3.59800e-06 1.800 3.59802e-06 0.000 3.60600e-06 0.000 3.60602e-06 1.800 3.61200e-06 1.800
+ 3.61202e-06 0.000 3.62200e-06 0.000 3.62202e-06 1.800 3.62800e-06 1.800 3.62802e-06 0.000 3.63600e-06 0.000
+ 3.63602e-06 1.800 3.64200e-06 1.800 3.64202e-06 0.000 3.65600e-06 0.000 3.65602e-06 1.800 3.66200e-06 1.800
+ 3.66202e-06 0.000 3.67000e-06 0.000 3.67002e-06 1.800 3.67600e-06 1.800 3.67602e-06 0.000 3.68600e-06 0.000
+ 3.68602e-06 1.800 3.69200e-06 1.800 3.69202e-06 0.000 3.70000e-06 0.000 3.70002e-06 1.800 3.70600e-06 1.800
+ 3.70602e-06 0.000 3.71800e-06 0.000 3.71802e-06 1.800 3.72400e-06 1.800 3.72402e-06 0.000 3.73200e-06 0.000
+ 3.73202e-06 1.800 3.73800e-06 1.800 3.73802e-06 0.000 3.74800e-06 0.000 3.74802e-06 1.800 3.75400e-06 1.800
+ 3.75402e-06 0.000 3.76200e-06 0.000 3.76202e-06 1.800 3.76600e-06 1.800 3.76602e-06 0.000 3.76800e-06 0.000
+ 3.76802e-06 1.800 3.77200e-06 1.800 3.77202e-06 0.000 3.77400e-06 0.000 3.77402e-06 1.800 3.78000e-06 1.800
+ 3.78002e-06 0.000 3.78200e-06 0.000 3.78202e-06 1.800 3.78600e-06 1.800 3.78602e-06 0.000 3.78800e-06 0.000
+ 3.78802e-06 1.800 3.79600e-06 1.800 3.79602e-06 0.000 3.79800e-06 0.000 3.79802e-06 1.800 3.80200e-06 1.800
+ 3.80202e-06 0.000 3.80400e-06 0.000 3.80402e-06 1.800 3.81000e-06 1.800 3.81002e-06 0.000 3.81200e-06 0.000
+ 3.81202e-06 1.800 3.81600e-06 1.800 3.81602e-06 0.000 3.81800e-06 0.000 3.81802e-06 1.800 3.82800e-06 1.800
+ 3.82802e-06 0.000 3.83000e-06 0.000 3.83002e-06 1.800 3.83400e-06 1.800 3.83402e-06 0.000 3.83600e-06 0.000
+ 3.83602e-06 1.800 3.84200e-06 1.800 3.84202e-06 0.000 3.84400e-06 0.000 3.84402e-06 1.800 3.84800e-06 1.800
+ 3.84802e-06 0.000 3.85000e-06 0.000 3.85002e-06 1.800 3.85800e-06 1.800 3.85802e-06 0.000 3.86000e-06 0.000
+ 3.86002e-06 1.800 3.86400e-06 1.800 3.86402e-06 0.000 3.86600e-06 0.000 3.86602e-06 1.800 3.87200e-06 1.800
+ 3.87202e-06 0.000 3.87400e-06 0.000 3.87402e-06 1.800 3.87800e-06 1.800 3.87802e-06 0.000 4.00800e-06 0.000
+ 4.00802e-06 1.800 4.21600e-06 1.800 4.21602e-06 0.000 4.29600e-06 0.000 4.29602e-06 1.800 4.29800e-06 1.800
+ 4.29802e-06 0.000 4.30200e-06 0.000 4.30202e-06 1.800 4.30400e-06 1.800 4.30402e-06 0.000 4.31000e-06 0.000
+ 4.31002e-06 1.800 4.31200e-06 1.800 4.31202e-06 0.000 4.31600e-06 0.000 4.31602e-06 1.800 4.31800e-06 1.800
+ 4.31802e-06 0.000 4.32600e-06 0.000 4.32602e-06 1.800 4.32800e-06 1.800 4.32802e-06 0.000 4.33200e-06 0.000
+ 4.33202e-06 1.800 4.33400e-06 1.800 4.33402e-06 0.000 4.34000e-06 0.000 4.34002e-06 1.800 4.34200e-06 1.800
+ 4.34202e-06 0.000 4.34600e-06 0.000 4.34602e-06 1.800 4.34800e-06 1.800 4.34802e-06 0.000 4.35800e-06 0.000
+ 4.35802e-06 1.800 4.36000e-06 1.800 4.36002e-06 0.000 4.36400e-06 0.000 4.36402e-06 1.800 4.36600e-06 1.800
+ 4.36602e-06 0.000 4.37200e-06 0.000 4.37202e-06 1.800 4.37400e-06 1.800 4.37402e-06 0.000 4.37800e-06 0.000
+ 4.37802e-06 1.800 4.38000e-06 1.800 4.38002e-06 0.000 4.38800e-06 0.000 4.38802e-06 1.800 4.39000e-06 1.800
+ 4.39002e-06 0.000 4.39400e-06 0.000 4.39402e-06 1.800 4.39600e-06 1.800 4.39602e-06 0.000 4.40200e-06 0.000
+ 4.40202e-06 1.800 4.40400e-06 1.800 4.40402e-06 0.000 4.40800e-06 0.000 4.40802e-06 1.800 4.53800e-06 1.800
+ 4.53802e-06 0.000 4.74600e-06 0.000 4.74602e-06 1.800 4.83000e-06 1.800 4.83002e-06 0.000 4.83600e-06 0.000
+ 4.83602e-06 1.800 4.84400e-06 1.800 4.84402e-06 0.000 4.85000e-06 0.000 4.85002e-06 1.800 4.86000e-06 1.800
+ 4.86002e-06 0.000 4.86600e-06 0.000 4.86602e-06 1.800 4.87400e-06 1.800 4.87402e-06 0.000 4.88000e-06 0.000
+ 4.88002e-06 1.800 4.89200e-06 1.800 4.89202e-06 0.000 4.89800e-06 0.000 4.89802e-06 1.800 4.90600e-06 1.800
+ 4.90602e-06 0.000 4.91200e-06 0.000 4.91202e-06 1.800 4.92200e-06 1.800 4.92202e-06 0.000 4.92800e-06 0.000
+ 4.92802e-06 1.800 4.93600e-06 1.800 4.93602e-06 0.000 4.94200e-06 0.000 4.94202e-06 1.800 4.95600e-06 1.800
+ 4.95602e-06 0.000 4.96200e-06 0.000 4.96202e-06 1.800 4.97000e-06 1.800 4.97002e-06 0.000 4.97600e-06 0.000
+ 4.97602e-06 1.800 4.98600e-06 1.800 4.98602e-06 0.000 4.99200e-06 0.000 4.99202e-06 1.800 5.00000e-06 1.800
+ 5.00002e-06 0.000 5.00600e-06 0.000 5.00602e-06 1.800 5.01800e-06 1.800 5.01802e-06 0.000 5.02400e-06 0.000
+ 5.02402e-06 1.800 5.03200e-06 1.800 5.03202e-06 0.000 5.03800e-06 0.000 5.03802e-06 1.800 5.04800e-06 1.800
+ 5.04802e-06 0.000 5.05400e-06 0.000 5.05402e-06 1.800 5.06200e-06 1.800 5.06202e-06 0.000 5.06600e-06 0.000
+ 5.06602e-06 1.800 5.06800e-06 1.800 5.06802e-06 0.000 5.07200e-06 0.000 5.07202e-06 1.800 5.07400e-06 1.800
+ 5.07402e-06 0.000 5.08000e-06 0.000 5.08002e-06 1.800 5.08200e-06 1.800 5.08202e-06 0.000 5.08600e-06 0.000
+ 5.08602e-06 1.800 5.08800e-06 1.800 5.08802e-06 0.000 5.09600e-06 0.000 5.09602e-06 1.800 5.09800e-06 1.800
+ 5.09802e-06 0.000 5.10200e-06 0.000 5.10202e-06 1.800 5.10400e-06 1.800 5.10402e-06 0.000 5.11000e-06 0.000
+ 5.11002e-06 1.800 5.11200e-06 1.800 5.11202e-06 0.000 5.11600e-06 0.000 5.11602e-06 1.800 5.11800e-06 1.800
+ 5.11802e-06 0.000 5.12800e-06 0.000 5.12802e-06 1.800 5.13000e-06 1.800 5.13002e-06 0.000 5.13400e-06 0.000
+ 5.13402e-06 1.800 5.13600e-06 1.800 5.13602e-06 0.000 5.14200e-06 0.000 5.14202e-06 1.800 5.14400e-06 1.800
+ 5.14402e-06 0.000 5.14800e-06 0.000 5.14802e-06 1.800 5.15000e-06 1.800 5.15002e-06 0.000 5.15800e-06 0.000
+ 5.15802e-06 1.800 5.16000e-06 1.800 5.16002e-06 0.000 5.16400e-06 0.000 5.16402e-06 1.800 5.16600e-06 1.800
+ 5.16602e-06 0.000 5.17200e-06 0.000 5.17202e-06 1.800 5.17400e-06 1.800 5.17402e-06 0.000 5.17800e-06 0.000
+ 5.17802e-06 1.800 5.30800e-06 1.800 5.30802e-06 0.000 5.51600e-06 0.000 5.51602e-06 1.800 5.59600e-06 1.800
+ 5.59602e-06 0.000 5.59800e-06 0.000 5.59802e-06 1.800 5.60200e-06 1.800 5.60202e-06 0.000 5.60400e-06 0.000
+ 5.60402e-06 1.800 5.61000e-06 1.800 5.61002e-06 0.000 5.61200e-06 0.000 5.61202e-06 1.800 5.61600e-06 1.800
+ 5.61602e-06 0.000 5.61800e-06 0.000 5.61802e-06 1.800 5.62600e-06 1.800 5.62602e-06 0.000 5.62800e-06 0.000
+ 5.62802e-06 1.800 5.63200e-06 1.800 5.63202e-06 0.000 5.63400e-06 0.000 5.63402e-06 1.800 5.64000e-06 1.800
+ 5.64002e-06 0.000 5.64200e-06 0.000 5.64202e-06 1.800 5.64600e-06 1.800 5.64602e-06 0.000 5.64800e-06 0.000
+ 5.64802e-06 1.800 5.65800e-06 1.800 5.65802e-06 0.000 5.66000e-06 0.000 5.66002e-06 1.800 5.66400e-06 1.800
+ 5.66402e-06 0.000 5.66600e-06 0.000 5.66602e-06 1.800 5.67200e-06 1.800 5.67202e-06 0.000 5.67400e-06 0.000
+ 5.67402e-06 1.800 5.67800e-06 1.800 5.67802e-06 0.000 5.68000e-06 0.000 5.68002e-06 1.800 5.68800e-06 1.800
+ 5.68802e-06 0.000 5.69000e-06 0.000 5.69002e-06 1.800 5.69400e-06 1.800 5.69402e-06 0.000 5.69600e-06 0.000
+ 5.69602e-06 1.800 5.70200e-06 1.800 5.70202e-06 0.000 5.70400e-06 0.000 5.70402e-06 1.800 5.70800e-06 1.800
+ 5.70802e-06 0.000 5.83800e-06 0.000 5.83802e-06 1.800 6.04600e-06 1.800 6.04602e-06 0.000 6.13800e-06 0.000
+ 6.13802e-06 1.800 6.15200e-06 1.800 6.15202e-06 0.000 6.16800e-06 0.000 6.16802e-06 1.800 6.18200e-06 1.800
+ 6.18202e-06 0.000 6.20000e-06 0.000 6.20002e-06 1.800 6.21400e-06 1.800 6.21402e-06 0.000 6.23000e-06 0.000
+ 6.23002e-06 1.800 6.24400e-06 1.800 6.24402e-06 0.000 6.26400e-06 0.000 6.26402e-06 1.800 6.27800e-06 1.800
+ 6.27802e-06 0.000 6.29400e-06 0.000 6.29402e-06 1.800 6.30800e-06 1.800 6.30802e-06 0.000 6.32600e-06 0.000
+ 6.32602e-06 1.800 6.34000e-06 1.800 6.34002e-06 0.000 6.35600e-06 0.000 6.35602e-06 1.800 6.37000e-06 1.800
+ 6.37002e-06 0.000 6.39200e-06 0.000 6.39202e-06 1.800 6.40600e-06 1.800 6.40602e-06 0.000 6.42200e-06 0.000
+ 6.42202e-06 1.800 6.43600e-06 1.800 6.43602e-06 0.000 6.45400e-06 0.000 6.45402e-06 1.800 6.46800e-06 1.800
+ 6.46802e-06 0.000 6.48400e-06 0.000 6.48402e-06 1.800 6.49800e-06 1.800 6.49802e-06 0.000 6.51800e-06 0.000
+ 6.51802e-06 1.800 6.53200e-06 1.800 6.53202e-06 0.000 6.54800e-06 0.000 6.54802e-06 1.800 6.56200e-06 1.800
+ 6.56202e-06 0.000 6.58000e-06 0.000 6.58002e-06 1.800 6.59400e-06 1.800 6.59402e-06 0.000 6.61000e-06 0.000
+ 6.61002e-06 1.800 6.62400e-06 1.800 6.62402e-06 0.000 6.63000e-06 0.000 6.63002e-06 1.800 6.63800e-06 1.800
+ 6.63802e-06 0.000 6.64400e-06 0.000 6.64402e-06 1.800 6.65400e-06 1.800 6.65402e-06 0.000 6.66000e-06 0.000
+ 6.66002e-06 1.800 6.66800e-06 1.800 6.66802e-06 0.000 6.67400e-06 0.000 6.67402e-06 1.800 6.68600e-06 1.800
+ 6.68602e-06 0.000 6.69200e-06 0.000 6.69202e-06 1.800 6.70000e-06 1.800 6.70002e-06 0.000 6.70600e-06 0.000
+ 6.70602e-06 1.800 6.71600e-06 1.800 6.71602e-06 0.000 6.72200e-06 0.000 6.72202e-06 1.800 6.73000e-06 1.800
+ 6.73002e-06 0.000 6.73600e-06 0.000 6.73602e-06 1.800 6.75000e-06 1.800 6.75002e-06 0.000 6.75600e-06 0.000
+ 6.75602e-06 1.800 6.76400e-06 1.800 6.76402e-06 0.000 6.77000e-06 0.000 6.77002e-06 1.800 6.78000e-06 1.800
+ 6.78002e-06 0.000 6.78600e-06 0.000 6.78602e-06 1.800 6.79400e-06 1.800 6.79402e-06 0.000 6.80000e-06 0.000
+ 6.80002e-06 1.800 6.81200e-06 1.800 6.81202e-06 0.000 6.81800e-06 0.000 6.81802e-06 1.800 6.82600e-06 1.800
+ 6.82602e-06 0.000 6.83200e-06 0.000 6.83202e-06 1.800 6.84200e-06 1.800 6.84202e-06 0.000 6.84800e-06 0.000
+ 6.84802e-06 1.800 6.85600e-06 1.800 6.85602e-06 0.000 6.86000e-06 0.000 6.86002e-06 1.800 6.86200e-06 1.800
+ 6.86202e-06 0.000 6.86600e-06 0.000 6.86602e-06 1.800 6.86800e-06 1.800 6.86802e-06 0.000 6.87400e-06 0.000
+ 6.87402e-06 1.800 6.87600e-06 1.800 6.87602e-06 0.000 6.88000e-06 0.000 6.88002e-06 1.800 6.88200e-06 1.800
+ 6.88202e-06 0.000 6.89000e-06 0.000 6.89002e-06 1.800 6.89200e-06 1.800 6.89202e-06 0.000 6.89600e-06 0.000
+ 6.89602e-06 1.800 6.89800e-06 1.800 6.89802e-06 0.000 6.90400e-06 0.000 6.90402e-06 1.800 6.90600e-06 1.800
+ 6.90602e-06 0.000 6.91000e-06 0.000 6.91002e-06 1.800 6.91200e-06 1.800 6.91202e-06 0.000 6.92200e-06 0.000
+ 6.92202e-06 1.800 6.92400e-06 1.800 6.92402e-06 0.000 6.92800e-06 0.000 6.92802e-06 1.800 6.93000e-06 1.800
+ 6.93002e-06 0.000 6.93600e-06 0.000 6.93602e-06 1.800 6.93800e-06 1.800 6.93802e-06 0.000 6.94200e-06 0.000
+ 6.94202e-06 1.800 6.94400e-06 1.800 6.94402e-06 0.000 6.95200e-06 0.000 6.95202e-06 1.800 6.95400e-06 1.800
+ 6.95402e-06 0.000 6.95800e-06 0.000 6.95802e-06 1.800 6.96000e-06 1.800 6.96002e-06 0.000 6.96600e-06 0.000
+ 6.96602e-06 1.800 6.96800e-06 1.800 6.96802e-06 0.000 6.97200e-06 0.000 6.97202e-06 1.800 7.10200e-06 1.800
+ 7.10202e-06 0.000 7.31000e-06 0.000 7.31002e-06 1.800 7.39000e-06 1.800 7.39002e-06 0.000 7.39200e-06 0.000
+ 7.39202e-06 1.800 7.39600e-06 1.800 7.39602e-06 0.000 7.39800e-06 0.000 7.39802e-06 1.800 7.40400e-06 1.800
+ 7.40402e-06 0.000 7.40600e-06 0.000 7.40602e-06 1.800 7.41000e-06 1.800 7.41002e-06 0.000 7.41200e-06 0.000
+ 7.41202e-06 1.800 7.42000e-06 1.800 7.42002e-06 0.000 7.42200e-06 0.000 7.42202e-06 1.800 7.42600e-06 1.800
+ 7.42602e-06 0.000 7.42800e-06 0.000 7.42802e-06 1.800 7.43400e-06 1.800 7.43402e-06 0.000 7.43600e-06 0.000
+ 7.43602e-06 1.800 7.44000e-06 1.800 7.44002e-06 0.000 7.44200e-06 0.000 7.44202e-06 1.800 7.45200e-06 1.800
+ 7.45202e-06 0.000 7.45400e-06 0.000 7.45402e-06 1.800 7.45800e-06 1.800 7.45802e-06 0.000 7.46000e-06 0.000
+ 7.46002e-06 1.800 7.46600e-06 1.800 7.46602e-06 0.000 7.46800e-06 0.000 7.46802e-06 1.800 7.47200e-06 1.800
+ 7.47202e-06 0.000 7.47400e-06 0.000 7.47402e-06 1.800 7.48200e-06 1.800 7.48202e-06 0.000 7.48400e-06 0.000
+ 7.48402e-06 1.800 7.48800e-06 1.800 7.48802e-06 0.000 7.49000e-06 0.000 7.49002e-06 1.800 7.49600e-06 1.800
+ 7.49602e-06 0.000 7.49800e-06 0.000 7.49802e-06 1.800 7.50200e-06 1.800 7.50202e-06 0.000 7.63200e-06 0.000
+ 7.63202e-06 1.800 7.84000e-06 1.800 7.84002e-06 0.000 7.92400e-06 0.000 7.92402e-06 1.800 7.93000e-06 1.800
+ 7.93002e-06 0.000 7.93800e-06 0.000 7.93802e-06 1.800 7.94400e-06 1.800 7.94402e-06 0.000 7.95400e-06 0.000
+ 7.95402e-06 1.800 7.96000e-06 1.800 7.96002e-06 0.000 7.96800e-06 0.000 7.96802e-06 1.800 7.97400e-06 1.800
+ 7.97402e-06 0.000 7.98600e-06 0.000 7.98602e-06 1.800 7.99200e-06 1.800 7.99202e-06 0.000 8.00000e-06 0.000
+ 8.00002e-06 1.800 8.00600e-06 1.800 8.00602e-06 0.000 8.01600e-06 0.000 8.01602e-06 1.800 8.02200e-06 1.800
+ 8.02202e-06 0.000 8.03000e-06 0.000 8.03002e-06 1.800 8.03600e-06 1.800 8.03602e-06 0.000 8.05000e-06 0.000
+ 8.05002e-06 1.800 8.05600e-06 1.800 8.05602e-06 0.000 8.06400e-06 0.000 8.06402e-06 1.800 8.07000e-06 1.800
+ 8.07002e-06 0.000 8.08000e-06 0.000 8.08002e-06 1.800 8.08600e-06 1.800 8.08602e-06 0.000 8.09400e-06 0.000
+ 8.09402e-06 1.800 8.10000e-06 1.800 8.10002e-06 0.000 8.11200e-06 0.000 8.11202e-06 1.800 8.11800e-06 1.800
+ 8.11802e-06 0.000 8.12600e-06 0.000 8.12602e-06 1.800 8.13200e-06 1.800 8.13202e-06 0.000 8.14200e-06 0.000
+ 8.14202e-06 1.800 8.14800e-06 1.800 8.14802e-06 0.000 8.15600e-06 0.000 8.15602e-06 1.800 8.16000e-06 1.800
+ 8.16002e-06 0.000 8.16200e-06 0.000 8.16202e-06 1.800 8.16600e-06 1.800 8.16602e-06 0.000 8.16800e-06 0.000
+ 8.16802e-06 1.800 8.17400e-06 1.800 8.17402e-06 0.000 8.17600e-06 0.000 8.17602e-06 1.800 8.18000e-06 1.800
+ 8.18002e-06 0.000 8.18200e-06 0.000 8.18202e-06 1.800 8.19000e-06 1.800 8.19002e-06 0.000 8.19200e-06 0.000
+ 8.19202e-06 1.800 8.19600e-06 1.800 8.19602e-06 0.000 8.19800e-06 0.000 8.19802e-06 1.800 8.20400e-06 1.800
+ 8.20402e-06 0.000 8.20600e-06 0.000 8.20602e-06 1.800 8.21000e-06 1.800 8.21002e-06 0.000 8.21200e-06 0.000
+ 8.21202e-06 1.800 8.22200e-06 1.800 8.22202e-06 0.000 8.22400e-06 0.000 8.22402e-06 1.800 8.22800e-06 1.800
+ 8.22802e-06 0.000 8.23000e-06 0.000 8.23002e-06 1.800 8.23600e-06 1.800 8.23602e-06 0.000 8.23800e-06 0.000
+ 8.23802e-06 1.800 8.24200e-06 1.800 8.24202e-06 0.000 8.24400e-06 0.000 8.24402e-06 1.800 8.25200e-06 1.800
+ 8.25202e-06 0.000 8.25400e-06 0.000 8.25402e-06 1.800 8.25800e-06 1.800 8.25802e-06 0.000 8.26000e-06 0.000
+ 8.26002e-06 1.800 8.26600e-06 1.800 8.26602e-06 0.000 8.26800e-06 0.000 8.26802e-06 1.800 8.27200e-06 1.800
+ 8.27202e-06 0.000 8.40200e-06 0.000 8.40202e-06 1.800 8.61000e-06 1.800 8.61002e-06 0.000 8.69000e-06 0.000
+ 8.69002e-06 1.800 8.69200e-06 1.800 8.69202e-06 0.000 8.69600e-06 0.000 8.69602e-06 1.800 8.69800e-06 1.800
+ 8.69802e-06 0.000 8.70400e-06 0.000 8.70402e-06 1.800 8.70600e-06 1.800 8.70602e-06 0.000 8.71000e-06 0.000
+ 8.71002e-06 1.800 8.71200e-06 1.800 8.71202e-06 0.000 8.72000e-06 0.000 8.72002e-06 1.800 8.72200e-06 1.800
+ 8.72202e-06 0.000 8.72600e-06 0.000 8.72602e-06 1.800 8.72800e-06 1.800 8.72802e-06 0.000 8.73400e-06 0.000
+ 8.73402e-06 1.800 8.73600e-06 1.800 8.73602e-06 0.000 8.74000e-06 0.000 8.74002e-06 1.800 8.74200e-06 1.800
+ 8.74202e-06 0.000 8.75200e-06 0.000 8.75202e-06 1.800 8.75400e-06 1.800 8.75402e-06 0.000 8.75800e-06 0.000
+ 8.75802e-06 1.800 8.76000e-06 1.800 8.76002e-06 0.000 8.76600e-06 0.000 8.76602e-06 1.800 8.76800e-06 1.800
+ 8.76802e-06 0.000 8.77200e-06 0.000 8.77202e-06 1.800 8.77400e-06 1.800 8.77402e-06 0.000 8.78200e-06 0.000
+ 8.78202e-06 1.800 8.78400e-06 1.800 8.78402e-06 0.000 8.78800e-06 0.000 8.78802e-06 1.800 8.79000e-06 1.800
+ 8.79002e-06 0.000 8.79600e-06 0.000 8.79602e-06 1.800 8.79800e-06 1.800 8.79802e-06 0.000 8.80200e-06 0.000
+ 8.80202e-06 1.800 8.93200e-06 1.800 8.93202e-06 0.000 9.14000e-06 0.000 9.14002e-06 1.800 9.21800e-06 1.800
+ )
Xd_g3b src_g3b g3b vdd gnd tb_x1
Vt0b src_t0b gnd PWL(
+ 0.00000e+00 1.800 1.26000e-07 1.800 1.26020e-07 0.000 2.52000e-07 0.000 2.52020e-07 1.800 3.80000e-07 1.800
+ 3.80020e-07 0.000 5.06000e-07 0.000 5.06020e-07 1.800 6.36000e-07 1.800 6.36020e-07 0.000 7.62000e-07 0.000
+ 7.62020e-07 1.800 8.90000e-07 1.800 8.90020e-07 0.000 1.01600e-06 0.000 1.01602e-06 1.800 1.14800e-06 1.800
+ 1.14802e-06 0.000 1.27400e-06 0.000 1.27402e-06 1.800 1.40200e-06 1.800 1.40202e-06 0.000 1.52800e-06 0.000
+ 1.52802e-06 1.800 1.65800e-06 1.800 1.65802e-06 0.000 1.78400e-06 0.000 1.78402e-06 1.800 1.91200e-06 1.800
+ 1.91202e-06 0.000 2.08800e-06 0.000 2.08802e-06 1.800 2.15000e-06 1.800 2.15002e-06 0.000 2.21400e-06 0.000
+ 2.21402e-06 1.800 2.27600e-06 1.800 2.27602e-06 0.000 2.34200e-06 0.000 2.34202e-06 1.800 2.40400e-06 1.800
+ 2.40402e-06 0.000 2.46800e-06 0.000 2.46802e-06 1.800 2.53000e-06 1.800 2.53002e-06 0.000 2.59800e-06 0.000
+ 2.59802e-06 1.800 2.66000e-06 1.800 2.66002e-06 0.000 2.72400e-06 0.000 2.72402e-06 1.800 2.78600e-06 1.800
+ 2.78602e-06 0.000 2.85200e-06 0.000 2.85202e-06 1.800 2.91400e-06 1.800 2.91402e-06 0.000 2.97800e-06 0.000
+ 2.97802e-06 1.800 3.06000e-06 1.800 3.06002e-06 0.000 3.09000e-06 0.000 3.09002e-06 1.800 3.12200e-06 1.800
+ 3.12202e-06 0.000 3.15200e-06 0.000 3.15202e-06 1.800 3.18600e-06 1.800 3.18602e-06 0.000 3.21600e-06 0.000
+ 3.21602e-06 1.800 3.24800e-06 1.800 3.24802e-06 0.000 3.27800e-06 0.000 3.27802e-06 1.800 3.31400e-06 1.800
+ 3.31402e-06 0.000 3.34400e-06 0.000 3.34402e-06 1.800 3.37600e-06 1.800 3.37602e-06 0.000 3.40600e-06 0.000
+ 3.40602e-06 1.800 3.44000e-06 1.800 3.44002e-06 0.000 3.47000e-06 0.000 3.47002e-06 1.800 3.50200e-06 1.800
+ 3.50202e-06 0.000 3.53800e-06 0.000 3.53802e-06 1.800 3.55200e-06 1.800 3.55202e-06 0.000 3.56800e-06 0.000
+ 3.56802e-06 1.800 3.58200e-06 1.800 3.58202e-06 0.000 3.60000e-06 0.000 3.60002e-06 1.800 3.61400e-06 1.800
+ 3.61402e-06 0.000 3.63000e-06 0.000 3.63002e-06 1.800 3.64400e-06 1.800 3.64402e-06 0.000 3.66400e-06 0.000
+ 3.66402e-06 1.800 3.67800e-06 1.800 3.67802e-06 0.000 3.69400e-06 0.000 3.69402e-06 1.800 3.70800e-06 1.800
+ 3.70802e-06 0.000 3.72600e-06 0.000 3.72602e-06 1.800 3.74000e-06 1.800 3.74002e-06 0.000 3.75600e-06 0.000
+ 3.75602e-06 1.800 3.77000e-06 1.800 3.77002e-06 0.000 3.77600e-06 0.000 3.77602e-06 1.800 3.78400e-06 1.800
+ 3.78402e-06 0.000 3.79000e-06 0.000 3.79002e-06 1.800 3.80000e-06 1.800 3.80002e-06 0.000 3.80600e-06 0.000
+ 3.80602e-06 1.800 3.81400e-06 1.800 3.81402e-06 0.000 3.82000e-06 0.000 3.82002e-06 1.800 3.83200e-06 1.800
+ 3.83202e-06 0.000 3.83800e-06 0.000 3.83802e-06 1.800 3.84600e-06 1.800 3.84602e-06 0.000 3.85200e-06 0.000
+ 3.85202e-06 1.800 3.86200e-06 1.800 3.86202e-06 0.000 3.86800e-06 0.000 3.86802e-06 1.800 3.87600e-06 1.800
+ 3.87602e-06 0.000 3.88000e-06 0.000 3.88002e-06 1.800 3.88200e-06 1.800 3.88202e-06 0.000 3.88600e-06 0.000
+ 3.88602e-06 1.800 3.88800e-06 1.800 3.88802e-06 0.000 3.89400e-06 0.000 3.89402e-06 1.800 3.89600e-06 1.800
+ 3.89602e-06 0.000 3.90000e-06 0.000 3.90002e-06 1.800 3.90200e-06 1.800 3.90202e-06 0.000 3.91000e-06 0.000
+ 3.91002e-06 1.800 3.91200e-06 1.800 3.91202e-06 0.000 3.91600e-06 0.000 3.91602e-06 1.800 3.91800e-06 1.800
+ 3.91802e-06 0.000 3.92400e-06 0.000 3.92402e-06 1.800 3.92600e-06 1.800 3.92602e-06 0.000 3.93000e-06 0.000
+ 3.93002e-06 1.800 3.98000e-06 1.800 3.98002e-06 0.000 4.05800e-06 0.000 4.05802e-06 1.800 4.08800e-06 1.800
+ 4.08802e-06 0.000 4.09000e-06 0.000 4.09002e-06 1.800 4.09400e-06 1.800 4.09402e-06 0.000 4.09600e-06 0.000
+ 4.09602e-06 1.800 4.10200e-06 1.800 4.10202e-06 0.000 4.10400e-06 0.000 4.10402e-06 1.800 4.10800e-06 1.800
+ 4.10802e-06 0.000 4.11000e-06 0.000 4.11002e-06 1.800 4.11800e-06 1.800 4.11802e-06 0.000 4.12000e-06 0.000
+ 4.12002e-06 1.800 4.12400e-06 1.800 4.12402e-06 0.000 4.12600e-06 0.000 4.12602e-06 1.800 4.13200e-06 1.800
+ 4.13202e-06 0.000 4.13400e-06 0.000 4.13402e-06 1.800 4.13800e-06 1.800 4.13802e-06 0.000 4.18800e-06 0.000
+ 4.18802e-06 1.800 4.26600e-06 1.800 4.26602e-06 0.000 4.30000e-06 0.000 4.30002e-06 1.800 4.30600e-06 1.800
+ 4.30602e-06 0.000 4.31400e-06 0.000 4.31402e-06 1.800 4.32000e-06 1.800 4.32002e-06 0.000 4.33000e-06 0.000
+ 4.33002e-06 1.800 4.33600e-06 1.800 4.33602e-06 0.000 4.34400e-06 0.000 4.34402e-06 1.800 4.35000e-06 1.800
+ 4.35002e-06 0.000 4.36200e-06 0.000 4.36202e-06 1.800 4.36800e-06 1.800 4.36802e-06 0.000 4.37600e-06 0.000
+ 4.37602e-06 1.800 4.38200e-06 1.800 4.38202e-06 0.000 4.39200e-06 0.000 4.39202e-06 1.800 4.39800e-06 1.800
+ 4.39802e-06 0.000 4.40600e-06 0.000 4.40602e-06 1.800 4.41000e-06 1.800 4.41002e-06 0.000 4.41200e-06 0.000
+ 4.41202e-06 1.800 4.41600e-06 1.800 4.41602e-06 0.000 4.41800e-06 0.000 4.41802e-06 1.800 4.42400e-06 1.800
+ 4.42402e-06 0.000 4.42600e-06 0.000 4.42602e-06 1.800 4.43000e-06 1.800 4.43002e-06 0.000 4.43200e-06 0.000
+ 4.43202e-06 1.800 4.44000e-06 1.800 4.44002e-06 0.000 4.44200e-06 0.000 4.44202e-06 1.800 4.44600e-06 1.800
+ 4.44602e-06 0.000 4.44800e-06 0.000 4.44802e-06 1.800 4.45400e-06 1.800 4.45402e-06 0.000 4.45600e-06 0.000
+ 4.45602e-06 1.800 4.46000e-06 1.800 4.46002e-06 0.000 4.51000e-06 0.000 4.51002e-06 1.800 4.58800e-06 1.800
+ 4.58802e-06 0.000 4.61800e-06 0.000 4.61802e-06 1.800 4.62000e-06 1.800 4.62002e-06 0.000 4.62400e-06 0.000
+ 4.62402e-06 1.800 4.62600e-06 1.800 4.62602e-06 0.000 4.63200e-06 0.000 4.63202e-06 1.800 4.63400e-06 1.800
+ 4.63402e-06 0.000 4.63800e-06 0.000 4.63802e-06 1.800 4.64000e-06 1.800 4.64002e-06 0.000 4.64800e-06 0.000
+ 4.64802e-06 1.800 4.65000e-06 1.800 4.65002e-06 0.000 4.65400e-06 0.000 4.65402e-06 1.800 4.65600e-06 1.800
+ 4.65602e-06 0.000 4.66200e-06 0.000 4.66202e-06 1.800 4.66400e-06 1.800 4.66402e-06 0.000 4.66800e-06 0.000
+ 4.66802e-06 1.800 4.71800e-06 1.800 4.71802e-06 0.000 4.79600e-06 0.000 4.79602e-06 1.800 4.83800e-06 1.800
+ 4.83802e-06 0.000 4.85200e-06 0.000 4.85202e-06 1.800 4.86800e-06 1.800 4.86802e-06 0.000 4.88200e-06 0.000
+ 4.88202e-06 1.800 4.90000e-06 1.800 4.90002e-06 0.000 4.91400e-06 0.000 4.91402e-06 1.800 4.93000e-06 1.800
+ 4.93002e-06 0.000 4.94400e-06 0.000 4.94402e-06 1.800 4.96400e-06 1.800 4.96402e-06 0.000 4.97800e-06 0.000
+ 4.97802e-06 1.800 4.99400e-06 1.800 4.99402e-06 0.000 5.00800e-06 0.000 5.00802e-06 1.800 5.02600e-06 1.800
+ 5.02602e-06 0.000 5.04000e-06 0.000 5.04002e-06 1.800 5.05600e-06 1.800 5.05602e-06 0.000 5.07000e-06 0.000
+ 5.07002e-06 1.800 5.07600e-06 1.800 5.07602e-06 0.000 5.08400e-06 0.000 5.08402e-06 1.800 5.09000e-06 1.800
+ 5.09002e-06 0.000 5.10000e-06 0.000 5.10002e-06 1.800 5.10600e-06 1.800 5.10602e-06 0.000 5.11400e-06 0.000
+ 5.11402e-06 1.800 5.12000e-06 1.800 5.12002e-06 0.000 5.13200e-06 0.000 5.13202e-06 1.800 5.13800e-06 1.800
+ 5.13802e-06 0.000 5.14600e-06 0.000 5.14602e-06 1.800 5.15200e-06 1.800 5.15202e-06 0.000 5.16200e-06 0.000
+ 5.16202e-06 1.800 5.16800e-06 1.800 5.16802e-06 0.000 5.17600e-06 0.000 5.17602e-06 1.800 5.18000e-06 1.800
+ 5.18002e-06 0.000 5.18200e-06 0.000 5.18202e-06 1.800 5.18600e-06 1.800 5.18602e-06 0.000 5.18800e-06 0.000
+ 5.18802e-06 1.800 5.19400e-06 1.800 5.19402e-06 0.000 5.19600e-06 0.000 5.19602e-06 1.800 5.20000e-06 1.800
+ 5.20002e-06 0.000 5.20200e-06 0.000 5.20202e-06 1.800 5.21000e-06 1.800 5.21002e-06 0.000 5.21200e-06 0.000
+ 5.21202e-06 1.800 5.21600e-06 1.800 5.21602e-06 0.000 5.21800e-06 0.000 5.21802e-06 1.800 5.22400e-06 1.800
+ 5.22402e-06 0.000 5.22600e-06 0.000 5.22602e-06 1.800 5.23000e-06 1.800 5.23002e-06 0.000 5.28000e-06 0.000
+ 5.28002e-06 1.800 5.35800e-06 1.800 5.35802e-06 0.000 5.38800e-06 0.000 5.38802e-06 1.800 5.39000e-06 1.800
+ 5.39002e-06 0.000 5.39400e-06 0.000 5.39402e-06 1.800 5.39600e-06 1.800 5.39602e-06 0.000 5.40200e-06 0.000
+ 5.40202e-06 1.800 5.40400e-06 1.800 5.40402e-06 0.000 5.40800e-06 0.000 5.40802e-06 1.800 5.41000e-06 1.800
+ 5.41002e-06 0.000 5.41800e-06 0.000 5.41802e-06 1.800 5.42000e-06 1.800 5.42002e-06 0.000 5.42400e-06 0.000
+ 5.42402e-06 1.800 5.42600e-06 1.800 5.42602e-06 0.000 5.43200e-06 0.000 5.43202e-06 1.800 5.43400e-06 1.800
+ 5.43402e-06 0.000 5.43800e-06 0.000 5.43802e-06 1.800 5.48800e-06 1.800 5.48802e-06 0.000 5.56600e-06 0.000
+ 5.56602e-06 1.800 5.60000e-06 1.800 5.60002e-06 0.000 5.60600e-06 0.000 5.60602e-06 1.800 5.61400e-06 1.800
+ 5.61402e-06 0.000 5.62000e-06 0.000 5.62002e-06 1.800 5.63000e-06 1.800 5.63002e-06 0.000 5.63600e-06 0.000
+ 5.63602e-06 1.800 5.64400e-06 1.800 5.64402e-06 0.000 5.65000e-06 0.000 5.65002e-06 1.800 5.66200e-06 1.800
+ 5.66202e-06 0.000 5.66800e-06 0.000 5.66802e-06 1.800 5.67600e-06 1.800 5.67602e-06 0.000 5.68200e-06 0.000
+ 5.68202e-06 1.800 5.69200e-06 1.800 5.69202e-06 0.000 5.69800e-06 0.000 5.69802e-06 1.800 5.70600e-06 1.800
+ 5.70602e-06 0.000 5.71000e-06 0.000 5.71002e-06 1.800 5.71200e-06 1.800 5.71202e-06 0.000 5.71600e-06 0.000
+ 5.71602e-06 1.800 5.71800e-06 1.800 5.71802e-06 0.000 5.72400e-06 0.000 5.72402e-06 1.800 5.72600e-06 1.800
+ 5.72602e-06 0.000 5.73000e-06 0.000 5.73002e-06 1.800 5.73200e-06 1.800 5.73202e-06 0.000 5.74000e-06 0.000
+ 5.74002e-06 1.800 5.74200e-06 1.800 5.74202e-06 0.000 5.74600e-06 0.000 5.74602e-06 1.800 5.74800e-06 1.800
+ 5.74802e-06 0.000 5.75400e-06 0.000 5.75402e-06 1.800 5.75600e-06 1.800 5.75602e-06 0.000 5.76000e-06 0.000
+ 5.76002e-06 1.800 5.81000e-06 1.800 5.81002e-06 0.000 5.88800e-06 0.000 5.88802e-06 1.800 5.91800e-06 1.800
+ 5.91802e-06 0.000 5.92000e-06 0.000 5.92002e-06 1.800 5.92400e-06 1.800 5.92402e-06 0.000 5.92600e-06 0.000
+ 5.92602e-06 1.800 5.93200e-06 1.800 5.93202e-06 0.000 5.93400e-06 0.000 5.93402e-06 1.800 5.93800e-06 1.800
+ 5.93802e-06 0.000 5.94000e-06 0.000 5.94002e-06 1.800 5.94800e-06 1.800 5.94802e-06 0.000 5.95000e-06 0.000
+ 5.95002e-06 1.800 5.95400e-06 1.800 5.95402e-06 0.000 5.95600e-06 0.000 5.95602e-06 1.800 5.96200e-06 1.800
+ 5.96202e-06 0.000 5.96400e-06 0.000 5.96402e-06 1.800 5.96800e-06 1.800 5.96802e-06 0.000 6.01800e-06 0.000
+ 6.01802e-06 1.800 6.09600e-06 1.800 6.09602e-06 0.000 6.15400e-06 0.000 6.15402e-06 1.800 6.18400e-06 1.800
+ 6.18402e-06 0.000 6.21600e-06 0.000 6.21602e-06 1.800 6.24600e-06 1.800 6.24602e-06 0.000 6.28000e-06 0.000
+ 6.28002e-06 1.800 6.31000e-06 1.800 6.31002e-06 0.000 6.34200e-06 0.000 6.34202e-06 1.800 6.37200e-06 1.800
+ 6.37202e-06 0.000 6.40800e-06 0.000 6.40802e-06 1.800 6.43800e-06 1.800 6.43802e-06 0.000 6.47000e-06 0.000
+ 6.47002e-06 1.800 6.50000e-06 1.800 6.50002e-06 0.000 6.53400e-06 0.000 6.53402e-06 1.800 6.56400e-06 1.800
+ 6.56402e-06 0.000 6.59600e-06 0.000 6.59602e-06 1.800 6.63200e-06 1.800 6.63202e-06 0.000 6.64600e-06 0.000
+ 6.64602e-06 1.800 6.66200e-06 1.800 6.66202e-06 0.000 6.67600e-06 0.000 6.67602e-06 1.800 6.69400e-06 1.800
+ 6.69402e-06 0.000 6.70800e-06 0.000 6.70802e-06 1.800 6.72400e-06 1.800 6.72402e-06 0.000 6.73800e-06 0.000
+ 6.73802e-06 1.800 6.75800e-06 1.800 6.75802e-06 0.000 6.77200e-06 0.000 6.77202e-06 1.800 6.78800e-06 1.800
+ 6.78802e-06 0.000 6.80200e-06 0.000 6.80202e-06 1.800 6.82000e-06 1.800 6.82002e-06 0.000 6.83400e-06 0.000
+ 6.83402e-06 1.800 6.85000e-06 1.800 6.85002e-06 0.000 6.86400e-06 0.000 6.86402e-06 1.800 6.87000e-06 1.800
+ 6.87002e-06 0.000 6.87800e-06 0.000 6.87802e-06 1.800 6.88400e-06 1.800 6.88402e-06 0.000 6.89400e-06 0.000
+ 6.89402e-06 1.800 6.90000e-06 1.800 6.90002e-06 0.000 6.90800e-06 0.000 6.90802e-06 1.800 6.91400e-06 1.800
+ 6.91402e-06 0.000 6.92600e-06 0.000 6.92602e-06 1.800 6.93200e-06 1.800 6.93202e-06 0.000 6.94000e-06 0.000
+ 6.94002e-06 1.800 6.94600e-06 1.800 6.94602e-06 0.000 6.95600e-06 0.000 6.95602e-06 1.800 6.96200e-06 1.800
+ 6.96202e-06 0.000 6.97000e-06 0.000 6.97002e-06 1.800 6.97400e-06 1.800 6.97402e-06 0.000 6.97600e-06 0.000
+ 6.97602e-06 1.800 6.98000e-06 1.800 6.98002e-06 0.000 6.98200e-06 0.000 6.98202e-06 1.800 6.98800e-06 1.800
+ 6.98802e-06 0.000 6.99000e-06 0.000 6.99002e-06 1.800 6.99400e-06 1.800 6.99402e-06 0.000 6.99600e-06 0.000
+ 6.99602e-06 1.800 7.00400e-06 1.800 7.00402e-06 0.000 7.00600e-06 0.000 7.00602e-06 1.800 7.01000e-06 1.800
+ 7.01002e-06 0.000 7.01200e-06 0.000 7.01202e-06 1.800 7.01800e-06 1.800 7.01802e-06 0.000 7.02000e-06 0.000
+ 7.02002e-06 1.800 7.02400e-06 1.800 7.02402e-06 0.000 7.07400e-06 0.000 7.07402e-06 1.800 7.15200e-06 1.800
+ 7.15202e-06 0.000 7.18200e-06 0.000 7.18202e-06 1.800 7.18400e-06 1.800 7.18402e-06 0.000 7.18800e-06 0.000
+ 7.18802e-06 1.800 7.19000e-06 1.800 7.19002e-06 0.000 7.19600e-06 0.000 7.19602e-06 1.800 7.19800e-06 1.800
+ 7.19802e-06 0.000 7.20200e-06 0.000 7.20202e-06 1.800 7.20400e-06 1.800 7.20402e-06 0.000 7.21200e-06 0.000
+ 7.21202e-06 1.800 7.21400e-06 1.800 7.21402e-06 0.000 7.21800e-06 0.000 7.21802e-06 1.800 7.22000e-06 1.800
+ 7.22002e-06 0.000 7.22600e-06 0.000 7.22602e-06 1.800 7.22800e-06 1.800 7.22802e-06 0.000 7.23200e-06 0.000
+ 7.23202e-06 1.800 7.28200e-06 1.800 7.28202e-06 0.000 7.36000e-06 0.000 7.36002e-06 1.800 7.39400e-06 1.800
+ 7.39402e-06 0.000 7.40000e-06 0.000 7.40002e-06 1.800 7.40800e-06 1.800 7.40802e-06 0.000 7.41400e-06 0.000
+ 7.41402e-06 1.800 7.42400e-06 1.800 7.42402e-06 0.000 7.43000e-06 0.000 7.43002e-06 1.800 7.43800e-06 1.800
+ 7.43802e-06 0.000 7.44400e-06 0.000 7.44402e-06 1.800 7.45600e-06 1.800 7.45602e-06 0.000 7.46200e-06 0.000
+ 7.46202e-06 1.800 7.47000e-06 1.800 7.47002e-06 0.000 7.47600e-06 0.000 7.47602e-06 1.800 7.48600e-06 1.800
+ 7.48602e-06 0.000 7.49200e-06 0.000 7.49202e-06 1.800 7.50000e-06 1.800 7.50002e-06 0.000 7.50400e-06 0.000
+ 7.50402e-06 1.800 7.50600e-06 1.800 7.50602e-06 0.000 7.51000e-06 0.000 7.51002e-06 1.800 7.51200e-06 1.800
+ 7.51202e-06 0.000 7.51800e-06 0.000 7.51802e-06 1.800 7.52000e-06 1.800 7.52002e-06 0.000 7.52400e-06 0.000
+ 7.52402e-06 1.800 7.52600e-06 1.800 7.52602e-06 0.000 7.53400e-06 0.000 7.53402e-06 1.800 7.53600e-06 1.800
+ 7.53602e-06 0.000 7.54000e-06 0.000 7.54002e-06 1.800 7.54200e-06 1.800 7.54202e-06 0.000 7.54800e-06 0.000
+ 7.54802e-06 1.800 7.55000e-06 1.800 7.55002e-06 0.000 7.55400e-06 0.000 7.55402e-06 1.800 7.60400e-06 1.800
+ 7.60402e-06 0.000 7.68200e-06 0.000 7.68202e-06 1.800 7.71200e-06 1.800 7.71202e-06 0.000 7.71400e-06 0.000
+ 7.71402e-06 1.800 7.71800e-06 1.800 7.71802e-06 0.000 7.72000e-06 0.000 7.72002e-06 1.800 7.72600e-06 1.800
+ 7.72602e-06 0.000 7.72800e-06 0.000 7.72802e-06 1.800 7.73200e-06 1.800 7.73202e-06 0.000 7.73400e-06 0.000
+ 7.73402e-06 1.800 7.74200e-06 1.800 7.74202e-06 0.000 7.74400e-06 0.000 7.74402e-06 1.800 7.74800e-06 1.800
+ 7.74802e-06 0.000 7.75000e-06 0.000 7.75002e-06 1.800 7.75600e-06 1.800 7.75602e-06 0.000 7.75800e-06 0.000
+ 7.75802e-06 1.800 7.76200e-06 1.800 7.76202e-06 0.000 7.81200e-06 0.000 7.81202e-06 1.800 7.89000e-06 1.800
+ 7.89002e-06 0.000 7.93200e-06 0.000 7.93202e-06 1.800 7.94600e-06 1.800 7.94602e-06 0.000 7.96200e-06 0.000
+ 7.96202e-06 1.800 7.97600e-06 1.800 7.97602e-06 0.000 7.99400e-06 0.000 7.99402e-06 1.800 8.00800e-06 1.800
+ 8.00802e-06 0.000 8.02400e-06 0.000 8.02402e-06 1.800 8.03800e-06 1.800 8.03802e-06 0.000 8.05800e-06 0.000
+ 8.05802e-06 1.800 8.07200e-06 1.800 8.07202e-06 0.000 8.08800e-06 0.000 8.08802e-06 1.800 8.10200e-06 1.800
+ 8.10202e-06 0.000 8.12000e-06 0.000 8.12002e-06 1.800 8.13400e-06 1.800 8.13402e-06 0.000 8.15000e-06 0.000
+ 8.15002e-06 1.800 8.16400e-06 1.800 8.16402e-06 0.000 8.17000e-06 0.000 8.17002e-06 1.800 8.17800e-06 1.800
+ 8.17802e-06 0.000 8.18400e-06 0.000 8.18402e-06 1.800 8.19400e-06 1.800 8.19402e-06 0.000 8.20000e-06 0.000
+ 8.20002e-06 1.800 8.20800e-06 1.800 8.20802e-06 0.000 8.21400e-06 0.000 8.21402e-06 1.800 8.22600e-06 1.800
+ 8.22602e-06 0.000 8.23200e-06 0.000 8.23202e-06 1.800 8.24000e-06 1.800 8.24002e-06 0.000 8.24600e-06 0.000
+ 8.24602e-06 1.800 8.25600e-06 1.800 8.25602e-06 0.000 8.26200e-06 0.000 8.26202e-06 1.800 8.27000e-06 1.800
+ 8.27002e-06 0.000 8.27400e-06 0.000 8.27402e-06 1.800 8.27600e-06 1.800 8.27602e-06 0.000 8.28000e-06 0.000
+ 8.28002e-06 1.800 8.28200e-06 1.800 8.28202e-06 0.000 8.28800e-06 0.000 8.28802e-06 1.800 8.29000e-06 1.800
+ 8.29002e-06 0.000 8.29400e-06 0.000 8.29402e-06 1.800 8.29600e-06 1.800 8.29602e-06 0.000 8.30400e-06 0.000
+ 8.30402e-06 1.800 8.30600e-06 1.800 8.30602e-06 0.000 8.31000e-06 0.000 8.31002e-06 1.800 8.31200e-06 1.800
+ 8.31202e-06 0.000 8.31800e-06 0.000 8.31802e-06 1.800 8.32000e-06 1.800 8.32002e-06 0.000 8.32400e-06 0.000
+ 8.32402e-06 1.800 8.37400e-06 1.800 8.37402e-06 0.000 8.45200e-06 0.000 8.45202e-06 1.800 8.48200e-06 1.800
+ 8.48202e-06 0.000 8.48400e-06 0.000 8.48402e-06 1.800 8.48800e-06 1.800 8.48802e-06 0.000 8.49000e-06 0.000
+ 8.49002e-06 1.800 8.49600e-06 1.800 8.49602e-06 0.000 8.49800e-06 0.000 8.49802e-06 1.800 8.50200e-06 1.800
+ 8.50202e-06 0.000 8.50400e-06 0.000 8.50402e-06 1.800 8.51200e-06 1.800 8.51202e-06 0.000 8.51400e-06 0.000
+ 8.51402e-06 1.800 8.51800e-06 1.800 8.51802e-06 0.000 8.52000e-06 0.000 8.52002e-06 1.800 8.52600e-06 1.800
+ 8.52602e-06 0.000 8.52800e-06 0.000 8.52802e-06 1.800 8.53200e-06 1.800 8.53202e-06 0.000 8.58200e-06 0.000
+ 8.58202e-06 1.800 8.66000e-06 1.800 8.66002e-06 0.000 8.69400e-06 0.000 8.69402e-06 1.800 8.70000e-06 1.800
+ 8.70002e-06 0.000 8.70800e-06 0.000 8.70802e-06 1.800 8.71400e-06 1.800 8.71402e-06 0.000 8.72400e-06 0.000
+ 8.72402e-06 1.800 8.73000e-06 1.800 8.73002e-06 0.000 8.73800e-06 0.000 8.73802e-06 1.800 8.74400e-06 1.800
+ 8.74402e-06 0.000 8.75600e-06 0.000 8.75602e-06 1.800 8.76200e-06 1.800 8.76202e-06 0.000 8.77000e-06 0.000
+ 8.77002e-06 1.800 8.77600e-06 1.800 8.77602e-06 0.000 8.78600e-06 0.000 8.78602e-06 1.800 8.79200e-06 1.800
+ 8.79202e-06 0.000 8.80000e-06 0.000 8.80002e-06 1.800 8.80400e-06 1.800 8.80402e-06 0.000 8.80600e-06 0.000
+ 8.80602e-06 1.800 8.81000e-06 1.800 8.81002e-06 0.000 8.81200e-06 0.000 8.81202e-06 1.800 8.81800e-06 1.800
+ 8.81802e-06 0.000 8.82000e-06 0.000 8.82002e-06 1.800 8.82400e-06 1.800 8.82402e-06 0.000 8.82600e-06 0.000
+ 8.82602e-06 1.800 8.83400e-06 1.800 8.83402e-06 0.000 8.83600e-06 0.000 8.83602e-06 1.800 8.84000e-06 1.800
+ 8.84002e-06 0.000 8.84200e-06 0.000 8.84202e-06 1.800 8.84800e-06 1.800 8.84802e-06 0.000 8.85000e-06 0.000
+ 8.85002e-06 1.800 8.85400e-06 1.800 8.85402e-06 0.000 8.90400e-06 0.000 8.90402e-06 1.800 8.98200e-06 1.800
+ 8.98202e-06 0.000 9.01200e-06 0.000 9.01202e-06 1.800 9.01400e-06 1.800 9.01402e-06 0.000 9.01800e-06 0.000
+ 9.01802e-06 1.800 9.02000e-06 1.800 9.02002e-06 0.000 9.02600e-06 0.000 9.02602e-06 1.800 9.02800e-06 1.800
+ 9.02802e-06 0.000 9.03200e-06 0.000 9.03202e-06 1.800 9.03400e-06 1.800 9.03402e-06 0.000 9.04200e-06 0.000
+ 9.04202e-06 1.800 9.04400e-06 1.800 9.04402e-06 0.000 9.04800e-06 0.000 9.04802e-06 1.800 9.05000e-06 1.800
+ 9.05002e-06 0.000 9.05600e-06 0.000 9.05602e-06 1.800 9.05800e-06 1.800 9.05802e-06 0.000 9.06200e-06 0.000
+ 9.06202e-06 1.800 9.11200e-06 1.800 9.11202e-06 0.000 9.19000e-06 0.000 9.19002e-06 1.800 9.21800e-06 1.800
+ )
Xd_t0b src_t0b t0b vdd gnd tb_x1
Vt1b src_t1b gnd PWL(
+ 0.00000e+00 1.800 2.54000e-07 1.800 2.54020e-07 0.000 5.08000e-07 0.000 5.08020e-07 1.800 7.64000e-07 1.800
+ 7.64020e-07 0.000 1.01800e-06 0.000 1.01802e-06 1.800 1.27600e-06 1.800 1.27602e-06 0.000 1.53000e-06 0.000
+ 1.53002e-06 1.800 1.78600e-06 1.800 1.78602e-06 0.000 2.15200e-06 0.000 2.15202e-06 1.800 2.27800e-06 1.800
+ 2.27802e-06 0.000 2.40600e-06 0.000 2.40602e-06 1.800 2.53200e-06 1.800 2.53202e-06 0.000 2.66200e-06 0.000
+ 2.66202e-06 1.800 2.78800e-06 1.800 2.78802e-06 0.000 2.91600e-06 0.000 2.91602e-06 1.800 3.09200e-06 1.800
+ 3.09202e-06 0.000 3.15400e-06 0.000 3.15402e-06 1.800 3.21800e-06 1.800 3.21802e-06 0.000 3.28000e-06 0.000
+ 3.28002e-06 1.800 3.34600e-06 1.800 3.34602e-06 0.000 3.40800e-06 0.000 3.40802e-06 1.800 3.47200e-06 1.800
+ 3.47202e-06 0.000 3.55400e-06 0.000 3.55402e-06 1.800 3.58400e-06 1.800 3.58402e-06 0.000 3.61600e-06 0.000
+ 3.61602e-06 1.800 3.64600e-06 1.800 3.64602e-06 0.000 3.68000e-06 0.000 3.68002e-06 1.800 3.71000e-06 1.800
+ 3.71002e-06 0.000 3.74200e-06 0.000 3.74202e-06 1.800 3.77800e-06 1.800 3.77802e-06 0.000 3.79200e-06 0.000
+ 3.79202e-06 1.800 3.80800e-06 1.800 3.80802e-06 0.000 3.82200e-06 0.000 3.82202e-06 1.800 3.84000e-06 1.800
+ 3.84002e-06 0.000 3.85400e-06 0.000 3.85402e-06 1.800 3.87000e-06 1.800 3.87002e-06 0.000 3.88400e-06 0.000
+ 3.88402e-06 1.800 3.89000e-06 1.800 3.89002e-06 0.000 3.89800e-06 0.000 3.89802e-06 1.800 3.90400e-06 1.800
+ 3.90402e-06 0.000 3.91400e-06 0.000 3.91402e-06 1.800 3.92000e-06 1.800 3.92002e-06 0.000 3.92800e-06 0.000
+ 3.92802e-06 1.800 3.93200e-06 1.800 3.93202e-06 0.000 3.93400e-06 0.000 3.93402e-06 1.800 3.93800e-06 1.800
+ 3.93802e-06 0.000 3.94000e-06 0.000 3.94002e-06 1.800 3.94600e-06 1.800 3.94602e-06 0.000 3.94800e-06 0.000
+ 3.94802e-06 1.800 3.95200e-06 1.800 3.95202e-06 0.000 3.97000e-06 0.000 3.97002e-06 1.800 3.99800e-06 1.800
+ 3.99802e-06 0.000 4.01000e-06 0.000 4.01002e-06 1.800 4.01200e-06 1.800 4.01202e-06 0.000 4.01600e-06 0.000
+ 4.01602e-06 1.800 4.01800e-06 1.800 4.01802e-06 0.000 4.02400e-06 0.000 4.02402e-06 1.800 4.02600e-06 1.800
+ 4.02602e-06 0.000 4.03000e-06 0.000 4.03002e-06 1.800 4.04800e-06 1.800 4.04802e-06 0.000 4.07600e-06 0.000
+ 4.07602e-06 1.800 4.09200e-06 1.800 4.09202e-06 0.000 4.09800e-06 0.000 4.09802e-06 1.800 4.10600e-06 1.800
+ 4.10602e-06 0.000 4.11200e-06 0.000 4.11202e-06 1.800 4.12200e-06 1.800 4.12202e-06 0.000 4.12800e-06 0.000
+ 4.12802e-06 1.800 4.13600e-06 1.800 4.13602e-06 0.000 4.14000e-06 0.000 4.14002e-06 1.800 4.14200e-06 1.800
+ 4.14202e-06 0.000 4.14600e-06 0.000 4.14602e-06 1.800 4.14800e-06 1.800 4.14802e-06 0.000 4.15400e-06 0.000
+ 4.15402e-06 1.800 4.15600e-06 1.800 4.15602e-06 0.000 4.16000e-06 0.000 4.16002e-06 1.800 4.17800e-06 1.800
+ 4.17802e-06 0.000 4.20600e-06 0.000 4.20602e-06 1.800 4.21800e-06 1.800 4.21802e-06 0.000 4.22000e-06 0.000
+ 4.22002e-06 1.800 4.22400e-06 1.800 4.22402e-06 0.000 4.22600e-06 0.000 4.22602e-06 1.800 4.23200e-06 1.800
+ 4.23202e-06 0.000 4.23400e-06 0.000 4.23402e-06 1.800 4.23800e-06 1.800 4.23802e-06 0.000 4.25600e-06 0.000
+ 4.25602e-06 1.800 4.28400e-06 1.800 4.28402e-06 0.000 4.30800e-06 0.000 4.30802e-06 1.800 4.32200e-06 1.800
+ 4.32202e-06 0.000 4.33800e-06 0.000 4.33802e-06 1.800 4.35200e-06 1.800 4.35202e-06 0.000 4.37000e-06 0.000
+ 4.37002e-06 1.800 4.38400e-06 1.800 4.38402e-06 0.000 4.40000e-06 0.000 4.40002e-06 1.800 4.41400e-06 1.800
+ 4.41402e-06 0.000 4.42000e-06 0.000 4.42002e-06 1.800 4.42800e-06 1.800 4.42802e-06 0.000 4.43400e-06 0.000
+ 4.43402e-06 1.800 4.44400e-06 1.800 4.44402e-06 0.000 4.45000e-06 0.000 4.45002e-06 1.800 4.45800e-06 1.800
+ 4.45802e-06 0.000 4.46200e-06 0.000 4.46202e-06 1.800 4.46400e-06 1.800 4.46402e-06 0.000 4.46800e-06 0.000
+ 4.46802e-06 1.800 4.47000e-06 1.800 4.47002e-06 0.000 4.47600e-06 0.000 4.47602e-06 1.800 4.47800e-06 1.800
+ 4.47802e-06 0.000 4.48200e-06 0.000 4.48202e-06 1.800 4.50000e-06 1.800 4.50002e-06 0.000 4.52800e-06 0.000
+ 4.52802e-06 1.800 4.54000e-06 1.800 4.54002e-06 0.000 4.54200e-06 0.000 4.54202e-06 1.800 4.54600e-06 1.800
+ 4.54602e-06 0.000 4.54800e-06 0.000 4.54802e-06 1.800 4.55400e-06 1.800 4.55402e-06 0.000 4.55600e-06 0.000
+ 4.55602e-06 1.800 4.56000e-06 1.800 4.56002e-06 0.000 4.57800e-06 0.000 4.57802e-06 1.800 4.60600e-06 1.800
+ 4.60602e-06 0.000 4.62200e-06 0.000 4.62202e-06 1.800 4.62800e-06 1.800 4.62802e-06 0.000 4.63600e-06 0.000
+ 4.63602e-06 1.800 4.64200e-06 1.800 4.64202e-06 0.000 4.65200e-06 0.000 4.65202e-06 1.800 4.65800e-06 1.800
+ 4.65802e-06 0.000 4.66600e-06 0.000 4.66602e-06 1.800 4.67000e-06 1.800 4.67002e-06 0.000 4.67200e-06 0.000
+ 4.67202e-06 1.800 4.67600e-06 1.800 4.67602e-06 0.000 4.67800e-06 0.000 4.67802e-06 1.800 4.68400e-06 1.800
+ 4.68402e-06 0.000 4.68600e-06 0.000 4.68602e-06 1.800 4.69000e-06 1.800 4.69002e-06 0.000 4.70800e-06 0.000
+ 4.70802e-06 1.800 4.73600e-06 1.800 4.73602e-06 0.000 4.74800e-06 0.000 4.74802e-06 1.800 4.75000e-06 1.800
+ 4.75002e-06 0.000 4.75400e-06 0.000 4.75402e-06 1.800 4.75600e-06 1.800 4.75602e-06 0.000 4.76200e-06 0.000
+ 4.76202e-06 1.800 4.76400e-06 1.800 4.76402e-06 0.000 4.76800e-06 0.000 4.76802e-06 1.800 4.78600e-06 1.800
+ 4.78602e-06 0.000 4.81400e-06 0.000 4.81402e-06 1.800 4.85400e-06 1.800 4.85402e-06 0.000 4.88400e-06 0.000
+ 4.88402e-06 1.800 4.91600e-06 1.800 4.91602e-06 0.000 4.94600e-06 0.000 4.94602e-06 1.800 4.98000e-06 1.800
+ 4.98002e-06 0.000 5.01000e-06 0.000 5.01002e-06 1.800 5.04200e-06 1.800 5.04202e-06 0.000 5.07800e-06 0.000
+ 5.07802e-06 1.800 5.09200e-06 1.800 5.09202e-06 0.000 5.10800e-06 0.000 5.10802e-06 1.800 5.12200e-06 1.800
+ 5.12202e-06 0.000 5.14000e-06 0.000 5.14002e-06 1.800 5.15400e-06 1.800 5.15402e-06 0.000 5.17000e-06 0.000
+ 5.17002e-06 1.800 5.18400e-06 1.800 5.18402e-06 0.000 5.19000e-06 0.000 5.19002e-06 1.800 5.19800e-06 1.800
+ 5.19802e-06 0.000 5.20400e-06 0.000 5.20402e-06 1.800 5.21400e-06 1.800 5.21402e-06 0.000 5.22000e-06 0.000
+ 5.22002e-06 1.800 5.22800e-06 1.800 5.22802e-06 0.000 5.23200e-06 0.000 5.23202e-06 1.800 5.23400e-06 1.800
+ 5.23402e-06 0.000 5.23800e-06 0.000 5.23802e-06 1.800 5.24000e-06 1.800 5.24002e-06 0.000 5.24600e-06 0.000
+ 5.24602e-06 1.800 5.24800e-06 1.800 5.24802e-06 0.000 5.25200e-06 0.000 5.25202e-06 1.800 5.27000e-06 1.800
+ 5.27002e-06 0.000 5.29800e-06 0.000 5.29802e-06 1.800 5.31000e-06 1.800 5.31002e-06 0.000 5.31200e-06 0.000
+ 5.31202e-06 1.800 5.31600e-06 1.800 5.31602e-06 0.000 5.31800e-06 0.000 5.31802e-06 1.800 5.32400e-06 1.800
+ 5.32402e-06 0.000 5.32600e-06 0.000 5.32602e-06 1.800 5.33000e-06 1.800 5.33002e-06 0.000 5.34800e-06 0.000
+ 5.34802e-06 1.800 5.37600e-06 1.800 5.37602e-06 0.000 5.39200e-06 0.000 5.39202e-06 1.800 5.39800e-06 1.800
+ 5.39802e-06 0.000 5.40600e-06 0.000 5.40602e-06 1.800 5.41200e-06 1.800 5.41202e-06 0.000 5.42200e-06 0.000
+ 5.42202e-06 1.800 5.42800e-06 1.800 5.42802e-06 0.000 5.43600e-06 0.000 5.43602e-06 1.800 5.44000e-06 1.800
+ 5.44002e-06 0.000 5.44200e-06 0.000 5.44202e-06 1.800 5.44600e-06 1.800 5.44602e-06 0.000 5.44800e-06 0.000
+ 5.44802e-06 1.800 5.45400e-06 1.800 5.45402e-06 0.000 5.45600e-06 0.000 5.45602e-06 1.800 5.46000e-06 1.800
+ 5.46002e-06 0.000 5.47800e-06 0.000 5.47802e-06 1.800 5.50600e-06 1.800 5.50602e-06 0.000 5.51800e-06 0.000
+ 5.51802e-06 1.800 5.52000e-06 1.800 5.52002e-06 0.000 5.52400e-06 0.000 5.52402e-06 1.800 5.52600e-06 1.800
+ 5.52602e-06 0.000 5.53200e-06 0.000 5.53202e-06 1.800 5.53400e-06 1.800 5.53402e-06 0.000 5.53800e-06 0.000
+ 5.53802e-06 1.800 5.55600e-06 1.800 5.55602e-06 0.000 5.58400e-06 0.000 5.58402e-06 1.800 5.60800e-06 1.800
+ 5.60802e-06 0.000 5.62200e-06 0.000 5.62202e-06 1.800 5.63800e-06 1.800 5.63802e-06 0.000 5.65200e-06 0.000
+ 5.65202e-06 1.800 5.67000e-06 1.800 5.67002e-06 0.000 5.68400e-06 0.000 5.68402e-06 1.800 5.70000e-06 1.800
+ 5.70002e-06 0.000 5.71400e-06 0.000 5.71402e-06 1.800 5.72000e-06 1.800 5.72002e-06 0.000 5.72800e-06 0.000
+ 5.72802e-06 1.800 5.73400e-06 1.800 5.73402e-06 0.000 5.74400e-06 0.000 5.74402e-06 1.800 5.75000e-06 1.800
+ 5.75002e-06 0.000 5.75800e-06 0.000 5.75802e-06 1.800 5.76200e-06 1.800 5.76202e-06 0.000 5.76400e-06 0.000
+ 5.76402e-06 1.800 5.76800e-06 1.800 5.76802e-06 0.000 5.77000e-06 0.000 5.77002e-06 1.800 5.77600e-06 1.800
+ 5.77602e-06 0.000 5.77800e-06 0.000 5.77802e-06 1.800 5.78200e-06 1.800 5.78202e-06 0.000 5.80000e-06 0.000
+ 5.80002e-06 1.800 5.82800e-06 1.800 5.82802e-06 0.000 5.84000e-06 0.000 5.84002e-06 1.800 5.84200e-06 1.800
+ 5.84202e-06 0.000 5.84600e-06 0.000 5.84602e-06 1.800 5.84800e-06 1.800 5.84802e-06 0.000 5.85400e-06 0.000
+ 5.85402e-06 1.800 5.85600e-06 1.800 5.85602e-06 0.000 5.86000e-06 0.000 5.86002e-06 1.800 5.87800e-06 1.800
+ 5.87802e-06 0.000 5.90600e-06 0.000 5.90602e-06 1.800 5.92200e-06 1.800 5.92202e-06 0.000 5.92800e-06 0.000
+ 5.92802e-06 1.800 5.93600e-06 1.800 5.93602e-06 0.000 5.94200e-06 0.000 5.94202e-06 1.800 5.95200e-06 1.800
+ 5.95202e-06 0.000 5.95800e-06 0.000 5.95802e-06 1.800 5.96600e-06 1.800 5.96602e-06 0.000 5.97000e-06 0.000
+ 5.97002e-06 1.800 5.97200e-06 1.800 5.97202e-06 0.000 5.97600e-06 0.000 5.97602e-06 1.800 5.97800e-06 1.800
+ 5.97802e-06 0.000 5.98400e-06 0.000 5.98402e-06 1.800 5.98600e-06 1.800 5.98602e-06 0.000 5.99000e-06 0.000
+ 5.99002e-06 1.800 6.00800e-06 1.800 6.00802e-06 0.000 6.03600e-06 0.000 6.03602e-06 1.800 6.04800e-06 1.800
+ 6.04802e-06 0.000 6.05000e-06 0.000 6.05002e-06 1.800 6.05400e-06 1.800 6.05402e-06 0.000 6.05600e-06 0.000
+ 6.05602e-06 1.800 6.06200e-06 1.800 6.06202e-06 0.000 6.06400e-06 0.000 6.06402e-06 1.800 6.06800e-06 1.800
+ 6.06802e-06 0.000 6.08600e-06 0.000 6.08602e-06 1.800 6.11400e-06 1.800 6.11402e-06 0.000 6.18600e-06 0.000
+ 6.18602e-06 1.800 6.24800e-06 1.800 6.24802e-06 0.000 6.31200e-06 0.000 6.31202e-06 1.800 6.37400e-06 1.800
+ 6.37402e-06 0.000 6.44000e-06 0.000 6.44002e-06 1.800 6.50200e-06 1.800 6.50202e-06 0.000 6.56600e-06 0.000
+ 6.56602e-06 1.800 6.64800e-06 1.800 6.64802e-06 0.000 6.67800e-06 0.000 6.67802e-06 1.800 6.71000e-06 1.800
+ 6.71002e-06 0.000 6.74000e-06 0.000 6.74002e-06 1.800 6.77400e-06 1.800 6.77402e-06 0.000 6.80400e-06 0.000
+ 6.80402e-06 1.800 6.83600e-06 1.800 6.83602e-06 0.000 6.87200e-06 0.000 6.87202e-06 1.800 6.88600e-06 1.800
+ 6.88602e-06 0.000 6.90200e-06 0.000 6.90202e-06 1.800 6.91600e-06 1.800 6.91602e-06 0.000 6.93400e-06 0.000
+ 6.93402e-06 1.800 6.94800e-06 1.800 6.94802e-06 0.000 6.96400e-06 0.000 6.96402e-06 1.800 6.97800e-06 1.800
+ 6.97802e-06 0.000 6.98400e-06 0.000 6.98402e-06 1.800 6.99200e-06 1.800 6.99202e-06 0.000 6.99800e-06 0.000
+ 6.99802e-06 1.800 7.00800e-06 1.800 7.00802e-06 0.000 7.01400e-06 0.000 7.01402e-06 1.800 7.02200e-06 1.800
+ 7.02202e-06 0.000 7.02600e-06 0.000 7.02602e-06 1.800 7.02800e-06 1.800 7.02802e-06 0.000 7.03200e-06 0.000
+ 7.03202e-06 1.800 7.03400e-06 1.800 7.03402e-06 0.000 7.04000e-06 0.000 7.04002e-06 1.800 7.04200e-06 1.800
+ 7.04202e-06 0.000 7.04600e-06 0.000 7.04602e-06 1.800 7.06400e-06 1.800 7.06402e-06 0.000 7.09200e-06 0.000
+ 7.09202e-06 1.800 7.10400e-06 1.800 7.10402e-06 0.000 7.10600e-06 0.000 7.10602e-06 1.800 7.11000e-06 1.800
+ 7.11002e-06 0.000 7.11200e-06 0.000 7.11202e-06 1.800 7.11800e-06 1.800 7.11802e-06 0.000 7.12000e-06 0.000
+ 7.12002e-06 1.800 7.12400e-06 1.800 7.12402e-06 0.000 7.14200e-06 0.000 7.14202e-06 1.800 7.17000e-06 1.800
+ 7.17002e-06 0.000 7.18600e-06 0.000 7.18602e-06 1.800 7.19200e-06 1.800 7.19202e-06 0.000 7.20000e-06 0.000
+ 7.20002e-06 1.800 7.20600e-06 1.800 7.20602e-06 0.000 7.21600e-06 0.000 7.21602e-06 1.800 7.22200e-06 1.800
+ 7.22202e-06 0.000 7.23000e-06 0.000 7.23002e-06 1.800 7.23400e-06 1.800 7.23402e-06 0.000 7.23600e-06 0.000
+ 7.23602e-06 1.800 7.24000e-06 1.800 7.24002e-06 0.000 7.24200e-06 0.000 7.24202e-06 1.800 7.24800e-06 1.800
+ 7.24802e-06 0.000 7.25000e-06 0.000 7.25002e-06 1.800 7.25400e-06 1.800 7.25402e-06 0.000 7.27200e-06 0.000
+ 7.27202e-06 1.800 7.30000e-06 1.800 7.30002e-06 0.000 7.31200e-06 0.000 7.31202e-06 1.800 7.31400e-06 1.800
+ 7.31402e-06 0.000 7.31800e-06 0.000 7.31802e-06 1.800 7.32000e-06 1.800 7.32002e-06 0.000 7.32600e-06 0.000
+ 7.32602e-06 1.800 7.32800e-06 1.800 7.32802e-06 0.000 7.33200e-06 0.000 7.33202e-06 1.800 7.35000e-06 1.800
+ 7.35002e-06 0.000 7.37800e-06 0.000 7.37802e-06 1.800 7.40200e-06 1.800 7.40202e-06 0.000 7.41600e-06 0.000
+ 7.41602e-06 1.800 7.43200e-06 1.800 7.43202e-06 0.000 7.44600e-06 0.000 7.44602e-06 1.800 7.46400e-06 1.800
+ 7.46402e-06 0.000 7.47800e-06 0.000 7.47802e-06 1.800 7.49400e-06 1.800 7.49402e-06 0.000 7.50800e-06 0.000
+ 7.50802e-06 1.800 7.51400e-06 1.800 7.51402e-06 0.000 7.52200e-06 0.000 7.52202e-06 1.800 7.52800e-06 1.800
+ 7.52802e-06 0.000 7.53800e-06 0.000 7.53802e-06 1.800 7.54400e-06 1.800 7.54402e-06 0.000 7.55200e-06 0.000
+ 7.55202e-06 1.800 7.55600e-06 1.800 7.55602e-06 0.000 7.55800e-06 0.000 7.55802e-06 1.800 7.56200e-06 1.800
+ 7.56202e-06 0.000 7.56400e-06 0.000 7.56402e-06 1.800 7.57000e-06 1.800 7.57002e-06 0.000 7.57200e-06 0.000
+ 7.57202e-06 1.800 7.57600e-06 1.800 7.57602e-06 0.000 7.59400e-06 0.000 7.59402e-06 1.800 7.62200e-06 1.800
+ 7.62202e-06 0.000 7.63400e-06 0.000 7.63402e-06 1.800 7.63600e-06 1.800 7.63602e-06 0.000 7.64000e-06 0.000
+ 7.64002e-06 1.800 7.64200e-06 1.800 7.64202e-06 0.000 7.64800e-06 0.000 7.64802e-06 1.800 7.65000e-06 1.800
+ 7.65002e-06 0.000 7.65400e-06 0.000 7.65402e-06 1.800 7.67200e-06 1.800 7.67202e-06 0.000 7.70000e-06 0.000
+ 7.70002e-06 1.800 7.71600e-06 1.800 7.71602e-06 0.000 7.72200e-06 0.000 7.72202e-06 1.800 7.73000e-06 1.800
+ 7.73002e-06 0.000 7.73600e-06 0.000 7.73602e-06 1.800 7.74600e-06 1.800 7.74602e-06 0.000 7.75200e-06 0.000
+ 7.75202e-06 1.800 7.76000e-06 1.800 7.76002e-06 0.000 7.76400e-06 0.000 7.76402e-06 1.800 7.76600e-06 1.800
+ 7.76602e-06 0.000 7.77000e-06 0.000 7.77002e-06 1.800 7.77200e-06 1.800 7.77202e-06 0.000 7.77800e-06 0.000
+ 7.77802e-06 1.800 7.78000e-06 1.800 7.78002e-06 0.000 7.78400e-06 0.000 7.78402e-06 1.800 7.80200e-06 1.800
+ 7.80202e-06 0.000 7.83000e-06 0.000 7.83002e-06 1.800 7.84200e-06 1.800 7.84202e-06 0.000 7.84400e-06 0.000
+ 7.84402e-06 1.800 7.84800e-06 1.800 7.84802e-06 0.000 7.85000e-06 0.000 7.85002e-06 1.800 7.85600e-06 1.800
+ 7.85602e-06 0.000 7.85800e-06 0.000 7.85802e-06 1.800 7.86200e-06 1.800 7.86202e-06 0.000 7.88000e-06 0.000
+ 7.88002e-06 1.800 7.90800e-06 1.800 7.90802e-06 0.000 7.94800e-06 0.000 7.94802e-06 1.800 7.97800e-06 1.800
+ 7.97802e-06 0.000 8.01000e-06 0.000 8.01002e-06 1.800 8.04000e-06 1.800 8.04002e-06 0.000 8.07400e-06 0.000
+ 8.07402e-06 1.800 8.10400e-06 1.800 8.10402e-06 0.000 8.13600e-06 0.000 8.13602e-06 1.800 8.17200e-06 1.800
+ 8.17202e-06 0.000 8.18600e-06 0.000 8.18602e-06 1.800 8.20200e-06 1.800 8.20202e-06 0.000 8.21600e-06 0.000
+ 8.21602e-06 1.800 8.23400e-06 1.800 8.23402e-06 0.000 8.24800e-06 0.000 8.24802e-06 1.800 8.26400e-06 1.800
+ 8.26402e-06 0.000 8.27800e-06 0.000 8.27802e-06 1.800 8.28400e-06 1.800 8.28402e-06 0.000 8.29200e-06 0.000
+ 8.29202e-06 1.800 8.29800e-06 1.800 8.29802e-06 0.000 8.30800e-06 0.000 8.30802e-06 1.800 8.31400e-06 1.800
+ 8.31402e-06 0.000 8.32200e-06 0.000 8.32202e-06 1.800 8.32600e-06 1.800 8.32602e-06 0.000 8.32800e-06 0.000
+ 8.32802e-06 1.800 8.33200e-06 1.800 8.33202e-06 0.000 8.33400e-06 0.000 8.33402e-06 1.800 8.34000e-06 1.800
+ 8.34002e-06 0.000 8.34200e-06 0.000 8.34202e-06 1.800 8.34600e-06 1.800 8.34602e-06 0.000 8.36400e-06 0.000
+ 8.36402e-06 1.800 8.39200e-06 1.800 8.39202e-06 0.000 8.40400e-06 0.000 8.40402e-06 1.800 8.40600e-06 1.800
+ 8.40602e-06 0.000 8.41000e-06 0.000 8.41002e-06 1.800 8.41200e-06 1.800 8.41202e-06 0.000 8.41800e-06 0.000
+ 8.41802e-06 1.800 8.42000e-06 1.800 8.42002e-06 0.000 8.42400e-06 0.000 8.42402e-06 1.800 8.44200e-06 1.800
+ 8.44202e-06 0.000 8.47000e-06 0.000 8.47002e-06 1.800 8.48600e-06 1.800 8.48602e-06 0.000 8.49200e-06 0.000
+ 8.49202e-06 1.800 8.50000e-06 1.800 8.50002e-06 0.000 8.50600e-06 0.000 8.50602e-06 1.800 8.51600e-06 1.800
+ 8.51602e-06 0.000 8.52200e-06 0.000 8.52202e-06 1.800 8.53000e-06 1.800 8.53002e-06 0.000 8.53400e-06 0.000
+ 8.53402e-06 1.800 8.53600e-06 1.800 8.53602e-06 0.000 8.54000e-06 0.000 8.54002e-06 1.800 8.54200e-06 1.800
+ 8.54202e-06 0.000 8.54800e-06 0.000 8.54802e-06 1.800 8.55000e-06 1.800 8.55002e-06 0.000 8.55400e-06 0.000
+ 8.55402e-06 1.800 8.57200e-06 1.800 8.57202e-06 0.000 8.60000e-06 0.000 8.60002e-06 1.800 8.61200e-06 1.800
+ 8.61202e-06 0.000 8.61400e-06 0.000 8.61402e-06 1.800 8.61800e-06 1.800 8.61802e-06 0.000 8.62000e-06 0.000
+ 8.62002e-06 1.800 8.62600e-06 1.800 8.62602e-06 0.000 8.62800e-06 0.000 8.62802e-06 1.800 8.63200e-06 1.800
+ 8.63202e-06 0.000 8.65000e-06 0.000 8.65002e-06 1.800 8.67800e-06 1.800 8.67802e-06 0.000 8.70200e-06 0.000
+ 8.70202e-06 1.800 8.71600e-06 1.800 8.71602e-06 0.000 8.73200e-06 0.000 8.73202e-06 1.800 8.74600e-06 1.800
+ 8.74602e-06 0.000 8.76400e-06 0.000 8.76402e-06 1.800 8.77800e-06 1.800 8.77802e-06 0.000 8.79400e-06 0.000
+ 8.79402e-06 1.800 8.80800e-06 1.800 8.80802e-06 0.000 8.81400e-06 0.000 8.81402e-06 1.800 8.82200e-06 1.800
+ 8.82202e-06 0.000 8.82800e-06 0.000 8.82802e-06 1.800 8.83800e-06 1.800 8.83802e-06 0.000 8.84400e-06 0.000
+ 8.84402e-06 1.800 8.85200e-06 1.800 8.85202e-06 0.000 8.85600e-06 0.000 8.85602e-06 1.800 8.85800e-06 1.800
+ 8.85802e-06 0.000 8.86200e-06 0.000 8.86202e-06 1.800 8.86400e-06 1.800 8.86402e-06 0.000 8.87000e-06 0.000
+ 8.87002e-06 1.800 8.87200e-06 1.800 8.87202e-06 0.000 8.87600e-06 0.000 8.87602e-06 1.800 8.89400e-06 1.800
+ 8.89402e-06 0.000 8.92200e-06 0.000 8.92202e-06 1.800 8.93400e-06 1.800 8.93402e-06 0.000 8.93600e-06 0.000
+ 8.93602e-06 1.800 8.94000e-06 1.800 8.94002e-06 0.000 8.94200e-06 0.000 8.94202e-06 1.800 8.94800e-06 1.800
+ 8.94802e-06 0.000 8.95000e-06 0.000 8.95002e-06 1.800 8.95400e-06 1.800 8.95402e-06 0.000 8.97200e-06 0.000
+ 8.97202e-06 1.800 9.00000e-06 1.800 9.00002e-06 0.000 9.01600e-06 0.000 9.01602e-06 1.800 9.02200e-06 1.800
+ 9.02202e-06 0.000 9.03000e-06 0.000 9.03002e-06 1.800 9.03600e-06 1.800 9.03602e-06 0.000 9.04600e-06 0.000
+ 9.04602e-06 1.800 9.05200e-06 1.800 9.05202e-06 0.000 9.06000e-06 0.000 9.06002e-06 1.800 9.06400e-06 1.800
+ 9.06402e-06 0.000 9.06600e-06 0.000 9.06602e-06 1.800 9.07000e-06 1.800 9.07002e-06 0.000 9.07200e-06 0.000
+ 9.07202e-06 1.800 9.07800e-06 1.800 9.07802e-06 0.000 9.08000e-06 0.000 9.08002e-06 1.800 9.08400e-06 1.800
+ 9.08402e-06 0.000 9.10200e-06 0.000 9.10202e-06 1.800 9.13000e-06 1.800 9.13002e-06 0.000 9.14200e-06 0.000
+ 9.14202e-06 1.800 9.14400e-06 1.800 9.14402e-06 0.000 9.14800e-06 0.000 9.14802e-06 1.800 9.15000e-06 1.800
+ 9.15002e-06 0.000 9.15600e-06 0.000 9.15602e-06 1.800 9.15800e-06 1.800 9.15802e-06 0.000 9.16200e-06 0.000
+ 9.16202e-06 1.800 9.18000e-06 1.800 9.18002e-06 0.000 9.20800e-06 0.000 9.20802e-06 1.800 9.21800e-06 1.800
+ )
Xd_t1b src_t1b t1b vdd gnd tb_x1
Vt2b src_t2b gnd PWL(
+ 0.00000e+00 1.800 5.10000e-07 1.800 5.10020e-07 0.000 1.02000e-06 0.000 1.02002e-06 1.800 1.53200e-06 1.800
+ 1.53202e-06 0.000 2.28000e-06 0.000 2.28002e-06 1.800 2.53400e-06 1.800 2.53402e-06 0.000 2.79000e-06 0.000
+ 2.79002e-06 1.800 3.15600e-06 1.800 3.15602e-06 0.000 3.28200e-06 0.000 3.28202e-06 1.800 3.41000e-06 1.800
+ 3.41002e-06 0.000 3.58600e-06 0.000 3.58602e-06 1.800 3.64800e-06 1.800 3.64802e-06 0.000 3.71200e-06 0.000
+ 3.71202e-06 1.800 3.79400e-06 1.800 3.79402e-06 0.000 3.82400e-06 0.000 3.82402e-06 1.800 3.85600e-06 1.800
+ 3.85602e-06 0.000 3.89200e-06 0.000 3.89202e-06 1.800 3.90600e-06 1.800 3.90602e-06 0.000 3.92200e-06 0.000
+ 3.92202e-06 1.800 3.93600e-06 1.800 3.93602e-06 0.000 3.94200e-06 0.000 3.94202e-06 1.800 3.95000e-06 1.800
+ 3.95002e-06 0.000 3.95400e-06 0.000 3.95402e-06 1.800 3.95600e-06 1.800 3.95602e-06 0.000 3.96000e-06 0.000
+ 3.96002e-06 1.800 3.96600e-06 1.800 3.96602e-06 0.000 3.97600e-06 0.000 3.97602e-06 1.800 3.98200e-06 1.800
+ 3.98202e-06 0.000 3.98400e-06 0.000 3.98402e-06 1.800 3.98800e-06 1.800 3.98802e-06 0.000 3.99400e-06 0.000
+ 3.99402e-06 1.800 4.00400e-06 1.800 4.00402e-06 0.000 4.01400e-06 0.000 4.01402e-06 1.800 4.02000e-06 1.800
+ 4.02002e-06 0.000 4.02800e-06 0.000 4.02802e-06 1.800 4.03200e-06 1.800 4.03202e-06 0.000 4.03400e-06 0.000
+ 4.03402e-06 1.800 4.03800e-06 1.800 4.03802e-06 0.000 4.04400e-06 0.000 4.04402e-06 1.800 4.05400e-06 1.800
+ 4.05402e-06 0.000 4.06000e-06 0.000 4.06002e-06 1.800 4.06200e-06 1.800 4.06202e-06 0.000 4.06600e-06 0.000
+ 4.06602e-06 1.800 4.07200e-06 1.800 4.07202e-06 0.000 4.08200e-06 0.000 4.08202e-06 1.800 4.10000e-06 1.800
+ 4.10002e-06 0.000 4.11400e-06 0.000 4.11402e-06 1.800 4.13000e-06 1.800 4.13002e-06 0.000 4.14400e-06 0.000
+ 4.14402e-06 1.800 4.15000e-06 1.800 4.15002e-06 0.000 4.15800e-06 0.000 4.15802e-06 1.800 4.16200e-06 1.800
+ 4.16202e-06 0.000 4.16400e-06 0.000 4.16402e-06 1.800 4.16800e-06 1.800 4.16802e-06 0.000 4.17400e-06 0.000
+ 4.17402e-06 1.800 4.18400e-06 1.800 4.18402e-06 0.000 4.19000e-06 0.000 4.19002e-06 1.800 4.19200e-06 1.800
+ 4.19202e-06 0.000 4.19600e-06 0.000 4.19602e-06 1.800 4.20200e-06 1.800 4.20202e-06 0.000 4.21200e-06 0.000
+ 4.21202e-06 1.800 4.22200e-06 1.800 4.22202e-06 0.000 4.22800e-06 0.000 4.22802e-06 1.800 4.23600e-06 1.800
+ 4.23602e-06 0.000 4.24000e-06 0.000 4.24002e-06 1.800 4.24200e-06 1.800 4.24202e-06 0.000 4.24600e-06 0.000
+ 4.24602e-06 1.800 4.25200e-06 1.800 4.25202e-06 0.000 4.26200e-06 0.000 4.26202e-06 1.800 4.26800e-06 1.800
+ 4.26802e-06 0.000 4.27000e-06 0.000 4.27002e-06 1.800 4.27400e-06 1.800 4.27402e-06 0.000 4.28000e-06 0.000
+ 4.28002e-06 1.800 4.29000e-06 1.800 4.29002e-06 0.000 4.32400e-06 0.000 4.32402e-06 1.800 4.35400e-06 1.800
+ 4.35402e-06 0.000 4.38600e-06 0.000 4.38602e-06 1.800 4.42200e-06 1.800 4.42202e-06 0.000 4.43600e-06 0.000
+ 4.43602e-06 1.800 4.45200e-06 1.800 4.45202e-06 0.000 4.46600e-06 0.000 4.46602e-06 1.800 4.47200e-06 1.800
+ 4.47202e-06 0.000 4.48000e-06 0.000 4.48002e-06 1.800 4.48400e-06 1.800 4.48402e-06 0.000 4.48600e-06 0.000
+ 4.48602e-06 1.800 4.49000e-06 1.800 4.49002e-06 0.000 4.49600e-06 0.000 4.49602e-06 1.800 4.50600e-06 1.800
+ 4.50602e-06 0.000 4.51200e-06 0.000 4.51202e-06 1.800 4.51400e-06 1.800 4.51402e-06 0.000 4.51800e-06 0.000
+ 4.51802e-06 1.800 4.52400e-06 1.800 4.52402e-06 0.000 4.53400e-06 0.000 4.53402e-06 1.800 4.54400e-06 1.800
+ 4.54402e-06 0.000 4.55000e-06 0.000 4.55002e-06 1.800 4.55800e-06 1.800 4.55802e-06 0.000 4.56200e-06 0.000
+ 4.56202e-06 1.800 4.56400e-06 1.800 4.56402e-06 0.000 4.56800e-06 0.000 4.56802e-06 1.800 4.57400e-06 1.800
+ 4.57402e-06 0.000 4.58400e-06 0.000 4.58402e-06 1.800 4.59000e-06 1.800 4.59002e-06 0.000 4.59200e-06 0.000
+ 4.59202e-06 1.800 4.59600e-06 1.800 4.59602e-06 0.000 4.60200e-06 0.000 4.60202e-06 1.800 4.61200e-06 1.800
+ 4.61202e-06 0.000 4.63000e-06 0.000 4.63002e-06 1.800 4.64400e-06 1.800 4.64402e-06 0.000 4.66000e-06 0.000
+ 4.66002e-06 1.800 4.67400e-06 1.800 4.67402e-06 0.000 4.68000e-06 0.000 4.68002e-06 1.800 4.68800e-06 1.800
+ 4.68802e-06 0.000 4.69200e-06 0.000 4.69202e-06 1.800 4.69400e-06 1.800 4.69402e-06 0.000 4.69800e-06 0.000
+ 4.69802e-06 1.800 4.70400e-06 1.800 4.70402e-06 0.000 4.71400e-06 0.000 4.71402e-06 1.800 4.72000e-06 1.800
+ 4.72002e-06 0.000 4.72200e-06 0.000 4.72202e-06 1.800 4.72600e-06 1.800 4.72602e-06 0.000 4.73200e-06 0.000
+ 4.73202e-06 1.800 4.74200e-06 1.800 4.74202e-06 0.000 4.75200e-06 0.000 4.75202e-06 1.800 4.75800e-06 1.800
+ 4.75802e-06 0.000 4.76600e-06 0.000 4.76602e-06 1.800 4.77000e-06 1.800 4.77002e-06 0.000 4.77200e-06 0.000
+ 4.77202e-06 1.800 4.77600e-06 1.800 4.77602e-06 0.000 4.78200e-06 0.000 4.78202e-06 1.800 4.79200e-06 1.800
+ 4.79202e-06 0.000 4.79800e-06 0.000 4.79802e-06 1.800 4.80000e-06 1.800 4.80002e-06 0.000 4.80400e-06 0.000
+ 4.80402e-06 1.800 4.81000e-06 1.800 4.81002e-06 0.000 4.82000e-06 0.000 4.82002e-06 1.800 4.88600e-06 1.800
+ 4.88602e-06 0.000 4.94800e-06 0.000 4.94802e-06 1.800 5.01200e-06 1.800 5.01202e-06 0.000 5.09400e-06 0.000
+ 5.09402e-06 1.800 5.12400e-06 1.800 5.12402e-06 0.000 5.15600e-06 0.000 5.15602e-06 1.800 5.19200e-06 1.800
+ 5.19202e-06 0.000 5.20600e-06 0.000 5.20602e-06 1.800 5.22200e-06 1.800 5.22202e-06 0.000 5.23600e-06 0.000
+ 5.23602e-06 1.800 5.24200e-06 1.800 5.24202e-06 0.000 5.25000e-06 0.000 5.25002e-06 1.800 5.25400e-06 1.800
+ 5.25402e-06 0.000 5.25600e-06 0.000 5.25602e-06 1.800 5.26000e-06 1.800 5.26002e-06 0.000 5.26600e-06 0.000
+ 5.26602e-06 1.800 5.27600e-06 1.800 5.27602e-06 0.000 5.28200e-06 0.000 5.28202e-06 1.800 5.28400e-06 1.800
+ 5.28402e-06 0.000 5.28800e-06 0.000 5.28802e-06 1.800 5.29400e-06 1.800 5.29402e-06 0.000 5.30400e-06 0.000
+ 5.30402e-06 1.800 5.31400e-06 1.800 5.31402e-06 0.000 5.32000e-06 0.000 5.32002e-06 1.800 5.32800e-06 1.800
+ 5.32802e-06 0.000 5.33200e-06 0.000 5.33202e-06 1.800 5.33400e-06 1.800 5.33402e-06 0.000 5.33800e-06 0.000
+ 5.33802e-06 1.800 5.34400e-06 1.800 5.34402e-06 0.000 5.35400e-06 0.000 5.35402e-06 1.800 5.36000e-06 1.800
+ 5.36002e-06 0.000 5.36200e-06 0.000 5.36202e-06 1.800 5.36600e-06 1.800 5.36602e-06 0.000 5.37200e-06 0.000
+ 5.37202e-06 1.800 5.38200e-06 1.800 5.38202e-06 0.000 5.40000e-06 0.000 5.40002e-06 1.800 5.41400e-06 1.800
+ 5.41402e-06 0.000 5.43000e-06 0.000 5.43002e-06 1.800 5.44400e-06 1.800 5.44402e-06 0.000 5.45000e-06 0.000
+ 5.45002e-06 1.800 5.45800e-06 1.800 5.45802e-06 0.000 5.46200e-06 0.000 5.46202e-06 1.800 5.46400e-06 1.800
+ 5.46402e-06 0.000 5.46800e-06 0.000 5.46802e-06 1.800 5.47400e-06 1.800 5.47402e-06 0.000 5.48400e-06 0.000
+ 5.48402e-06 1.800 5.49000e-06 1.800 5.49002e-06 0.000 5.49200e-06 0.000 5.49202e-06 1.800 5.49600e-06 1.800
+ 5.49602e-06 0.000 5.50200e-06 0.000 5.50202e-06 1.800 5.51200e-06 1.800 5.51202e-06 0.000 5.52200e-06 0.000
+ 5.52202e-06 1.800 5.52800e-06 1.800 5.52802e-06 0.000 5.53600e-06 0.000 5.53602e-06 1.800 5.54000e-06 1.800
+ 5.54002e-06 0.000 5.54200e-06 0.000 5.54202e-06 1.800 5.54600e-06 1.800 5.54602e-06 0.000 5.55200e-06 0.000
+ 5.55202e-06 1.800 5.56200e-06 1.800 5.56202e-06 0.000 5.56800e-06 0.000 5.56802e-06 1.800 5.57000e-06 1.800
+ 5.57002e-06 0.000 5.57400e-06 0.000 5.57402e-06 1.800 5.58000e-06 1.800 5.58002e-06 0.000 5.59000e-06 0.000
+ 5.59002e-06 1.800 5.62400e-06 1.800 5.62402e-06 0.000 5.65400e-06 0.000 5.65402e-06 1.800 5.68600e-06 1.800
+ 5.68602e-06 0.000 5.72200e-06 0.000 5.72202e-06 1.800 5.73600e-06 1.800 5.73602e-06 0.000 5.75200e-06 0.000
+ 5.75202e-06 1.800 5.76600e-06 1.800 5.76602e-06 0.000 5.77200e-06 0.000 5.77202e-06 1.800 5.78000e-06 1.800
+ 5.78002e-06 0.000 5.78400e-06 0.000 5.78402e-06 1.800 5.78600e-06 1.800 5.78602e-06 0.000 5.79000e-06 0.000
+ 5.79002e-06 1.800 5.79600e-06 1.800 5.79602e-06 0.000 5.80600e-06 0.000 5.80602e-06 1.800 5.81200e-06 1.800
+ 5.81202e-06 0.000 5.81400e-06 0.000 5.81402e-06 1.800 5.81800e-06 1.800 5.81802e-06 0.000 5.82400e-06 0.000
+ 5.82402e-06 1.800 5.83400e-06 1.800 5.83402e-06 0.000 5.84400e-06 0.000 5.84402e-06 1.800 5.85000e-06 1.800
+ 5.85002e-06 0.000 5.85800e-06 0.000 5.85802e-06 1.800 5.86200e-06 1.800 5.86202e-06 0.000 5.86400e-06 0.000
+ 5.86402e-06 1.800 5.86800e-06 1.800 5.86802e-06 0.000 5.87400e-06 0.000 5.87402e-06 1.800 5.88400e-06 1.800
+ 5.88402e-06 0.000 5.89000e-06 0.000 5.89002e-06 1.800 5.89200e-06 1.800 5.89202e-06 0.000 5.89600e-06 0.000
+ 5.89602e-06 1.800 5.90200e-06 1.800 5.90202e-06 0.000 5.91200e-06 0.000 5.91202e-06 1.800 5.93000e-06 1.800
+ 5.93002e-06 0.000 5.94400e-06 0.000 5.94402e-06 1.800 5.96000e-06 1.800 5.96002e-06 0.000 5.97400e-06 0.000
+ 5.97402e-06 1.800 5.98000e-06 1.800 5.98002e-06 0.000 5.98800e-06 0.000 5.98802e-06 1.800 5.99200e-06 1.800
+ 5.99202e-06 0.000 5.99400e-06 0.000 5.99402e-06 1.800 5.99800e-06 1.800 5.99802e-06 0.000 6.00400e-06 0.000
+ 6.00402e-06 1.800 6.01400e-06 1.800 6.01402e-06 0.000 6.02000e-06 0.000 6.02002e-06 1.800 6.02200e-06 1.800
+ 6.02202e-06 0.000 6.02600e-06 0.000 6.02602e-06 1.800 6.03200e-06 1.800 6.03202e-06 0.000 6.04200e-06 0.000
+ 6.04202e-06 1.800 6.05200e-06 1.800 6.05202e-06 0.000 6.05800e-06 0.000 6.05802e-06 1.800 6.06600e-06 1.800
+ 6.06602e-06 0.000 6.07000e-06 0.000 6.07002e-06 1.800 6.07200e-06 1.800 6.07202e-06 0.000 6.07600e-06 0.000
+ 6.07602e-06 1.800 6.08200e-06 1.800 6.08202e-06 0.000 6.09200e-06 0.000 6.09202e-06 1.800 6.09800e-06 1.800
+ 6.09802e-06 0.000 6.10000e-06 0.000 6.10002e-06 1.800 6.10400e-06 1.800 6.10402e-06 0.000 6.11000e-06 0.000
+ 6.11002e-06 1.800 6.12000e-06 1.800 6.12002e-06 0.000 6.25000e-06 0.000 6.25002e-06 1.800 6.37600e-06 1.800
+ 6.37602e-06 0.000 6.50400e-06 0.000 6.50402e-06 1.800 6.68000e-06 1.800 6.68002e-06 0.000 6.74200e-06 0.000
+ 6.74202e-06 1.800 6.80600e-06 1.800 6.80602e-06 0.000 6.88800e-06 0.000 6.88802e-06 1.800 6.91800e-06 1.800
+ 6.91802e-06 0.000 6.95000e-06 0.000 6.95002e-06 1.800 6.98600e-06 1.800 6.98602e-06 0.000 7.00000e-06 0.000
+ 7.00002e-06 1.800 7.01600e-06 1.800 7.01602e-06 0.000 7.03000e-06 0.000 7.03002e-06 1.800 7.03600e-06 1.800
+ 7.03602e-06 0.000 7.04400e-06 0.000 7.04402e-06 1.800 7.04800e-06 1.800 7.04802e-06 0.000 7.05000e-06 0.000
+ 7.05002e-06 1.800 7.05400e-06 1.800 7.05402e-06 0.000 7.06000e-06 0.000 7.06002e-06 1.800 7.07000e-06 1.800
+ 7.07002e-06 0.000 7.07600e-06 0.000 7.07602e-06 1.800 7.07800e-06 1.800 7.07802e-06 0.000 7.08200e-06 0.000
+ 7.08202e-06 1.800 7.08800e-06 1.800 7.08802e-06 0.000 7.09800e-06 0.000 7.09802e-06 1.800 7.10800e-06 1.800
+ 7.10802e-06 0.000 7.11400e-06 0.000 7.11402e-06 1.800 7.12200e-06 1.800 7.12202e-06 0.000 7.12600e-06 0.000
+ 7.12602e-06 1.800 7.12800e-06 1.800 7.12802e-06 0.000 7.13200e-06 0.000 7.13202e-06 1.800 7.13800e-06 1.800
+ 7.13802e-06 0.000 7.14800e-06 0.000 7.14802e-06 1.800 7.15400e-06 1.800 7.15402e-06 0.000 7.15600e-06 0.000
+ 7.15602e-06 1.800 7.16000e-06 1.800 7.16002e-06 0.000 7.16600e-06 0.000 7.16602e-06 1.800 7.17600e-06 1.800
+ 7.17602e-06 0.000 7.19400e-06 0.000 7.19402e-06 1.800 7.20800e-06 1.800 7.20802e-06 0.000 7.22400e-06 0.000
+ 7.22402e-06 1.800 7.23800e-06 1.800 7.23802e-06 0.000 7.24400e-06 0.000 7.24402e-06 1.800 7.25200e-06 1.800
+ 7.25202e-06 0.000 7.25600e-06 0.000 7.25602e-06 1.800 7.25800e-06 1.800 7.25802e-06 0.000 7.26200e-06 0.000
+ 7.26202e-06 1.800 7.26800e-06 1.800 7.26802e-06 0.000 7.27800e-06 0.000 7.27802e-06 1.800 7.28400e-06 1.800
+ 7.28402e-06 0.000 7.28600e-06 0.000 7.28602e-06 1.800 7.29000e-06 1.800 7.29002e-06 0.000 7.29600e-06 0.000
+ 7.29602e-06 1.800 7.30600e-06 1.800 7.30602e-06 0.000 7.31600e-06 0.000 7.31602e-06 1.800 7.32200e-06 1.800
+ 7.32202e-06 0.000 7.33000e-06 0.000 7.33002e-06 1.800 7.33400e-06 1.800 7.33402e-06 0.000 7.33600e-06 0.000
+ 7.33602e-06 1.800 7.34000e-06 1.800 7.34002e-06 0.000 7.34600e-06 0.000 7.34602e-06 1.800 7.35600e-06 1.800
+ 7.35602e-06 0.000 7.36200e-06 0.000 7.36202e-06 1.800 7.36400e-06 1.800 7.36402e-06 0.000 7.36800e-06 0.000
+ 7.36802e-06 1.800 7.37400e-06 1.800 7.37402e-06 0.000 7.38400e-06 0.000 7.38402e-06 1.800 7.41800e-06 1.800
+ 7.41802e-06 0.000 7.44800e-06 0.000 7.44802e-06 1.800 7.48000e-06 1.800 7.48002e-06 0.000 7.51600e-06 0.000
+ 7.51602e-06 1.800 7.53000e-06 1.800 7.53002e-06 0.000 7.54600e-06 0.000 7.54602e-06 1.800 7.56000e-06 1.800
+ 7.56002e-06 0.000 7.56600e-06 0.000 7.56602e-06 1.800 7.57400e-06 1.800 7.57402e-06 0.000 7.57800e-06 0.000
+ 7.57802e-06 1.800 7.58000e-06 1.800 7.58002e-06 0.000 7.58400e-06 0.000 7.58402e-06 1.800 7.59000e-06 1.800
+ 7.59002e-06 0.000 7.60000e-06 0.000 7.60002e-06 1.800 7.60600e-06 1.800 7.60602e-06 0.000 7.60800e-06 0.000
+ 7.60802e-06 1.800 7.61200e-06 1.800 7.61202e-06 0.000 7.61800e-06 0.000 7.61802e-06 1.800 7.62800e-06 1.800
+ 7.62802e-06 0.000 7.63800e-06 0.000 7.63802e-06 1.800 7.64400e-06 1.800 7.64402e-06 0.000 7.65200e-06 0.000
+ 7.65202e-06 1.800 7.65600e-06 1.800 7.65602e-06 0.000 7.65800e-06 0.000 7.65802e-06 1.800 7.66200e-06 1.800
+ 7.66202e-06 0.000 7.66800e-06 0.000 7.66802e-06 1.800 7.67800e-06 1.800 7.67802e-06 0.000 7.68400e-06 0.000
+ 7.68402e-06 1.800 7.68600e-06 1.800 7.68602e-06 0.000 7.69000e-06 0.000 7.69002e-06 1.800 7.69600e-06 1.800
+ 7.69602e-06 0.000 7.70600e-06 0.000 7.70602e-06 1.800 7.72400e-06 1.800 7.72402e-06 0.000 7.73800e-06 0.000
+ 7.73802e-06 1.800 7.75400e-06 1.800 7.75402e-06 0.000 7.76800e-06 0.000 7.76802e-06 1.800 7.77400e-06 1.800
+ 7.77402e-06 0.000 7.78200e-06 0.000 7.78202e-06 1.800 7.78600e-06 1.800 7.78602e-06 0.000 7.78800e-06 0.000
+ 7.78802e-06 1.800 7.79200e-06 1.800 7.79202e-06 0.000 7.79800e-06 0.000 7.79802e-06 1.800 7.80800e-06 1.800
+ 7.80802e-06 0.000 7.81400e-06 0.000 7.81402e-06 1.800 7.81600e-06 1.800 7.81602e-06 0.000 7.82000e-06 0.000
+ 7.82002e-06 1.800 7.82600e-06 1.800 7.82602e-06 0.000 7.83600e-06 0.000 7.83602e-06 1.800 7.84600e-06 1.800
+ 7.84602e-06 0.000 7.85200e-06 0.000 7.85202e-06 1.800 7.86000e-06 1.800 7.86002e-06 0.000 7.86400e-06 0.000
+ 7.86402e-06 1.800 7.86600e-06 1.800 7.86602e-06 0.000 7.87000e-06 0.000 7.87002e-06 1.800 7.87600e-06 1.800
+ 7.87602e-06 0.000 7.88600e-06 0.000 7.88602e-06 1.800 7.89200e-06 1.800 7.89202e-06 0.000 7.89400e-06 0.000
+ 7.89402e-06 1.800 7.89800e-06 1.800 7.89802e-06 0.000 7.90400e-06 0.000 7.90402e-06 1.800 7.91400e-06 1.800
+ 7.91402e-06 0.000 7.98000e-06 0.000 7.98002e-06 1.800 8.04200e-06 1.800 8.04202e-06 0.000 8.10600e-06 0.000
+ 8.10602e-06 1.800 8.18800e-06 1.800 8.18802e-06 0.000 8.21800e-06 0.000 8.21802e-06 1.800 8.25000e-06 1.800
+ 8.25002e-06 0.000 8.28600e-06 0.000 8.28602e-06 1.800 8.30000e-06 1.800 8.30002e-06 0.000 8.31600e-06 0.000
+ 8.31602e-06 1.800 8.33000e-06 1.800 8.33002e-06 0.000 8.33600e-06 0.000 8.33602e-06 1.800 8.34400e-06 1.800
+ 8.34402e-06 0.000 8.34800e-06 0.000 8.34802e-06 1.800 8.35000e-06 1.800 8.35002e-06 0.000 8.35400e-06 0.000
+ 8.35402e-06 1.800 8.36000e-06 1.800 8.36002e-06 0.000 8.37000e-06 0.000 8.37002e-06 1.800 8.37600e-06 1.800
+ 8.37602e-06 0.000 8.37800e-06 0.000 8.37802e-06 1.800 8.38200e-06 1.800 8.38202e-06 0.000 8.38800e-06 0.000
+ 8.38802e-06 1.800 8.39800e-06 1.800 8.39802e-06 0.000 8.40800e-06 0.000 8.40802e-06 1.800 8.41400e-06 1.800
+ 8.41402e-06 0.000 8.42200e-06 0.000 8.42202e-06 1.800 8.42600e-06 1.800 8.42602e-06 0.000 8.42800e-06 0.000
+ 8.42802e-06 1.800 8.43200e-06 1.800 8.43202e-06 0.000 8.43800e-06 0.000 8.43802e-06 1.800 8.44800e-06 1.800
+ 8.44802e-06 0.000 8.45400e-06 0.000 8.45402e-06 1.800 8.45600e-06 1.800 8.45602e-06 0.000 8.46000e-06 0.000
+ 8.46002e-06 1.800 8.46600e-06 1.800 8.46602e-06 0.000 8.47600e-06 0.000 8.47602e-06 1.800 8.49400e-06 1.800
+ 8.49402e-06 0.000 8.50800e-06 0.000 8.50802e-06 1.800 8.52400e-06 1.800 8.52402e-06 0.000 8.53800e-06 0.000
+ 8.53802e-06 1.800 8.54400e-06 1.800 8.54402e-06 0.000 8.55200e-06 0.000 8.55202e-06 1.800 8.55600e-06 1.800
+ 8.55602e-06 0.000 8.55800e-06 0.000 8.55802e-06 1.800 8.56200e-06 1.800 8.56202e-06 0.000 8.56800e-06 0.000
+ 8.56802e-06 1.800 8.57800e-06 1.800 8.57802e-06 0.000 8.58400e-06 0.000 8.58402e-06 1.800 8.58600e-06 1.800
+ 8.58602e-06 0.000 8.59000e-06 0.000 8.59002e-06 1.800 8.59600e-06 1.800 8.59602e-06 0.000 8.60600e-06 0.000
+ 8.60602e-06 1.800 8.61600e-06 1.800 8.61602e-06 0.000 8.62200e-06 0.000 8.62202e-06 1.800 8.63000e-06 1.800
+ 8.63002e-06 0.000 8.63400e-06 0.000 8.63402e-06 1.800 8.63600e-06 1.800 8.63602e-06 0.000 8.64000e-06 0.000
+ 8.64002e-06 1.800 8.64600e-06 1.800 8.64602e-06 0.000 8.65600e-06 0.000 8.65602e-06 1.800 8.66200e-06 1.800
+ 8.66202e-06 0.000 8.66400e-06 0.000 8.66402e-06 1.800 8.66800e-06 1.800 8.66802e-06 0.000 8.67400e-06 0.000
+ 8.67402e-06 1.800 8.68400e-06 1.800 8.68402e-06 0.000 8.71800e-06 0.000 8.71802e-06 1.800 8.74800e-06 1.800
+ 8.74802e-06 0.000 8.78000e-06 0.000 8.78002e-06 1.800 8.81600e-06 1.800 8.81602e-06 0.000 8.83000e-06 0.000
+ 8.83002e-06 1.800 8.84600e-06 1.800 8.84602e-06 0.000 8.86000e-06 0.000 8.86002e-06 1.800 8.86600e-06 1.800
+ 8.86602e-06 0.000 8.87400e-06 0.000 8.87402e-06 1.800 8.87800e-06 1.800 8.87802e-06 0.000 8.88000e-06 0.000
+ 8.88002e-06 1.800 8.88400e-06 1.800 8.88402e-06 0.000 8.89000e-06 0.000 8.89002e-06 1.800 8.90000e-06 1.800
+ 8.90002e-06 0.000 8.90600e-06 0.000 8.90602e-06 1.800 8.90800e-06 1.800 8.90802e-06 0.000 8.91200e-06 0.000
+ 8.91202e-06 1.800 8.91800e-06 1.800 8.91802e-06 0.000 8.92800e-06 0.000 8.92802e-06 1.800 8.93800e-06 1.800
+ 8.93802e-06 0.000 8.94400e-06 0.000 8.94402e-06 1.800 8.95200e-06 1.800 8.95202e-06 0.000 8.95600e-06 0.000
+ 8.95602e-06 1.800 8.95800e-06 1.800 8.95802e-06 0.000 8.96200e-06 0.000 8.96202e-06 1.800 8.96800e-06 1.800
+ 8.96802e-06 0.000 8.97800e-06 0.000 8.97802e-06 1.800 8.98400e-06 1.800 8.98402e-06 0.000 8.98600e-06 0.000
+ 8.98602e-06 1.800 8.99000e-06 1.800 8.99002e-06 0.000 8.99600e-06 0.000 8.99602e-06 1.800 9.00600e-06 1.800
+ 9.00602e-06 0.000 9.02400e-06 0.000 9.02402e-06 1.800 9.03800e-06 1.800 9.03802e-06 0.000 9.05400e-06 0.000
+ 9.05402e-06 1.800 9.06800e-06 1.800 9.06802e-06 0.000 9.07400e-06 0.000 9.07402e-06 1.800 9.08200e-06 1.800
+ 9.08202e-06 0.000 9.08600e-06 0.000 9.08602e-06 1.800 9.08800e-06 1.800 9.08802e-06 0.000 9.09200e-06 0.000
+ 9.09202e-06 1.800 9.09800e-06 1.800 9.09802e-06 0.000 9.10800e-06 0.000 9.10802e-06 1.800 9.11400e-06 1.800
+ 9.11402e-06 0.000 9.11600e-06 0.000 9.11602e-06 1.800 9.12000e-06 1.800 9.12002e-06 0.000 9.12600e-06 0.000
+ 9.12602e-06 1.800 9.13600e-06 1.800 9.13602e-06 0.000 9.14600e-06 0.000 9.14602e-06 1.800 9.15200e-06 1.800
+ 9.15202e-06 0.000 9.16000e-06 0.000 9.16002e-06 1.800 9.16400e-06 1.800 9.16402e-06 0.000 9.16600e-06 0.000
+ 9.16602e-06 1.800 9.17000e-06 1.800 9.17002e-06 0.000 9.17600e-06 0.000 9.17602e-06 1.800 9.18600e-06 1.800
+ 9.18602e-06 0.000 9.19200e-06 0.000 9.19202e-06 1.800 9.19400e-06 1.800 9.19402e-06 0.000 9.19800e-06 0.000
+ 9.19802e-06 1.800 9.20400e-06 1.800 9.20402e-06 0.000 9.21400e-06 0.000 9.21402e-06 1.800 9.21800e-06 1.800
+ )
Xd_t2b src_t2b t2b vdd gnd tb_x1
Vt3b src_t3b gnd PWL(
+ 0.00000e+00 1.800 1.02200e-06 1.800 1.02202e-06 0.000 2.53600e-06 0.000 2.53602e-06 1.800 3.28400e-06 1.800
+ 3.28402e-06 0.000 3.65000e-06 0.000 3.65002e-06 1.800 3.82600e-06 1.800 3.82602e-06 0.000 3.90800e-06 0.000
+ 3.90802e-06 1.800 3.94400e-06 1.800 3.94402e-06 0.000 3.95800e-06 0.000 3.95802e-06 1.800 3.96200e-06 1.800
+ 3.96202e-06 0.000 3.96400e-06 0.000 3.96402e-06 1.800 3.96800e-06 1.800 3.96802e-06 0.000 3.97200e-06 0.000
+ 3.97202e-06 1.800 3.97400e-06 1.800 3.97402e-06 0.000 3.97800e-06 0.000 3.97802e-06 1.800 3.98600e-06 1.800
+ 3.98602e-06 0.000 3.99000e-06 0.000 3.99002e-06 1.800 3.99200e-06 1.800 3.99202e-06 0.000 3.99600e-06 0.000
+ 3.99602e-06 1.800 4.00000e-06 1.800 4.00002e-06 0.000 4.00200e-06 0.000 4.00202e-06 1.800 4.00600e-06 1.800
+ 4.00602e-06 0.000 4.02200e-06 0.000 4.02202e-06 1.800 4.03600e-06 1.800 4.03602e-06 0.000 4.04000e-06 0.000
+ 4.04002e-06 1.800 4.04200e-06 1.800 4.04202e-06 0.000 4.04600e-06 0.000 4.04602e-06 1.800 4.05000e-06 1.800
+ 4.05002e-06 0.000 4.05200e-06 0.000 4.05202e-06 1.800 4.05600e-06 1.800 4.05602e-06 0.000 4.06400e-06 0.000
+ 4.06402e-06 1.800 4.06800e-06 1.800 4.06802e-06 0.000 4.07000e-06 0.000 4.07002e-06 1.800 4.07400e-06 1.800
+ 4.07402e-06 0.000 4.07800e-06 0.000 4.07802e-06 1.800 4.08000e-06 1.800 4.08002e-06 0.000 4.08400e-06 0.000
+ 4.08402e-06 1.800 4.11600e-06 1.800 4.11602e-06 0.000 4.15200e-06 0.000 4.15202e-06 1.800 4.16600e-06 1.800
+ 4.16602e-06 0.000 4.17000e-06 0.000 4.17002e-06 1.800 4.17200e-06 1.800 4.17202e-06 0.000 4.17600e-06 0.000
+ 4.17602e-06 1.800 4.18000e-06 1.800 4.18002e-06 0.000 4.18200e-06 0.000 4.18202e-06 1.800 4.18600e-06 1.800
+ 4.18602e-06 0.000 4.19400e-06 0.000 4.19402e-06 1.800 4.19800e-06 1.800 4.19802e-06 0.000 4.20000e-06 0.000
+ 4.20002e-06 1.800 4.20400e-06 1.800 4.20402e-06 0.000 4.20800e-06 0.000 4.20802e-06 1.800 4.21000e-06 1.800
+ 4.21002e-06 0.000 4.21400e-06 0.000 4.21402e-06 1.800 4.23000e-06 1.800 4.23002e-06 0.000 4.24400e-06 0.000
+ 4.24402e-06 1.800 4.24800e-06 1.800 4.24802e-06 0.000 4.25000e-06 0.000 4.25002e-06 1.800 4.25400e-06 1.800
+ 4.25402e-06 0.000 4.25800e-06 0.000 4.25802e-06 1.800 4.26000e-06 1.800 4.26002e-06 0.000 4.26400e-06 0.000
+ 4.26402e-06 1.800 4.27200e-06 1.800 4.27202e-06 0.000 4.27600e-06 0.000 4.27602e-06 1.800 4.27800e-06 1.800
+ 4.27802e-06 0.000 4.28200e-06 0.000 4.28202e-06 1.800 4.28600e-06 1.800 4.28602e-06 0.000 4.28800e-06 0.000
+ 4.28802e-06 1.800 4.29200e-06 1.800 4.29202e-06 0.000 4.35600e-06 0.000 4.35602e-06 1.800 4.43800e-06 1.800
+ 4.43802e-06 0.000 4.47400e-06 0.000 4.47402e-06 1.800 4.48800e-06 1.800 4.48802e-06 0.000 4.49200e-06 0.000
+ 4.49202e-06 1.800 4.49400e-06 1.800 4.49402e-06 0.000 4.49800e-06 0.000 4.49802e-06 1.800 4.50200e-06 1.800
+ 4.50202e-06 0.000 4.50400e-06 0.000 4.50402e-06 1.800 4.50800e-06 1.800 4.50802e-06 0.000 4.51600e-06 0.000
+ 4.51602e-06 1.800 4.52000e-06 1.800 4.52002e-06 0.000 4.52200e-06 0.000 4.52202e-06 1.800 4.52600e-06 1.800
+ 4.52602e-06 0.000 4.53000e-06 0.000 4.53002e-06 1.800 4.53200e-06 1.800 4.53202e-06 0.000 4.53600e-06 0.000
+ 4.53602e-06 1.800 4.55200e-06 1.800 4.55202e-06 0.000 4.56600e-06 0.000 4.56602e-06 1.800 4.57000e-06 1.800
+ 4.57002e-06 0.000 4.57200e-06 0.000 4.57202e-06 1.800 4.57600e-06 1.800 4.57602e-06 0.000 4.58000e-06 0.000
+ 4.58002e-06 1.800 4.58200e-06 1.800 4.58202e-06 0.000 4.58600e-06 0.000 4.58602e-06 1.800 4.59400e-06 1.800
+ 4.59402e-06 0.000 4.59800e-06 0.000 4.59802e-06 1.800 4.60000e-06 1.800 4.60002e-06 0.000 4.60400e-06 0.000
+ 4.60402e-06 1.800 4.60800e-06 1.800 4.60802e-06 0.000 4.61000e-06 0.000 4.61002e-06 1.800 4.61400e-06 1.800
+ 4.61402e-06 0.000 4.64600e-06 0.000 4.64602e-06 1.800 4.68200e-06 1.800 4.68202e-06 0.000 4.69600e-06 0.000
+ 4.69602e-06 1.800 4.70000e-06 1.800 4.70002e-06 0.000 4.70200e-06 0.000 4.70202e-06 1.800 4.70600e-06 1.800
+ 4.70602e-06 0.000 4.71000e-06 0.000 4.71002e-06 1.800 4.71200e-06 1.800 4.71202e-06 0.000 4.71600e-06 0.000
+ 4.71602e-06 1.800 4.72400e-06 1.800 4.72402e-06 0.000 4.72800e-06 0.000 4.72802e-06 1.800 4.73000e-06 1.800
+ 4.73002e-06 0.000 4.73400e-06 0.000 4.73402e-06 1.800 4.73800e-06 1.800 4.73802e-06 0.000 4.74000e-06 0.000
+ 4.74002e-06 1.800 4.74400e-06 1.800 4.74402e-06 0.000 4.76000e-06 0.000 4.76002e-06 1.800 4.77400e-06 1.800
+ 4.77402e-06 0.000 4.77800e-06 0.000 4.77802e-06 1.800 4.78000e-06 1.800 4.78002e-06 0.000 4.78400e-06 0.000
+ 4.78402e-06 1.800 4.78800e-06 1.800 4.78802e-06 0.000 4.79000e-06 0.000 4.79002e-06 1.800 4.79400e-06 1.800
+ 4.79402e-06 0.000 4.80200e-06 0.000 4.80202e-06 1.800 4.80600e-06 1.800 4.80602e-06 0.000 4.80800e-06 0.000
+ 4.80802e-06 1.800 4.81200e-06 1.800 4.81202e-06 0.000 4.81600e-06 0.000 4.81602e-06 1.800 4.81800e-06 1.800
+ 4.81802e-06 0.000 4.82200e-06 0.000 4.82202e-06 1.800 4.95000e-06 1.800 4.95002e-06 0.000 5.12600e-06 0.000
+ 5.12602e-06 1.800 5.20800e-06 1.800 5.20802e-06 0.000 5.24400e-06 0.000 5.24402e-06 1.800 5.25800e-06 1.800
+ 5.25802e-06 0.000 5.26200e-06 0.000 5.26202e-06 1.800 5.26400e-06 1.800 5.26402e-06 0.000 5.26800e-06 0.000
+ 5.26802e-06 1.800 5.27200e-06 1.800 5.27202e-06 0.000 5.27400e-06 0.000 5.27402e-06 1.800 5.27800e-06 1.800
+ 5.27802e-06 0.000 5.28600e-06 0.000 5.28602e-06 1.800 5.29000e-06 1.800 5.29002e-06 0.000 5.29200e-06 0.000
+ 5.29202e-06 1.800 5.29600e-06 1.800 5.29602e-06 0.000 5.30000e-06 0.000 5.30002e-06 1.800 5.30200e-06 1.800
+ 5.30202e-06 0.000 5.30600e-06 0.000 5.30602e-06 1.800 5.32200e-06 1.800 5.32202e-06 0.000 5.33600e-06 0.000
+ 5.33602e-06 1.800 5.34000e-06 1.800 5.34002e-06 0.000 5.34200e-06 0.000 5.34202e-06 1.800 5.34600e-06 1.800
+ 5.34602e-06 0.000 5.35000e-06 0.000 5.35002e-06 1.800 5.35200e-06 1.800 5.35202e-06 0.000 5.35600e-06 0.000
+ 5.35602e-06 1.800 5.36400e-06 1.800 5.36402e-06 0.000 5.36800e-06 0.000 5.36802e-06 1.800 5.37000e-06 1.800
+ 5.37002e-06 0.000 5.37400e-06 0.000 5.37402e-06 1.800 5.37800e-06 1.800 5.37802e-06 0.000 5.38000e-06 0.000
+ 5.38002e-06 1.800 5.38400e-06 1.800 5.38402e-06 0.000 5.41600e-06 0.000 5.41602e-06 1.800 5.45200e-06 1.800
+ 5.45202e-06 0.000 5.46600e-06 0.000 5.46602e-06 1.800 5.47000e-06 1.800 5.47002e-06 0.000 5.47200e-06 0.000
+ 5.47202e-06 1.800 5.47600e-06 1.800 5.47602e-06 0.000 5.48000e-06 0.000 5.48002e-06 1.800 5.48200e-06 1.800
+ 5.48202e-06 0.000 5.48600e-06 0.000 5.48602e-06 1.800 5.49400e-06 1.800 5.49402e-06 0.000 5.49800e-06 0.000
+ 5.49802e-06 1.800 5.50000e-06 1.800 5.50002e-06 0.000 5.50400e-06 0.000 5.50402e-06 1.800 5.50800e-06 1.800
+ 5.50802e-06 0.000 5.51000e-06 0.000 5.51002e-06 1.800 5.51400e-06 1.800 5.51402e-06 0.000 5.53000e-06 0.000
+ 5.53002e-06 1.800 5.54400e-06 1.800 5.54402e-06 0.000 5.54800e-06 0.000 5.54802e-06 1.800 5.55000e-06 1.800
+ 5.55002e-06 0.000 5.55400e-06 0.000 5.55402e-06 1.800 5.55800e-06 1.800 5.55802e-06 0.000 5.56000e-06 0.000
+ 5.56002e-06 1.800 5.56400e-06 1.800 5.56402e-06 0.000 5.57200e-06 0.000 5.57202e-06 1.800 5.57600e-06 1.800
+ 5.57602e-06 0.000 5.57800e-06 0.000 5.57802e-06 1.800 5.58200e-06 1.800 5.58202e-06 0.000 5.58600e-06 0.000
+ 5.58602e-06 1.800 5.58800e-06 1.800 5.58802e-06 0.000 5.59200e-06 0.000 5.59202e-06 1.800 5.65600e-06 1.800
+ 5.65602e-06 0.000 5.73800e-06 0.000 5.73802e-06 1.800 5.77400e-06 1.800 5.77402e-06 0.000 5.78800e-06 0.000
+ 5.78802e-06 1.800 5.79200e-06 1.800 5.79202e-06 0.000 5.79400e-06 0.000 5.79402e-06 1.800 5.79800e-06 1.800
+ 5.79802e-06 0.000 5.80200e-06 0.000 5.80202e-06 1.800 5.80400e-06 1.800 5.80402e-06 0.000 5.80800e-06 0.000
+ 5.80802e-06 1.800 5.81600e-06 1.800 5.81602e-06 0.000 5.82000e-06 0.000 5.82002e-06 1.800 5.82200e-06 1.800
+ 5.82202e-06 0.000 5.82600e-06 0.000 5.82602e-06 1.800 5.83000e-06 1.800 5.83002e-06 0.000 5.83200e-06 0.000
+ 5.83202e-06 1.800 5.83600e-06 1.800 5.83602e-06 0.000 5.85200e-06 0.000 5.85202e-06 1.800 5.86600e-06 1.800
+ 5.86602e-06 0.000 5.87000e-06 0.000 5.87002e-06 1.800 5.87200e-06 1.800 5.87202e-06 0.000 5.87600e-06 0.000
+ 5.87602e-06 1.800 5.88000e-06 1.800 5.88002e-06 0.000 5.88200e-06 0.000 5.88202e-06 1.800 5.88600e-06 1.800
+ 5.88602e-06 0.000 5.89400e-06 0.000 5.89402e-06 1.800 5.89800e-06 1.800 5.89802e-06 0.000 5.90000e-06 0.000
+ 5.90002e-06 1.800 5.90400e-06 1.800 5.90402e-06 0.000 5.90800e-06 0.000 5.90802e-06 1.800 5.91000e-06 1.800
+ 5.91002e-06 0.000 5.91400e-06 0.000 5.91402e-06 1.800 5.94600e-06 1.800 5.94602e-06 0.000 5.98200e-06 0.000
+ 5.98202e-06 1.800 5.99600e-06 1.800 5.99602e-06 0.000 6.00000e-06 0.000 6.00002e-06 1.800 6.00200e-06 1.800
+ 6.00202e-06 0.000 6.00600e-06 0.000 6.00602e-06 1.800 6.01000e-06 1.800 6.01002e-06 0.000 6.01200e-06 0.000
+ 6.01202e-06 1.800 6.01600e-06 1.800 6.01602e-06 0.000 6.02400e-06 0.000 6.02402e-06 1.800 6.02800e-06 1.800
+ 6.02802e-06 0.000 6.03000e-06 0.000 6.03002e-06 1.800 6.03400e-06 1.800 6.03402e-06 0.000 6.03800e-06 0.000
+ 6.03802e-06 1.800 6.04000e-06 1.800 6.04002e-06 0.000 6.04400e-06 0.000 6.04402e-06 1.800 6.06000e-06 1.800
+ 6.06002e-06 0.000 6.07400e-06 0.000 6.07402e-06 1.800 6.07800e-06 1.800 6.07802e-06 0.000 6.08000e-06 0.000
+ 6.08002e-06 1.800 6.08400e-06 1.800 6.08402e-06 0.000 6.08800e-06 0.000 6.08802e-06 1.800 6.09000e-06 1.800
+ 6.09002e-06 0.000 6.09400e-06 0.000 6.09402e-06 1.800 6.10200e-06 1.800 6.10202e-06 0.000 6.10600e-06 0.000
+ 6.10602e-06 1.800 6.10800e-06 1.800 6.10802e-06 0.000 6.11200e-06 0.000 6.11202e-06 1.800 6.11600e-06 1.800
+ 6.11602e-06 0.000 6.11800e-06 0.000 6.11802e-06 1.800 6.12200e-06 1.800 6.12202e-06 0.000 6.37800e-06 0.000
+ 6.37802e-06 1.800 6.74400e-06 1.800 6.74402e-06 0.000 6.92000e-06 0.000 6.92002e-06 1.800 7.00200e-06 1.800
+ 7.00202e-06 0.000 7.03800e-06 0.000 7.03802e-06 1.800 7.05200e-06 1.800 7.05202e-06 0.000 7.05600e-06 0.000
+ 7.05602e-06 1.800 7.05800e-06 1.800 7.05802e-06 0.000 7.06200e-06 0.000 7.06202e-06 1.800 7.06600e-06 1.800
+ 7.06602e-06 0.000 7.06800e-06 0.000 7.06802e-06 1.800 7.07200e-06 1.800 7.07202e-06 0.000 7.08000e-06 0.000
+ 7.08002e-06 1.800 7.08400e-06 1.800 7.08402e-06 0.000 7.08600e-06 0.000 7.08602e-06 1.800 7.09000e-06 1.800
+ 7.09002e-06 0.000 7.09400e-06 0.000 7.09402e-06 1.800 7.09600e-06 1.800 7.09602e-06 0.000 7.10000e-06 0.000
+ 7.10002e-06 1.800 7.11600e-06 1.800 7.11602e-06 0.000 7.13000e-06 0.000 7.13002e-06 1.800 7.13400e-06 1.800
+ 7.13402e-06 0.000 7.13600e-06 0.000 7.13602e-06 1.800 7.14000e-06 1.800 7.14002e-06 0.000 7.14400e-06 0.000
+ 7.14402e-06 1.800 7.14600e-06 1.800 7.14602e-06 0.000 7.15000e-06 0.000 7.15002e-06 1.800 7.15800e-06 1.800
+ 7.15802e-06 0.000 7.16200e-06 0.000 7.16202e-06 1.800 7.16400e-06 1.800 7.16402e-06 0.000 7.16800e-06 0.000
+ 7.16802e-06 1.800 7.17200e-06 1.800 7.17202e-06 0.000 7.17400e-06 0.000 7.17402e-06 1.800 7.17800e-06 1.800
+ 7.17802e-06 0.000 7.21000e-06 0.000 7.21002e-06 1.800 7.24600e-06 1.800 7.24602e-06 0.000 7.26000e-06 0.000
+ 7.26002e-06 1.800 7.26400e-06 1.800 7.26402e-06 0.000 7.26600e-06 0.000 7.26602e-06 1.800 7.27000e-06 1.800
+ 7.27002e-06 0.000 7.27400e-06 0.000 7.27402e-06 1.800 7.27600e-06 1.800 7.27602e-06 0.000 7.28000e-06 0.000
+ 7.28002e-06 1.800 7.28800e-06 1.800 7.28802e-06 0.000 7.29200e-06 0.000 7.29202e-06 1.800 7.29400e-06 1.800
+ 7.29402e-06 0.000 7.29800e-06 0.000 7.29802e-06 1.800 7.30200e-06 1.800 7.30202e-06 0.000 7.30400e-06 0.000
+ 7.30402e-06 1.800 7.30800e-06 1.800 7.30802e-06 0.000 7.32400e-06 0.000 7.32402e-06 1.800 7.33800e-06 1.800
+ 7.33802e-06 0.000 7.34200e-06 0.000 7.34202e-06 1.800 7.34400e-06 1.800 7.34402e-06 0.000 7.34800e-06 0.000
+ 7.34802e-06 1.800 7.35200e-06 1.800 7.35202e-06 0.000 7.35400e-06 0.000 7.35402e-06 1.800 7.35800e-06 1.800
+ 7.35802e-06 0.000 7.36600e-06 0.000 7.36602e-06 1.800 7.37000e-06 1.800 7.37002e-06 0.000 7.37200e-06 0.000
+ 7.37202e-06 1.800 7.37600e-06 1.800 7.37602e-06 0.000 7.38000e-06 0.000 7.38002e-06 1.800 7.38200e-06 1.800
+ 7.38202e-06 0.000 7.38600e-06 0.000 7.38602e-06 1.800 7.45000e-06 1.800 7.45002e-06 0.000 7.53200e-06 0.000
+ 7.53202e-06 1.800 7.56800e-06 1.800 7.56802e-06 0.000 7.58200e-06 0.000 7.58202e-06 1.800 7.58600e-06 1.800
+ 7.58602e-06 0.000 7.58800e-06 0.000 7.58802e-06 1.800 7.59200e-06 1.800 7.59202e-06 0.000 7.59600e-06 0.000
+ 7.59602e-06 1.800 7.59800e-06 1.800 7.59802e-06 0.000 7.60200e-06 0.000 7.60202e-06 1.800 7.61000e-06 1.800
+ 7.61002e-06 0.000 7.61400e-06 0.000 7.61402e-06 1.800 7.61600e-06 1.800 7.61602e-06 0.000 7.62000e-06 0.000
+ 7.62002e-06 1.800 7.62400e-06 1.800 7.62402e-06 0.000 7.62600e-06 0.000 7.62602e-06 1.800 7.63000e-06 1.800
+ 7.63002e-06 0.000 7.64600e-06 0.000 7.64602e-06 1.800 7.66000e-06 1.800 7.66002e-06 0.000 7.66400e-06 0.000
+ 7.66402e-06 1.800 7.66600e-06 1.800 7.66602e-06 0.000 7.67000e-06 0.000 7.67002e-06 1.800 7.67400e-06 1.800
+ 7.67402e-06 0.000 7.67600e-06 0.000 7.67602e-06 1.800 7.68000e-06 1.800 7.68002e-06 0.000 7.68800e-06 0.000
+ 7.68802e-06 1.800 7.69200e-06 1.800 7.69202e-06 0.000 7.69400e-06 0.000 7.69402e-06 1.800 7.69800e-06 1.800
+ 7.69802e-06 0.000 7.70200e-06 0.000 7.70202e-06 1.800 7.70400e-06 1.800 7.70402e-06 0.000 7.70800e-06 0.000
+ 7.70802e-06 1.800 7.74000e-06 1.800 7.74002e-06 0.000 7.77600e-06 0.000 7.77602e-06 1.800 7.79000e-06 1.800
+ 7.79002e-06 0.000 7.79400e-06 0.000 7.79402e-06 1.800 7.79600e-06 1.800 7.79602e-06 0.000 7.80000e-06 0.000
+ 7.80002e-06 1.800 7.80400e-06 1.800 7.80402e-06 0.000 7.80600e-06 0.000 7.80602e-06 1.800 7.81000e-06 1.800
+ 7.81002e-06 0.000 7.81800e-06 0.000 7.81802e-06 1.800 7.82200e-06 1.800 7.82202e-06 0.000 7.82400e-06 0.000
+ 7.82402e-06 1.800 7.82800e-06 1.800 7.82802e-06 0.000 7.83200e-06 0.000 7.83202e-06 1.800 7.83400e-06 1.800
+ 7.83402e-06 0.000 7.83800e-06 0.000 7.83802e-06 1.800 7.85400e-06 1.800 7.85402e-06 0.000 7.86800e-06 0.000
+ 7.86802e-06 1.800 7.87200e-06 1.800 7.87202e-06 0.000 7.87400e-06 0.000 7.87402e-06 1.800 7.87800e-06 1.800
+ 7.87802e-06 0.000 7.88200e-06 0.000 7.88202e-06 1.800 7.88400e-06 1.800 7.88402e-06 0.000 7.88800e-06 0.000
+ 7.88802e-06 1.800 7.89600e-06 1.800 7.89602e-06 0.000 7.90000e-06 0.000 7.90002e-06 1.800 7.90200e-06 1.800
+ 7.90202e-06 0.000 7.90600e-06 0.000 7.90602e-06 1.800 7.91000e-06 1.800 7.91002e-06 0.000 7.91200e-06 0.000
+ 7.91202e-06 1.800 7.91600e-06 1.800 7.91602e-06 0.000 8.04400e-06 0.000 8.04402e-06 1.800 8.22000e-06 1.800
+ 8.22002e-06 0.000 8.30200e-06 0.000 8.30202e-06 1.800 8.33800e-06 1.800 8.33802e-06 0.000 8.35200e-06 0.000
+ 8.35202e-06 1.800 8.35600e-06 1.800 8.35602e-06 0.000 8.35800e-06 0.000 8.35802e-06 1.800 8.36200e-06 1.800
+ 8.36202e-06 0.000 8.36600e-06 0.000 8.36602e-06 1.800 8.36800e-06 1.800 8.36802e-06 0.000 8.37200e-06 0.000
+ 8.37202e-06 1.800 8.38000e-06 1.800 8.38002e-06 0.000 8.38400e-06 0.000 8.38402e-06 1.800 8.38600e-06 1.800
+ 8.38602e-06 0.000 8.39000e-06 0.000 8.39002e-06 1.800 8.39400e-06 1.800 8.39402e-06 0.000 8.39600e-06 0.000
+ 8.39602e-06 1.800 8.40000e-06 1.800 8.40002e-06 0.000 8.41600e-06 0.000 8.41602e-06 1.800 8.43000e-06 1.800
+ 8.43002e-06 0.000 8.43400e-06 0.000 8.43402e-06 1.800 8.43600e-06 1.800 8.43602e-06 0.000 8.44000e-06 0.000
+ 8.44002e-06 1.800 8.44400e-06 1.800 8.44402e-06 0.000 8.44600e-06 0.000 8.44602e-06 1.800 8.45000e-06 1.800
+ 8.45002e-06 0.000 8.45800e-06 0.000 8.45802e-06 1.800 8.46200e-06 1.800 8.46202e-06 0.000 8.46400e-06 0.000
+ 8.46402e-06 1.800 8.46800e-06 1.800 8.46802e-06 0.000 8.47200e-06 0.000 8.47202e-06 1.800 8.47400e-06 1.800
+ 8.47402e-06 0.000 8.47800e-06 0.000 8.47802e-06 1.800 8.51000e-06 1.800 8.51002e-06 0.000 8.54600e-06 0.000
+ 8.54602e-06 1.800 8.56000e-06 1.800 8.56002e-06 0.000 8.56400e-06 0.000 8.56402e-06 1.800 8.56600e-06 1.800
+ 8.56602e-06 0.000 8.57000e-06 0.000 8.57002e-06 1.800 8.57400e-06 1.800 8.57402e-06 0.000 8.57600e-06 0.000
+ 8.57602e-06 1.800 8.58000e-06 1.800 8.58002e-06 0.000 8.58800e-06 0.000 8.58802e-06 1.800 8.59200e-06 1.800
+ 8.59202e-06 0.000 8.59400e-06 0.000 8.59402e-06 1.800 8.59800e-06 1.800 8.59802e-06 0.000 8.60200e-06 0.000
+ 8.60202e-06 1.800 8.60400e-06 1.800 8.60402e-06 0.000 8.60800e-06 0.000 8.60802e-06 1.800 8.62400e-06 1.800
+ 8.62402e-06 0.000 8.63800e-06 0.000 8.63802e-06 1.800 8.64200e-06 1.800 8.64202e-06 0.000 8.64400e-06 0.000
+ 8.64402e-06 1.800 8.64800e-06 1.800 8.64802e-06 0.000 8.65200e-06 0.000 8.65202e-06 1.800 8.65400e-06 1.800
+ 8.65402e-06 0.000 8.65800e-06 0.000 8.65802e-06 1.800 8.66600e-06 1.800 8.66602e-06 0.000 8.67000e-06 0.000
+ 8.67002e-06 1.800 8.67200e-06 1.800 8.67202e-06 0.000 8.67600e-06 0.000 8.67602e-06 1.800 8.68000e-06 1.800
+ 8.68002e-06 0.000 8.68200e-06 0.000 8.68202e-06 1.800 8.68600e-06 1.800 8.68602e-06 0.000 8.75000e-06 0.000
+ 8.75002e-06 1.800 8.83200e-06 1.800 8.83202e-06 0.000 8.86800e-06 0.000 8.86802e-06 1.800 8.88200e-06 1.800
+ 8.88202e-06 0.000 8.88600e-06 0.000 8.88602e-06 1.800 8.88800e-06 1.800 8.88802e-06 0.000 8.89200e-06 0.000
+ 8.89202e-06 1.800 8.89600e-06 1.800 8.89602e-06 0.000 8.89800e-06 0.000 8.89802e-06 1.800 8.90200e-06 1.800
+ 8.90202e-06 0.000 8.91000e-06 0.000 8.91002e-06 1.800 8.91400e-06 1.800 8.91402e-06 0.000 8.91600e-06 0.000
+ 8.91602e-06 1.800 8.92000e-06 1.800 8.92002e-06 0.000 8.92400e-06 0.000 8.92402e-06 1.800 8.92600e-06 1.800
+ 8.92602e-06 0.000 8.93000e-06 0.000 8.93002e-06 1.800 8.94600e-06 1.800 8.94602e-06 0.000 8.96000e-06 0.000
+ 8.96002e-06 1.800 8.96400e-06 1.800 8.96402e-06 0.000 8.96600e-06 0.000 8.96602e-06 1.800 8.97000e-06 1.800
+ 8.97002e-06 0.000 8.97400e-06 0.000 8.97402e-06 1.800 8.97600e-06 1.800 8.97602e-06 0.000 8.98000e-06 0.000
+ 8.98002e-06 1.800 8.98800e-06 1.800 8.98802e-06 0.000 8.99200e-06 0.000 8.99202e-06 1.800 8.99400e-06 1.800
+ 8.99402e-06 0.000 8.99800e-06 0.000 8.99802e-06 1.800 9.00200e-06 1.800 9.00202e-06 0.000 9.00400e-06 0.000
+ 9.00402e-06 1.800 9.00800e-06 1.800 9.00802e-06 0.000 9.04000e-06 0.000 9.04002e-06 1.800 9.07600e-06 1.800
+ 9.07602e-06 0.000 9.09000e-06 0.000 9.09002e-06 1.800 9.09400e-06 1.800 9.09402e-06 0.000 9.09600e-06 0.000
+ 9.09602e-06 1.800 9.10000e-06 1.800 9.10002e-06 0.000 9.10400e-06 0.000 9.10402e-06 1.800 9.10600e-06 1.800
+ 9.10602e-06 0.000 9.11000e-06 0.000 9.11002e-06 1.800 9.11800e-06 1.800 9.11802e-06 0.000 9.12200e-06 0.000
+ 9.12202e-06 1.800 9.12400e-06 1.800 9.12402e-06 0.000 9.12800e-06 0.000 9.12802e-06 1.800 9.13200e-06 1.800
+ 9.13202e-06 0.000 9.13400e-06 0.000 9.13402e-06 1.800 9.13800e-06 1.800 9.13802e-06 0.000 9.15400e-06 0.000
+ 9.15402e-06 1.800 9.16800e-06 1.800 9.16802e-06 0.000 9.17200e-06 0.000 9.17202e-06 1.800 9.17400e-06 1.800
+ 9.17402e-06 0.000 9.17800e-06 0.000 9.17802e-06 1.800 9.18200e-06 1.800 9.18202e-06 0.000 9.18400e-06 0.000
+ 9.18402e-06 1.800 9.18800e-06 1.800 9.18802e-06 0.000 9.19600e-06 0.000 9.19602e-06 1.800 9.20000e-06 1.800
+ 9.20002e-06 0.000 9.20200e-06 0.000 9.20202e-06 1.800 9.20600e-06 1.800 9.20602e-06 0.000 9.21000e-06 0.000
+ 9.21002e-06 1.800 9.21200e-06 1.800 9.21202e-06 0.000 9.21600e-06 0.000 9.21602e-06 1.800 9.21800e-06 1.800
+ )
Xd_t3b src_t3b t3b vdd gnd tb_x1
Xl_c1 c1 lo_c1 vdd gnd tb_x1
Xl_c2 c2 lo_c2 vdd gnd tb_x1
Xl_c3 c3 lo_c3 vdd gnd tb_x1
Xl_c4 c4 lo_c4 vdd gnd tb_x1
X0 c0 g0b g1b g2b g3b t0b t1b t2b t3b c1 c2 c3 c4 vdd gnd carryx_post
.tran 200p 9.21800e-06
.control
set wr_singlescale
set wr_vecnames
run
wrdata carry_post.txt v(c0) v(g0b) v(g1b) v(g2b) v(g3b) v(t0b) v(t1b) v(t2b) v(t3b) v(c1) v(c2) v(c3) v(c4)
quit
.endc
.end
