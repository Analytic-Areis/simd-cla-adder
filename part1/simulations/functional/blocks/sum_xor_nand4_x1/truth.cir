* Truth table of sum_xor_nand4_x1: inputs through unit inverters, outputs load 20L/10L inverter
.include ../../../../spice/models/TSMC_180nm.txt
.options reltol=1e-3
VDD vdd gnd 1.8
* xor_nand4_x1: four-NAND XOR baseline
* GENERATED from part1/cells/library.py. Do not edit by hand.
.subckt xor_nand4_x1 p c s vdd gnd
Ms0p1 n1 p vdd vdd CMOSP W=1.8000e-06 L=1.8000e-07 AS=9.7200e-13 PS=4.6800e-06 AD=9.7200e-13 PD=4.6800e-06
Ms0p2 n1 c vdd vdd CMOSP W=1.8000e-06 L=1.8000e-07 AS=9.7200e-13 PS=4.6800e-06 AD=9.7200e-13 PD=4.6800e-06
Ms0n1 n1 p s0xn1 gnd CMOSN W=1.8000e-06 L=1.8000e-07 AS=4.8600e-13 PS=4.1400e-06 AD=9.7200e-13 PD=4.6800e-06
Ms0n2 s0xn1 c gnd gnd CMOSN W=1.8000e-06 L=1.8000e-07 AS=9.7200e-13 PS=4.6800e-06 AD=4.8600e-13 PD=4.1400e-06
Ms1p1 n2 p vdd vdd CMOSP W=1.8000e-06 L=1.8000e-07 AS=9.7200e-13 PS=4.6800e-06 AD=9.7200e-13 PD=4.6800e-06
Ms1p2 n2 n1 vdd vdd CMOSP W=1.8000e-06 L=1.8000e-07 AS=9.7200e-13 PS=4.6800e-06 AD=9.7200e-13 PD=4.6800e-06
Ms1n1 n2 p s1xn1 gnd CMOSN W=1.8000e-06 L=1.8000e-07 AS=4.8600e-13 PS=4.1400e-06 AD=9.7200e-13 PD=4.6800e-06
Ms1n2 s1xn1 n1 gnd gnd CMOSN W=1.8000e-06 L=1.8000e-07 AS=9.7200e-13 PS=4.6800e-06 AD=4.8600e-13 PD=4.1400e-06
Ms2p1 n3 c vdd vdd CMOSP W=1.8000e-06 L=1.8000e-07 AS=9.7200e-13 PS=4.6800e-06 AD=9.7200e-13 PD=4.6800e-06
Ms2p2 n3 n1 vdd vdd CMOSP W=1.8000e-06 L=1.8000e-07 AS=9.7200e-13 PS=4.6800e-06 AD=9.7200e-13 PD=4.6800e-06
Ms2n1 n3 c s2xn1 gnd CMOSN W=1.8000e-06 L=1.8000e-07 AS=4.8600e-13 PS=4.1400e-06 AD=9.7200e-13 PD=4.6800e-06
Ms2n2 s2xn1 n1 gnd gnd CMOSN W=1.8000e-06 L=1.8000e-07 AS=9.7200e-13 PS=4.6800e-06 AD=4.8600e-13 PD=4.1400e-06
Ms3p1 s n2 vdd vdd CMOSP W=1.8000e-06 L=1.8000e-07 AS=9.7200e-13 PS=4.6800e-06 AD=9.7200e-13 PD=4.6800e-06
Ms3p2 s n3 vdd vdd CMOSP W=1.8000e-06 L=1.8000e-07 AS=9.7200e-13 PS=4.6800e-06 AD=9.7200e-13 PD=4.6800e-06
Ms3n1 s n2 s3xn1 gnd CMOSN W=1.8000e-06 L=1.8000e-07 AS=4.8600e-13 PS=4.1400e-06 AD=9.7200e-13 PD=4.6800e-06
Ms3n2 s3xn1 n3 gnd gnd CMOSN W=1.8000e-06 L=1.8000e-07 AS=9.7200e-13 PS=4.6800e-06 AD=4.8600e-13 PD=4.1400e-06
.ends xor_nand4_x1
* sum_xor_nand4_x1: 4-bit sum block using xor_nand4
* GENERATED from part1/cells/library.py. Do not edit by hand.
.subckt sum_xor_nand4_x1 p0 p1 p2 p3 c0 c1 c2 c3 s0 s1 s2 s3 vdd gnd
Xsum0 p0 c0 s0 vdd gnd xor_nand4_x1
Xsum1 p1 c1 s1 vdd gnd xor_nand4_x1
Xsum2 p2 c2 s2 vdd gnd xor_nand4_x1
Xsum3 p3 c3 s3 vdd gnd xor_nand4_x1
.ends sum_xor_nand4_x1
.subckt tb_inv a y vdd gnd
mp y a vdd vdd CMOSP W=1.8e-06 L=1.8e-07 AS=9.72e-13 PS=4.68e-06 AD=9.72e-13 PD=4.68e-06
mn y a gnd gnd CMOSN W=9.0e-07 L=1.8e-07 AS=4.86e-13 PS=2.88e-06 AD=4.86e-13 PD=2.88e-06
.ends
Vp0 src_p0 gnd PWL(
+ 0.00000e+00 1.800 1.28000e-07 1.800 1.28050e-07 0.000 2.58000e-07 0.000 2.58050e-07 1.800 2.59000e-07 1.800
+ 2.59050e-07 0.000 2.60000e-07 0.000 2.60050e-07 1.800 2.61000e-07 1.800 2.61050e-07 0.000 2.64000e-07 0.000
+ 2.64050e-07 1.800 2.65000e-07 1.800 2.65050e-07 0.000 2.68000e-07 0.000 2.68050e-07 1.800 2.69000e-07 1.800
+ 2.69050e-07 0.000 2.70000e-07 0.000 2.70050e-07 1.800 2.72000e-07 1.800 2.72050e-07 0.000 2.73000e-07 0.000
+ 2.73050e-07 1.800 2.74000e-07 1.800 2.74050e-07 0.000 2.75000e-07 0.000 2.75050e-07 1.800 2.76000e-07 1.800
+ 2.76050e-07 0.000 2.78000e-07 0.000 2.78050e-07 1.800 2.79000e-07 1.800 2.79050e-07 0.000 2.80000e-07 0.000
+ 2.80050e-07 1.800 2.81000e-07 1.800 2.81050e-07 0.000 2.82000e-07 0.000 2.82050e-07 1.800 2.86000e-07 1.800
+ 2.86050e-07 0.000 2.88000e-07 0.000 2.88050e-07 1.800 2.89000e-07 1.800 2.89050e-07 0.000 2.95000e-07 0.000
+ 2.95050e-07 1.800 2.96000e-07 1.800 2.96050e-07 0.000 2.98000e-07 0.000 2.98050e-07 1.800 3.00000e-07 1.800
+ 3.00050e-07 0.000 3.02000e-07 0.000 3.02050e-07 1.800 3.04000e-07 1.800 3.04050e-07 0.000 3.05000e-07 0.000
+ 3.05050e-07 1.800 3.06000e-07 1.800 3.06050e-07 0.000 3.07000e-07 0.000 3.07050e-07 1.800 3.09000e-07 1.800
+ 3.09050e-07 0.000 3.11000e-07 0.000 3.11050e-07 1.800 3.12000e-07 1.800 3.12050e-07 0.000 3.14000e-07 0.000
+ 3.14050e-07 1.800 3.16000e-07 1.800 3.16050e-07 0.000 3.17000e-07 0.000 3.17050e-07 1.800 3.18000e-07 1.800
+ 3.18050e-07 0.000 3.19000e-07 0.000 3.19050e-07 1.800 3.20000e-07 1.800 3.20050e-07 0.000 3.21000e-07 0.000
+ 3.21050e-07 1.800 3.24000e-07 1.800 3.24050e-07 0.000 3.25000e-07 0.000 3.25050e-07 1.800 3.30000e-07 1.800
+ 3.30050e-07 0.000 3.31000e-07 0.000 3.31050e-07 1.800 3.33000e-07 1.800 3.33050e-07 0.000 3.34000e-07 0.000
+ 3.34050e-07 1.800 3.37000e-07 1.800 3.37050e-07 0.000 3.39000e-07 0.000 3.39050e-07 1.800 3.42000e-07 1.800
+ 3.42050e-07 0.000 3.43000e-07 0.000 3.43050e-07 1.800 3.44000e-07 1.800 3.44050e-07 0.000 3.45000e-07 0.000
+ 3.45050e-07 1.800 3.50000e-07 1.800 3.50050e-07 0.000 3.52000e-07 0.000 3.52050e-07 1.800 3.53000e-07 1.800
+ 3.53050e-07 0.000 3.57000e-07 0.000 3.57050e-07 1.800 3.59000e-07 1.800 3.59050e-07 0.000 3.60000e-07 0.000
+ 3.60050e-07 1.800 3.61000e-07 1.800 3.61050e-07 0.000 3.62000e-07 0.000 3.62050e-07 1.800 3.63000e-07 1.800
+ 3.63050e-07 0.000 3.65000e-07 0.000 3.65050e-07 1.800 3.67000e-07 1.800 3.67050e-07 0.000 3.71000e-07 0.000
+ 3.71050e-07 1.800 3.73000e-07 1.800 3.73050e-07 0.000 3.75000e-07 0.000 3.75050e-07 1.800 3.76000e-07 1.800
+ 3.76050e-07 0.000 3.78000e-07 0.000 3.78050e-07 1.800 3.79000e-07 1.800 3.79050e-07 0.000 3.80000e-07 0.000
+ 3.80050e-07 1.800 3.89000e-07 1.800 3.89050e-07 0.000 3.91000e-07 0.000 3.91050e-07 1.800 3.92000e-07 1.800
+ 3.92050e-07 0.000 3.97000e-07 0.000 3.97050e-07 1.800 3.99000e-07 1.800 3.99050e-07 0.000 4.02000e-07 0.000
+ 4.02050e-07 1.800 4.03000e-07 1.800 4.03050e-07 0.000 4.04000e-07 0.000 4.04050e-07 1.800 4.06000e-07 1.800
+ 4.06050e-07 0.000 4.08000e-07 0.000 4.08050e-07 1.800 4.10000e-07 1.800 4.10050e-07 0.000 4.12000e-07 0.000
+ 4.12050e-07 1.800 4.14000e-07 1.800 4.14050e-07 0.000 4.16000e-07 0.000 4.16050e-07 1.800 4.18000e-07 1.800
+ 4.18050e-07 0.000 4.19000e-07 0.000 4.19050e-07 1.800 4.21000e-07 1.800 4.21050e-07 0.000 4.22000e-07 0.000
+ 4.22050e-07 1.800 4.26000e-07 1.800 4.26050e-07 0.000 4.27000e-07 0.000 4.27050e-07 1.800 4.28000e-07 1.800
+ 4.28050e-07 0.000 4.29000e-07 0.000 4.29050e-07 1.800 4.30000e-07 1.800 4.30050e-07 0.000 4.31000e-07 0.000
+ 4.31050e-07 1.800 4.34000e-07 1.800 4.34050e-07 0.000 4.39000e-07 0.000 4.39050e-07 1.800 4.40000e-07 1.800
+ 4.40050e-07 0.000 4.41000e-07 0.000 4.41050e-07 1.800 4.42000e-07 1.800 4.42050e-07 0.000 4.44000e-07 0.000
+ 4.44050e-07 1.800 4.46000e-07 1.800 4.46050e-07 0.000 4.48000e-07 0.000 4.48050e-07 1.800 4.49000e-07 1.800
+ 4.49050e-07 0.000 4.50000e-07 0.000 4.50050e-07 1.800 4.52000e-07 1.800 4.52050e-07 0.000 4.56000e-07 0.000
+ 4.56050e-07 1.800 4.58000e-07 1.800 4.58050e-07 0.000 4.60000e-07 0.000 4.60050e-07 1.800 4.61000e-07 1.800
+ 4.61050e-07 0.000 4.62000e-07 0.000 4.62050e-07 1.800 4.63000e-07 1.800 4.63050e-07 0.000 4.66000e-07 0.000
+ 4.66050e-07 1.800 4.68000e-07 1.800 4.68050e-07 0.000 4.70000e-07 0.000 4.70050e-07 1.800 4.71000e-07 1.800
+ 4.71050e-07 0.000 4.73000e-07 0.000 4.73050e-07 1.800 4.75000e-07 1.800 4.75050e-07 0.000 4.76000e-07 0.000
+ 4.76050e-07 1.800 4.78000e-07 1.800 4.78050e-07 0.000 4.79000e-07 0.000 4.79050e-07 1.800 4.80000e-07 1.800
+ 4.80050e-07 0.000 4.83000e-07 0.000 4.83050e-07 1.800 4.84000e-07 1.800 4.84050e-07 0.000 4.85000e-07 0.000
+ 4.85050e-07 1.800 4.86000e-07 1.800 4.86050e-07 0.000 4.89000e-07 0.000 4.89050e-07 1.800 4.91000e-07 1.800
+ 4.91050e-07 0.000 4.93000e-07 0.000 4.93050e-07 1.800 4.97000e-07 1.800 4.97050e-07 0.000 4.98000e-07 0.000
+ 4.98050e-07 1.800 4.99000e-07 1.800 4.99050e-07 0.000 5.00000e-07 0.000 5.00050e-07 1.800 5.02000e-07 1.800
+ 5.02050e-07 0.000 5.03000e-07 0.000 5.03050e-07 1.800 5.07000e-07 1.800 5.07050e-07 0.000 5.11000e-07 0.000
+ 5.11050e-07 1.800 5.12000e-07 1.800
+ )
Xd_p0 src_p0 p0 vdd gnd tb_inv
Vp1 src_p1 gnd PWL(
+ 0.00000e+00 1.800 6.40000e-08 1.800 6.40500e-08 0.000 1.28000e-07 0.000 1.28050e-07 1.800 1.92000e-07 1.800
+ 1.92050e-07 0.000 2.59000e-07 0.000 2.59050e-07 1.800 2.61000e-07 1.800 2.61050e-07 0.000 2.65000e-07 0.000
+ 2.65050e-07 1.800 2.72000e-07 1.800 2.72050e-07 0.000 2.73000e-07 0.000 2.73050e-07 1.800 2.74000e-07 1.800
+ 2.74050e-07 0.000 2.76000e-07 0.000 2.76050e-07 1.800 2.79000e-07 1.800 2.79050e-07 0.000 2.87000e-07 0.000
+ 2.87050e-07 1.800 2.91000e-07 1.800 2.91050e-07 0.000 2.92000e-07 0.000 2.92050e-07 1.800 2.95000e-07 1.800
+ 2.95050e-07 0.000 2.96000e-07 0.000 2.96050e-07 1.800 2.97000e-07 1.800 2.97050e-07 0.000 2.98000e-07 0.000
+ 2.98050e-07 1.800 2.99000e-07 1.800 2.99050e-07 0.000 3.00000e-07 0.000 3.00050e-07 1.800 3.01000e-07 1.800
+ 3.01050e-07 0.000 3.03000e-07 0.000 3.03050e-07 1.800 3.04000e-07 1.800 3.04050e-07 0.000 3.06000e-07 0.000
+ 3.06050e-07 1.800 3.09000e-07 1.800 3.09050e-07 0.000 3.14000e-07 0.000 3.14050e-07 1.800 3.16000e-07 1.800
+ 3.16050e-07 0.000 3.19000e-07 0.000 3.19050e-07 1.800 3.21000e-07 1.800 3.21050e-07 0.000 3.22000e-07 0.000
+ 3.22050e-07 1.800 3.25000e-07 1.800 3.25050e-07 0.000 3.30000e-07 0.000 3.30050e-07 1.800 3.35000e-07 1.800
+ 3.35050e-07 0.000 3.37000e-07 0.000 3.37050e-07 1.800 3.38000e-07 1.800 3.38050e-07 0.000 3.39000e-07 0.000
+ 3.39050e-07 1.800 3.44000e-07 1.800 3.44050e-07 0.000 3.45000e-07 0.000 3.45050e-07 1.800 3.47000e-07 1.800
+ 3.47050e-07 0.000 3.48000e-07 0.000 3.48050e-07 1.800 3.53000e-07 1.800 3.53050e-07 0.000 3.54000e-07 0.000
+ 3.54050e-07 1.800 3.56000e-07 1.800 3.56050e-07 0.000 3.57000e-07 0.000 3.57050e-07 1.800 3.58000e-07 1.800
+ 3.58050e-07 0.000 3.59000e-07 0.000 3.59050e-07 1.800 3.60000e-07 1.800 3.60050e-07 0.000 3.61000e-07 0.000
+ 3.61050e-07 1.800 3.65000e-07 1.800 3.65050e-07 0.000 3.69000e-07 0.000 3.69050e-07 1.800 3.70000e-07 1.800
+ 3.70050e-07 0.000 3.71000e-07 0.000 3.71050e-07 1.800 3.72000e-07 1.800 3.72050e-07 0.000 3.73000e-07 0.000
+ 3.73050e-07 1.800 3.75000e-07 1.800 3.75050e-07 0.000 3.76000e-07 0.000 3.76050e-07 1.800 3.78000e-07 1.800
+ 3.78050e-07 0.000 3.80000e-07 0.000 3.80050e-07 1.800 3.81000e-07 1.800 3.81050e-07 0.000 3.82000e-07 0.000
+ 3.82050e-07 1.800 3.84000e-07 1.800 3.84050e-07 0.000 3.85000e-07 0.000 3.85050e-07 1.800 3.87000e-07 1.800
+ 3.87050e-07 0.000 3.88000e-07 0.000 3.88050e-07 1.800 3.89000e-07 1.800 3.89050e-07 0.000 3.93000e-07 0.000
+ 3.93050e-07 1.800 3.94000e-07 1.800 3.94050e-07 0.000 3.97000e-07 0.000 3.97050e-07 1.800 3.99000e-07 1.800
+ 3.99050e-07 0.000 4.00000e-07 0.000 4.00050e-07 1.800 4.04000e-07 1.800 4.04050e-07 0.000 4.05000e-07 0.000
+ 4.05050e-07 1.800 4.06000e-07 1.800 4.06050e-07 0.000 4.11000e-07 0.000 4.11050e-07 1.800 4.15000e-07 1.800
+ 4.15050e-07 0.000 4.16000e-07 0.000 4.16050e-07 1.800 4.17000e-07 1.800 4.17050e-07 0.000 4.18000e-07 0.000
+ 4.18050e-07 1.800 4.19000e-07 1.800 4.19050e-07 0.000 4.20000e-07 0.000 4.20050e-07 1.800 4.21000e-07 1.800
+ 4.21050e-07 0.000 4.23000e-07 0.000 4.23050e-07 1.800 4.24000e-07 1.800 4.24050e-07 0.000 4.25000e-07 0.000
+ 4.25050e-07 1.800 4.27000e-07 1.800 4.27050e-07 0.000 4.28000e-07 0.000 4.28050e-07 1.800 4.29000e-07 1.800
+ 4.29050e-07 0.000 4.30000e-07 0.000 4.30050e-07 1.800 4.31000e-07 1.800 4.31050e-07 0.000 4.33000e-07 0.000
+ 4.33050e-07 1.800 4.36000e-07 1.800 4.36050e-07 0.000 4.37000e-07 0.000 4.37050e-07 1.800 4.39000e-07 1.800
+ 4.39050e-07 0.000 4.43000e-07 0.000 4.43050e-07 1.800 4.48000e-07 1.800 4.48050e-07 0.000 4.54000e-07 0.000
+ 4.54050e-07 1.800 4.55000e-07 1.800 4.55050e-07 0.000 4.57000e-07 0.000 4.57050e-07 1.800 4.59000e-07 1.800
+ 4.59050e-07 0.000 4.62000e-07 0.000 4.62050e-07 1.800 4.64000e-07 1.800 4.64050e-07 0.000 4.65000e-07 0.000
+ 4.65050e-07 1.800 4.66000e-07 1.800 4.66050e-07 0.000 4.67000e-07 0.000 4.67050e-07 1.800 4.69000e-07 1.800
+ 4.69050e-07 0.000 4.70000e-07 0.000 4.70050e-07 1.800 4.72000e-07 1.800 4.72050e-07 0.000 4.73000e-07 0.000
+ 4.73050e-07 1.800 4.75000e-07 1.800 4.75050e-07 0.000 4.77000e-07 0.000 4.77050e-07 1.800 4.80000e-07 1.800
+ 4.80050e-07 0.000 4.81000e-07 0.000 4.81050e-07 1.800 4.82000e-07 1.800 4.82050e-07 0.000 4.84000e-07 0.000
+ 4.84050e-07 1.800 4.86000e-07 1.800 4.86050e-07 0.000 4.88000e-07 0.000 4.88050e-07 1.800 4.89000e-07 1.800
+ 4.89050e-07 0.000 4.93000e-07 0.000 4.93050e-07 1.800 4.94000e-07 1.800 4.94050e-07 0.000 4.95000e-07 0.000
+ 4.95050e-07 1.800 4.97000e-07 1.800 4.97050e-07 0.000 4.99000e-07 0.000 4.99050e-07 1.800 5.00000e-07 1.800
+ 5.00050e-07 0.000 5.04000e-07 0.000 5.04050e-07 1.800 5.05000e-07 1.800 5.05050e-07 0.000 5.06000e-07 0.000
+ 5.06050e-07 1.800 5.07000e-07 1.800 5.07050e-07 0.000 5.10000e-07 0.000 5.10050e-07 1.800 5.11000e-07 1.800
+ 5.11050e-07 0.000 5.12000e-07 0.000
+ )
Xd_p1 src_p1 p1 vdd gnd tb_inv
Vp2 src_p2 gnd PWL(
+ 0.00000e+00 1.800 3.20000e-08 1.800 3.20500e-08 0.000 6.40000e-08 0.000 6.40500e-08 1.800 9.60000e-08 1.800
+ 9.60500e-08 0.000 1.28000e-07 0.000 1.28050e-07 1.800 1.60000e-07 1.800 1.60050e-07 0.000 1.92000e-07 0.000
+ 1.92050e-07 1.800 2.24000e-07 1.800 2.24050e-07 0.000 2.58000e-07 0.000 2.58050e-07 1.800 2.59000e-07 1.800
+ 2.59050e-07 0.000 2.60000e-07 0.000 2.60050e-07 1.800 2.62000e-07 1.800 2.62050e-07 0.000 2.63000e-07 0.000
+ 2.63050e-07 1.800 2.64000e-07 1.800 2.64050e-07 0.000 2.67000e-07 0.000 2.67050e-07 1.800 2.71000e-07 1.800
+ 2.71050e-07 0.000 2.72000e-07 0.000 2.72050e-07 1.800 2.74000e-07 1.800 2.74050e-07 0.000 2.77000e-07 0.000
+ 2.77050e-07 1.800 2.78000e-07 1.800 2.78050e-07 0.000 2.79000e-07 0.000 2.79050e-07 1.800 2.81000e-07 1.800
+ 2.81050e-07 0.000 2.82000e-07 0.000 2.82050e-07 1.800 2.84000e-07 1.800 2.84050e-07 0.000 2.85000e-07 0.000
+ 2.85050e-07 1.800 2.87000e-07 1.800 2.87050e-07 0.000 2.90000e-07 0.000 2.90050e-07 1.800 2.92000e-07 1.800
+ 2.92050e-07 0.000 2.93000e-07 0.000 2.93050e-07 1.800 2.94000e-07 1.800 2.94050e-07 0.000 2.95000e-07 0.000
+ 2.95050e-07 1.800 2.97000e-07 1.800 2.97050e-07 0.000 2.98000e-07 0.000 2.98050e-07 1.800 3.02000e-07 1.800
+ 3.02050e-07 0.000 3.05000e-07 0.000 3.05050e-07 1.800 3.07000e-07 1.800 3.07050e-07 0.000 3.08000e-07 0.000
+ 3.08050e-07 1.800 3.09000e-07 1.800 3.09050e-07 0.000 3.11000e-07 0.000 3.11050e-07 1.800 3.13000e-07 1.800
+ 3.13050e-07 0.000 3.14000e-07 0.000 3.14050e-07 1.800 3.15000e-07 1.800 3.15050e-07 0.000 3.16000e-07 0.000
+ 3.16050e-07 1.800 3.17000e-07 1.800 3.17050e-07 0.000 3.21000e-07 0.000 3.21050e-07 1.800 3.22000e-07 1.800
+ 3.22050e-07 0.000 3.24000e-07 0.000 3.24050e-07 1.800 3.25000e-07 1.800 3.25050e-07 0.000 3.27000e-07 0.000
+ 3.27050e-07 1.800 3.28000e-07 1.800 3.28050e-07 0.000 3.29000e-07 0.000 3.29050e-07 1.800 3.30000e-07 1.800
+ 3.30050e-07 0.000 3.31000e-07 0.000 3.31050e-07 1.800 3.33000e-07 1.800 3.33050e-07 0.000 3.37000e-07 0.000
+ 3.37050e-07 1.800 3.39000e-07 1.800 3.39050e-07 0.000 3.40000e-07 0.000 3.40050e-07 1.800 3.41000e-07 1.800
+ 3.41050e-07 0.000 3.42000e-07 0.000 3.42050e-07 1.800 3.43000e-07 1.800 3.43050e-07 0.000 3.44000e-07 0.000
+ 3.44050e-07 1.800 3.49000e-07 1.800 3.49050e-07 0.000 3.50000e-07 0.000 3.50050e-07 1.800 3.53000e-07 1.800
+ 3.53050e-07 0.000 3.56000e-07 0.000 3.56050e-07 1.800 3.58000e-07 1.800 3.58050e-07 0.000 3.60000e-07 0.000
+ 3.60050e-07 1.800 3.62000e-07 1.800 3.62050e-07 0.000 3.63000e-07 0.000 3.63050e-07 1.800 3.67000e-07 1.800
+ 3.67050e-07 0.000 3.75000e-07 0.000 3.75050e-07 1.800 3.76000e-07 1.800 3.76050e-07 0.000 3.78000e-07 0.000
+ 3.78050e-07 1.800 3.80000e-07 1.800 3.80050e-07 0.000 3.83000e-07 0.000 3.83050e-07 1.800 3.84000e-07 1.800
+ 3.84050e-07 0.000 3.88000e-07 0.000 3.88050e-07 1.800 3.89000e-07 1.800 3.89050e-07 0.000 3.91000e-07 0.000
+ 3.91050e-07 1.800 3.94000e-07 1.800 3.94050e-07 0.000 3.95000e-07 0.000 3.95050e-07 1.800 3.97000e-07 1.800
+ 3.97050e-07 0.000 3.98000e-07 0.000 3.98050e-07 1.800 4.00000e-07 1.800 4.00050e-07 0.000 4.01000e-07 0.000
+ 4.01050e-07 1.800 4.02000e-07 1.800 4.02050e-07 0.000 4.03000e-07 0.000 4.03050e-07 1.800 4.06000e-07 1.800
+ 4.06050e-07 0.000 4.07000e-07 0.000 4.07050e-07 1.800 4.08000e-07 1.800 4.08050e-07 0.000 4.09000e-07 0.000
+ 4.09050e-07 1.800 4.10000e-07 1.800 4.10050e-07 0.000 4.11000e-07 0.000 4.11050e-07 1.800 4.12000e-07 1.800
+ 4.12050e-07 0.000 4.13000e-07 0.000 4.13050e-07 1.800 4.20000e-07 1.800 4.20050e-07 0.000 4.21000e-07 0.000
+ 4.21050e-07 1.800 4.22000e-07 1.800 4.22050e-07 0.000 4.25000e-07 0.000 4.25050e-07 1.800 4.26000e-07 1.800
+ 4.26050e-07 0.000 4.30000e-07 0.000 4.30050e-07 1.800 4.33000e-07 1.800 4.33050e-07 0.000 4.35000e-07 0.000
+ 4.35050e-07 1.800 4.38000e-07 1.800 4.38050e-07 0.000 4.39000e-07 0.000 4.39050e-07 1.800 4.40000e-07 1.800
+ 4.40050e-07 0.000 4.41000e-07 0.000 4.41050e-07 1.800 4.43000e-07 1.800 4.43050e-07 0.000 4.45000e-07 0.000
+ 4.45050e-07 1.800 4.46000e-07 1.800 4.46050e-07 0.000 4.47000e-07 0.000 4.47050e-07 1.800 4.48000e-07 1.800
+ 4.48050e-07 0.000 4.49000e-07 0.000 4.49050e-07 1.800 4.51000e-07 1.800 4.51050e-07 0.000 4.53000e-07 0.000
+ 4.53050e-07 1.800 4.54000e-07 1.800 4.54050e-07 0.000 4.56000e-07 0.000 4.56050e-07 1.800 4.57000e-07 1.800
+ 4.57050e-07 0.000 4.58000e-07 0.000 4.58050e-07 1.800 4.59000e-07 1.800 4.59050e-07 0.000 4.63000e-07 0.000
+ 4.63050e-07 1.800 4.65000e-07 1.800 4.65050e-07 0.000 4.70000e-07 0.000 4.70050e-07 1.800 4.72000e-07 1.800
+ 4.72050e-07 0.000 4.73000e-07 0.000 4.73050e-07 1.800 4.75000e-07 1.800 4.75050e-07 0.000 4.76000e-07 0.000
+ 4.76050e-07 1.800 4.79000e-07 1.800 4.79050e-07 0.000 4.85000e-07 0.000 4.85050e-07 1.800 4.87000e-07 1.800
+ 4.87050e-07 0.000 4.88000e-07 0.000 4.88050e-07 1.800 4.89000e-07 1.800 4.89050e-07 0.000 4.91000e-07 0.000
+ 4.91050e-07 1.800 4.92000e-07 1.800 4.92050e-07 0.000 4.93000e-07 0.000 4.93050e-07 1.800 4.94000e-07 1.800
+ 4.94050e-07 0.000 4.95000e-07 0.000 4.95050e-07 1.800 4.96000e-07 1.800 4.96050e-07 0.000 4.97000e-07 0.000
+ 4.97050e-07 1.800 4.98000e-07 1.800 4.98050e-07 0.000 5.02000e-07 0.000 5.02050e-07 1.800 5.03000e-07 1.800
+ 5.03050e-07 0.000 5.04000e-07 0.000 5.04050e-07 1.800 5.12000e-07 1.800
+ )
Xd_p2 src_p2 p2 vdd gnd tb_inv
Vp3 src_p3 gnd PWL(
+ 0.00000e+00 1.800 1.60000e-08 1.800 1.60500e-08 0.000 3.20000e-08 0.000 3.20500e-08 1.800 4.80000e-08 1.800
+ 4.80500e-08 0.000 6.40000e-08 0.000 6.40500e-08 1.800 8.00000e-08 1.800 8.00500e-08 0.000 9.60000e-08 0.000
+ 9.60500e-08 1.800 1.12000e-07 1.800 1.12050e-07 0.000 1.28000e-07 0.000 1.28050e-07 1.800 1.44000e-07 1.800
+ 1.44050e-07 0.000 1.60000e-07 0.000 1.60050e-07 1.800 1.76000e-07 1.800 1.76050e-07 0.000 1.92000e-07 0.000
+ 1.92050e-07 1.800 2.08000e-07 1.800 2.08050e-07 0.000 2.24000e-07 0.000 2.24050e-07 1.800 2.40000e-07 1.800
+ 2.40050e-07 0.000 2.56000e-07 0.000 2.56050e-07 1.800 2.57000e-07 1.800 2.57050e-07 0.000 2.58000e-07 0.000
+ 2.58050e-07 1.800 2.59000e-07 1.800 2.59050e-07 0.000 2.60000e-07 0.000 2.60050e-07 1.800 2.61000e-07 1.800
+ 2.61050e-07 0.000 2.62000e-07 0.000 2.62050e-07 1.800 2.63000e-07 1.800 2.63050e-07 0.000 2.69000e-07 0.000
+ 2.69050e-07 1.800 2.70000e-07 1.800 2.70050e-07 0.000 2.71000e-07 0.000 2.71050e-07 1.800 2.73000e-07 1.800
+ 2.73050e-07 0.000 2.74000e-07 0.000 2.74050e-07 1.800 2.76000e-07 1.800 2.76050e-07 0.000 2.78000e-07 0.000
+ 2.78050e-07 1.800 2.80000e-07 1.800 2.80050e-07 0.000 2.83000e-07 0.000 2.83050e-07 1.800 2.84000e-07 1.800
+ 2.84050e-07 0.000 2.86000e-07 0.000 2.86050e-07 1.800 2.87000e-07 1.800 2.87050e-07 0.000 2.91000e-07 0.000
+ 2.91050e-07 1.800 2.93000e-07 1.800 2.93050e-07 0.000 2.95000e-07 0.000 2.95050e-07 1.800 2.98000e-07 1.800
+ 2.98050e-07 0.000 3.00000e-07 0.000 3.00050e-07 1.800 3.02000e-07 1.800 3.02050e-07 0.000 3.07000e-07 0.000
+ 3.07050e-07 1.800 3.11000e-07 1.800 3.11050e-07 0.000 3.14000e-07 0.000 3.14050e-07 1.800 3.15000e-07 1.800
+ 3.15050e-07 0.000 3.18000e-07 0.000 3.18050e-07 1.800 3.21000e-07 1.800 3.21050e-07 0.000 3.25000e-07 0.000
+ 3.25050e-07 1.800 3.27000e-07 1.800 3.27050e-07 0.000 3.29000e-07 0.000 3.29050e-07 1.800 3.31000e-07 1.800
+ 3.31050e-07 0.000 3.33000e-07 0.000 3.33050e-07 1.800 3.35000e-07 1.800 3.35050e-07 0.000 3.36000e-07 0.000
+ 3.36050e-07 1.800 3.37000e-07 1.800 3.37050e-07 0.000 3.38000e-07 0.000 3.38050e-07 1.800 3.40000e-07 1.800
+ 3.40050e-07 0.000 3.41000e-07 0.000 3.41050e-07 1.800 3.43000e-07 1.800 3.43050e-07 0.000 3.45000e-07 0.000
+ 3.45050e-07 1.800 3.47000e-07 1.800 3.47050e-07 0.000 3.48000e-07 0.000 3.48050e-07 1.800 3.51000e-07 1.800
+ 3.51050e-07 0.000 3.53000e-07 0.000 3.53050e-07 1.800 3.56000e-07 1.800 3.56050e-07 0.000 3.58000e-07 0.000
+ 3.58050e-07 1.800 3.59000e-07 1.800 3.59050e-07 0.000 3.60000e-07 0.000 3.60050e-07 1.800 3.63000e-07 1.800
+ 3.63050e-07 0.000 3.65000e-07 0.000 3.65050e-07 1.800 3.69000e-07 1.800 3.69050e-07 0.000 3.71000e-07 0.000
+ 3.71050e-07 1.800 3.77000e-07 1.800 3.77050e-07 0.000 3.78000e-07 0.000 3.78050e-07 1.800 3.79000e-07 1.800
+ 3.79050e-07 0.000 3.80000e-07 0.000 3.80050e-07 1.800 3.82000e-07 1.800 3.82050e-07 0.000 3.83000e-07 0.000
+ 3.83050e-07 1.800 3.85000e-07 1.800 3.85050e-07 0.000 3.86000e-07 0.000 3.86050e-07 1.800 3.91000e-07 1.800
+ 3.91050e-07 0.000 3.92000e-07 0.000 3.92050e-07 1.800 3.94000e-07 1.800 3.94050e-07 0.000 3.95000e-07 0.000
+ 3.95050e-07 1.800 3.96000e-07 1.800 3.96050e-07 0.000 3.98000e-07 0.000 3.98050e-07 1.800 3.99000e-07 1.800
+ 3.99050e-07 0.000 4.02000e-07 0.000 4.02050e-07 1.800 4.03000e-07 1.800 4.03050e-07 0.000 4.04000e-07 0.000
+ 4.04050e-07 1.800 4.06000e-07 1.800 4.06050e-07 0.000 4.10000e-07 0.000 4.10050e-07 1.800 4.13000e-07 1.800
+ 4.13050e-07 0.000 4.14000e-07 0.000 4.14050e-07 1.800 4.16000e-07 1.800 4.16050e-07 0.000 4.18000e-07 0.000
+ 4.18050e-07 1.800 4.19000e-07 1.800 4.19050e-07 0.000 4.20000e-07 0.000 4.20050e-07 1.800 4.23000e-07 1.800
+ 4.23050e-07 0.000 4.25000e-07 0.000 4.25050e-07 1.800 4.28000e-07 1.800 4.28050e-07 0.000 4.31000e-07 0.000
+ 4.31050e-07 1.800 4.33000e-07 1.800 4.33050e-07 0.000 4.34000e-07 0.000 4.34050e-07 1.800 4.36000e-07 1.800
+ 4.36050e-07 0.000 4.37000e-07 0.000 4.37050e-07 1.800 4.38000e-07 1.800 4.38050e-07 0.000 4.41000e-07 0.000
+ 4.41050e-07 1.800 4.42000e-07 1.800 4.42050e-07 0.000 4.43000e-07 0.000 4.43050e-07 1.800 4.45000e-07 1.800
+ 4.45050e-07 0.000 4.46000e-07 0.000 4.46050e-07 1.800 4.49000e-07 1.800 4.49050e-07 0.000 4.50000e-07 0.000
+ 4.50050e-07 1.800 4.51000e-07 1.800 4.51050e-07 0.000 4.53000e-07 0.000 4.53050e-07 1.800 4.55000e-07 1.800
+ 4.55050e-07 0.000 4.58000e-07 0.000 4.58050e-07 1.800 4.59000e-07 1.800 4.59050e-07 0.000 4.61000e-07 0.000
+ 4.61050e-07 1.800 4.62000e-07 1.800 4.62050e-07 0.000 4.63000e-07 0.000 4.63050e-07 1.800 4.64000e-07 1.800
+ 4.64050e-07 0.000 4.66000e-07 0.000 4.66050e-07 1.800 4.67000e-07 1.800 4.67050e-07 0.000 4.68000e-07 0.000
+ 4.68050e-07 1.800 4.69000e-07 1.800 4.69050e-07 0.000 4.70000e-07 0.000 4.70050e-07 1.800 4.72000e-07 1.800
+ 4.72050e-07 0.000 4.73000e-07 0.000 4.73050e-07 1.800 4.76000e-07 1.800 4.76050e-07 0.000 4.85000e-07 0.000
+ 4.85050e-07 1.800 4.87000e-07 1.800 4.87050e-07 0.000 4.89000e-07 0.000 4.89050e-07 1.800 4.91000e-07 1.800
+ 4.91050e-07 0.000 4.92000e-07 0.000 4.92050e-07 1.800 4.94000e-07 1.800 4.94050e-07 0.000 4.97000e-07 0.000
+ 4.97050e-07 1.800 5.00000e-07 1.800 5.00050e-07 0.000 5.02000e-07 0.000 5.02050e-07 1.800 5.03000e-07 1.800
+ 5.03050e-07 0.000 5.05000e-07 0.000 5.05050e-07 1.800 5.06000e-07 1.800 5.06050e-07 0.000 5.07000e-07 0.000
+ 5.07050e-07 1.800 5.09000e-07 1.800 5.09050e-07 0.000 5.11000e-07 0.000 5.11050e-07 1.800 5.12000e-07 1.800
+ )
Xd_p3 src_p3 p3 vdd gnd tb_inv
Vc0 src_c0 gnd PWL(
+ 0.00000e+00 1.800 8.00000e-09 1.800 8.05000e-09 0.000 1.60000e-08 0.000 1.60500e-08 1.800 2.40000e-08 1.800
+ 2.40500e-08 0.000 3.20000e-08 0.000 3.20500e-08 1.800 4.00000e-08 1.800 4.00500e-08 0.000 4.80000e-08 0.000
+ 4.80500e-08 1.800 5.60000e-08 1.800 5.60500e-08 0.000 6.40000e-08 0.000 6.40500e-08 1.800 7.20000e-08 1.800
+ 7.20500e-08 0.000 8.00000e-08 0.000 8.00500e-08 1.800 8.80000e-08 1.800 8.80500e-08 0.000 9.60000e-08 0.000
+ 9.60500e-08 1.800 1.04000e-07 1.800 1.04050e-07 0.000 1.12000e-07 0.000 1.12050e-07 1.800 1.20000e-07 1.800
+ 1.20050e-07 0.000 1.28000e-07 0.000 1.28050e-07 1.800 1.36000e-07 1.800 1.36050e-07 0.000 1.44000e-07 0.000
+ 1.44050e-07 1.800 1.52000e-07 1.800 1.52050e-07 0.000 1.60000e-07 0.000 1.60050e-07 1.800 1.68000e-07 1.800
+ 1.68050e-07 0.000 1.76000e-07 0.000 1.76050e-07 1.800 1.84000e-07 1.800 1.84050e-07 0.000 1.92000e-07 0.000
+ 1.92050e-07 1.800 2.00000e-07 1.800 2.00050e-07 0.000 2.08000e-07 0.000 2.08050e-07 1.800 2.16000e-07 1.800
+ 2.16050e-07 0.000 2.24000e-07 0.000 2.24050e-07 1.800 2.32000e-07 1.800 2.32050e-07 0.000 2.40000e-07 0.000
+ 2.40050e-07 1.800 2.48000e-07 1.800 2.48050e-07 0.000 2.58000e-07 0.000 2.58050e-07 1.800 2.60000e-07 1.800
+ 2.60050e-07 0.000 2.61000e-07 0.000 2.61050e-07 1.800 2.62000e-07 1.800 2.62050e-07 0.000 2.64000e-07 0.000
+ 2.64050e-07 1.800 2.65000e-07 1.800 2.65050e-07 0.000 2.66000e-07 0.000 2.66050e-07 1.800 2.67000e-07 1.800
+ 2.67050e-07 0.000 2.68000e-07 0.000 2.68050e-07 1.800 2.77000e-07 1.800 2.77050e-07 0.000 2.79000e-07 0.000
+ 2.79050e-07 1.800 2.80000e-07 1.800 2.80050e-07 0.000 2.81000e-07 0.000 2.81050e-07 1.800 2.83000e-07 1.800
+ 2.83050e-07 0.000 2.84000e-07 0.000 2.84050e-07 1.800 2.86000e-07 1.800 2.86050e-07 0.000 2.88000e-07 0.000
+ 2.88050e-07 1.800 2.89000e-07 1.800 2.89050e-07 0.000 2.92000e-07 0.000 2.92050e-07 1.800 2.93000e-07 1.800
+ 2.93050e-07 0.000 2.94000e-07 0.000 2.94050e-07 1.800 2.96000e-07 1.800 2.96050e-07 0.000 2.97000e-07 0.000
+ 2.97050e-07 1.800 2.98000e-07 1.800 2.98050e-07 0.000 3.03000e-07 0.000 3.03050e-07 1.800 3.04000e-07 1.800
+ 3.04050e-07 0.000 3.07000e-07 0.000 3.07050e-07 1.800 3.08000e-07 1.800 3.08050e-07 0.000 3.11000e-07 0.000
+ 3.11050e-07 1.800 3.12000e-07 1.800 3.12050e-07 0.000 3.15000e-07 0.000 3.15050e-07 1.800 3.16000e-07 1.800
+ 3.16050e-07 0.000 3.19000e-07 0.000 3.19050e-07 1.800 3.22000e-07 1.800 3.22050e-07 0.000 3.27000e-07 0.000
+ 3.27050e-07 1.800 3.33000e-07 1.800 3.33050e-07 0.000 3.34000e-07 0.000 3.34050e-07 1.800 3.40000e-07 1.800
+ 3.40050e-07 0.000 3.41000e-07 0.000 3.41050e-07 1.800 3.43000e-07 1.800 3.43050e-07 0.000 3.44000e-07 0.000
+ 3.44050e-07 1.800 3.45000e-07 1.800 3.45050e-07 0.000 3.47000e-07 0.000 3.47050e-07 1.800 3.50000e-07 1.800
+ 3.50050e-07 0.000 3.51000e-07 0.000 3.51050e-07 1.800 3.54000e-07 1.800 3.54050e-07 0.000 3.55000e-07 0.000
+ 3.55050e-07 1.800 3.56000e-07 1.800 3.56050e-07 0.000 3.58000e-07 0.000 3.58050e-07 1.800 3.59000e-07 1.800
+ 3.59050e-07 0.000 3.63000e-07 0.000 3.63050e-07 1.800 3.65000e-07 1.800 3.65050e-07 0.000 3.66000e-07 0.000
+ 3.66050e-07 1.800 3.67000e-07 1.800 3.67050e-07 0.000 3.68000e-07 0.000 3.68050e-07 1.800 3.69000e-07 1.800
+ 3.69050e-07 0.000 3.70000e-07 0.000 3.70050e-07 1.800 3.71000e-07 1.800 3.71050e-07 0.000 3.73000e-07 0.000
+ 3.73050e-07 1.800 3.74000e-07 1.800 3.74050e-07 0.000 3.75000e-07 0.000 3.75050e-07 1.800 3.76000e-07 1.800
+ 3.76050e-07 0.000 3.78000e-07 0.000 3.78050e-07 1.800 3.80000e-07 1.800 3.80050e-07 0.000 3.85000e-07 0.000
+ 3.85050e-07 1.800 3.91000e-07 1.800 3.91050e-07 0.000 3.93000e-07 0.000 3.93050e-07 1.800 3.94000e-07 1.800
+ 3.94050e-07 0.000 3.95000e-07 0.000 3.95050e-07 1.800 3.99000e-07 1.800 3.99050e-07 0.000 4.00000e-07 0.000
+ 4.00050e-07 1.800 4.02000e-07 1.800 4.02050e-07 0.000 4.06000e-07 0.000 4.06050e-07 1.800 4.08000e-07 1.800
+ 4.08050e-07 0.000 4.11000e-07 0.000 4.11050e-07 1.800 4.12000e-07 1.800 4.12050e-07 0.000 4.14000e-07 0.000
+ 4.14050e-07 1.800 4.15000e-07 1.800 4.15050e-07 0.000 4.16000e-07 0.000 4.16050e-07 1.800 4.17000e-07 1.800
+ 4.17050e-07 0.000 4.21000e-07 0.000 4.21050e-07 1.800 4.23000e-07 1.800 4.23050e-07 0.000 4.27000e-07 0.000
+ 4.27050e-07 1.800 4.29000e-07 1.800 4.29050e-07 0.000 4.30000e-07 0.000 4.30050e-07 1.800 4.31000e-07 1.800
+ 4.31050e-07 0.000 4.33000e-07 0.000 4.33050e-07 1.800 4.34000e-07 1.800 4.34050e-07 0.000 4.35000e-07 0.000
+ 4.35050e-07 1.800 4.40000e-07 1.800 4.40050e-07 0.000 4.42000e-07 0.000 4.42050e-07 1.800 4.44000e-07 1.800
+ 4.44050e-07 0.000 4.46000e-07 0.000 4.46050e-07 1.800 4.47000e-07 1.800 4.47050e-07 0.000 4.51000e-07 0.000
+ 4.51050e-07 1.800 4.53000e-07 1.800 4.53050e-07 0.000 4.55000e-07 0.000 4.55050e-07 1.800 4.56000e-07 1.800
+ 4.56050e-07 0.000 4.59000e-07 0.000 4.59050e-07 1.800 4.62000e-07 1.800 4.62050e-07 0.000 4.63000e-07 0.000
+ 4.63050e-07 1.800 4.64000e-07 1.800 4.64050e-07 0.000 4.67000e-07 0.000 4.67050e-07 1.800 4.68000e-07 1.800
+ 4.68050e-07 0.000 4.69000e-07 0.000 4.69050e-07 1.800 4.71000e-07 1.800 4.71050e-07 0.000 4.72000e-07 0.000
+ 4.72050e-07 1.800 4.75000e-07 1.800 4.75050e-07 0.000 4.76000e-07 0.000 4.76050e-07 1.800 4.77000e-07 1.800
+ 4.77050e-07 0.000 4.78000e-07 0.000 4.78050e-07 1.800 4.79000e-07 1.800 4.79050e-07 0.000 4.83000e-07 0.000
+ 4.83050e-07 1.800 4.87000e-07 1.800 4.87050e-07 0.000 4.90000e-07 0.000 4.90050e-07 1.800 4.94000e-07 1.800
+ 4.94050e-07 0.000 4.96000e-07 0.000 4.96050e-07 1.800 4.97000e-07 1.800 4.97050e-07 0.000 4.98000e-07 0.000
+ 4.98050e-07 1.800 5.00000e-07 1.800 5.00050e-07 0.000 5.01000e-07 0.000 5.01050e-07 1.800 5.03000e-07 1.800
+ 5.03050e-07 0.000 5.05000e-07 0.000 5.05050e-07 1.800 5.08000e-07 1.800 5.08050e-07 0.000 5.10000e-07 0.000
+ 5.10050e-07 1.800 5.12000e-07 1.800
+ )
Xd_c0 src_c0 c0 vdd gnd tb_inv
Vc1 src_c1 gnd PWL(
+ 0.00000e+00 1.800 4.00000e-09 1.800 4.05000e-09 0.000 8.00000e-09 0.000 8.05000e-09 1.800 1.20000e-08 1.800
+ 1.20500e-08 0.000 1.60000e-08 0.000 1.60500e-08 1.800 2.00000e-08 1.800 2.00500e-08 0.000 2.40000e-08 0.000
+ 2.40500e-08 1.800 2.80000e-08 1.800 2.80500e-08 0.000 3.20000e-08 0.000 3.20500e-08 1.800 3.60000e-08 1.800
+ 3.60500e-08 0.000 4.00000e-08 0.000 4.00500e-08 1.800 4.40000e-08 1.800 4.40500e-08 0.000 4.80000e-08 0.000
+ 4.80500e-08 1.800 5.20000e-08 1.800 5.20500e-08 0.000 5.60000e-08 0.000 5.60500e-08 1.800 6.00000e-08 1.800
+ 6.00500e-08 0.000 6.40000e-08 0.000 6.40500e-08 1.800 6.80000e-08 1.800 6.80500e-08 0.000 7.20000e-08 0.000
+ 7.20500e-08 1.800 7.60000e-08 1.800 7.60500e-08 0.000 8.00000e-08 0.000 8.00500e-08 1.800 8.40000e-08 1.800
+ 8.40500e-08 0.000 8.80000e-08 0.000 8.80500e-08 1.800 9.20000e-08 1.800 9.20500e-08 0.000 9.60000e-08 0.000
+ 9.60500e-08 1.800 1.00000e-07 1.800 1.00050e-07 0.000 1.04000e-07 0.000 1.04050e-07 1.800 1.08000e-07 1.800
+ 1.08050e-07 0.000 1.12000e-07 0.000 1.12050e-07 1.800 1.16000e-07 1.800 1.16050e-07 0.000 1.20000e-07 0.000
+ 1.20050e-07 1.800 1.24000e-07 1.800 1.24050e-07 0.000 1.28000e-07 0.000 1.28050e-07 1.800 1.32000e-07 1.800
+ 1.32050e-07 0.000 1.36000e-07 0.000 1.36050e-07 1.800 1.40000e-07 1.800 1.40050e-07 0.000 1.44000e-07 0.000
+ 1.44050e-07 1.800 1.48000e-07 1.800 1.48050e-07 0.000 1.52000e-07 0.000 1.52050e-07 1.800 1.56000e-07 1.800
+ 1.56050e-07 0.000 1.60000e-07 0.000 1.60050e-07 1.800 1.64000e-07 1.800 1.64050e-07 0.000 1.68000e-07 0.000
+ 1.68050e-07 1.800 1.72000e-07 1.800 1.72050e-07 0.000 1.76000e-07 0.000 1.76050e-07 1.800 1.80000e-07 1.800
+ 1.80050e-07 0.000 1.84000e-07 0.000 1.84050e-07 1.800 1.88000e-07 1.800 1.88050e-07 0.000 1.92000e-07 0.000
+ 1.92050e-07 1.800 1.96000e-07 1.800 1.96050e-07 0.000 2.00000e-07 0.000 2.00050e-07 1.800 2.04000e-07 1.800
+ 2.04050e-07 0.000 2.08000e-07 0.000 2.08050e-07 1.800 2.12000e-07 1.800 2.12050e-07 0.000 2.16000e-07 0.000
+ 2.16050e-07 1.800 2.20000e-07 1.800 2.20050e-07 0.000 2.24000e-07 0.000 2.24050e-07 1.800 2.28000e-07 1.800
+ 2.28050e-07 0.000 2.32000e-07 0.000 2.32050e-07 1.800 2.36000e-07 1.800 2.36050e-07 0.000 2.40000e-07 0.000
+ 2.40050e-07 1.800 2.44000e-07 1.800 2.44050e-07 0.000 2.48000e-07 0.000 2.48050e-07 1.800 2.52000e-07 1.800
+ 2.52050e-07 0.000 2.56000e-07 0.000 2.56050e-07 1.800 2.57000e-07 1.800 2.57050e-07 0.000 2.58000e-07 0.000
+ 2.58050e-07 1.800 2.59000e-07 1.800 2.59050e-07 0.000 2.61000e-07 0.000 2.61050e-07 1.800 2.63000e-07 1.800
+ 2.63050e-07 0.000 2.65000e-07 0.000 2.65050e-07 1.800 2.67000e-07 1.800 2.67050e-07 0.000 2.68000e-07 0.000
+ 2.68050e-07 1.800 2.69000e-07 1.800 2.69050e-07 0.000 2.70000e-07 0.000 2.70050e-07 1.800 2.71000e-07 1.800
+ 2.71050e-07 0.000 2.72000e-07 0.000 2.72050e-07 1.800 2.75000e-07 1.800 2.75050e-07 0.000 2.77000e-07 0.000
+ 2.77050e-07 1.800 2.79000e-07 1.800 2.79050e-07 0.000 2.82000e-07 0.000 2.82050e-07 1.800 2.84000e-07 1.800
+ 2.84050e-07 0.000 2.86000e-07 0.000 2.86050e-07 1.800 2.88000e-07 1.800 2.88050e-07 0.000 2.90000e-07 0.000
+ 2.90050e-07 1.800 2.92000e-07 1.800 2.92050e-07 0.000 2.94000e-07 0.000 2.94050e-07 1.800 2.95000e-07 1.800
+ 2.95050e-07 0.000 2.96000e-07 0.000 2.96050e-07 1.800 2.98000e-07 1.800 2.98050e-07 0.000 2.99000e-07 0.000
+ 2.99050e-07 1.800 3.01000e-07 1.800 3.01050e-07 0.000 3.02000e-07 0.000 3.02050e-07 1.800 3.06000e-07 1.800
+ 3.06050e-07 0.000 3.09000e-07 0.000 3.09050e-07 1.800 3.10000e-07 1.800 3.10050e-07 0.000 3.12000e-07 0.000
+ 3.12050e-07 1.800 3.14000e-07 1.800 3.14050e-07 0.000 3.15000e-07 0.000 3.15050e-07 1.800 3.16000e-07 1.800
+ 3.16050e-07 0.000 3.17000e-07 0.000 3.17050e-07 1.800 3.18000e-07 1.800 3.18050e-07 0.000 3.20000e-07 0.000
+ 3.20050e-07 1.800 3.22000e-07 1.800 3.22050e-07 0.000 3.25000e-07 0.000 3.25050e-07 1.800 3.28000e-07 1.800
+ 3.28050e-07 0.000 3.29000e-07 0.000 3.29050e-07 1.800 3.31000e-07 1.800 3.31050e-07 0.000 3.33000e-07 0.000
+ 3.33050e-07 1.800 3.34000e-07 1.800 3.34050e-07 0.000 3.35000e-07 0.000 3.35050e-07 1.800 3.38000e-07 1.800
+ 3.38050e-07 0.000 3.39000e-07 0.000 3.39050e-07 1.800 3.40000e-07 1.800 3.40050e-07 0.000 3.41000e-07 0.000
+ 3.41050e-07 1.800 3.42000e-07 1.800 3.42050e-07 0.000 3.43000e-07 0.000 3.43050e-07 1.800 3.44000e-07 1.800
+ 3.44050e-07 0.000 3.45000e-07 0.000 3.45050e-07 1.800 3.47000e-07 1.800 3.47050e-07 0.000 3.49000e-07 0.000
+ 3.49050e-07 1.800 3.51000e-07 1.800 3.51050e-07 0.000 3.54000e-07 0.000 3.54050e-07 1.800 3.56000e-07 1.800
+ 3.56050e-07 0.000 3.62000e-07 0.000 3.62050e-07 1.800 3.63000e-07 1.800 3.63050e-07 0.000 3.64000e-07 0.000
+ 3.64050e-07 1.800 3.65000e-07 1.800 3.65050e-07 0.000 3.67000e-07 0.000 3.67050e-07 1.800 3.68000e-07 1.800
+ 3.68050e-07 0.000 3.70000e-07 0.000 3.70050e-07 1.800 3.71000e-07 1.800 3.71050e-07 0.000 3.72000e-07 0.000
+ 3.72050e-07 1.800 3.73000e-07 1.800 3.73050e-07 0.000 3.75000e-07 0.000 3.75050e-07 1.800 3.77000e-07 1.800
+ 3.77050e-07 0.000 3.86000e-07 0.000 3.86050e-07 1.800 3.94000e-07 1.800 3.94050e-07 0.000 3.97000e-07 0.000
+ 3.97050e-07 1.800 3.99000e-07 1.800 3.99050e-07 0.000 4.01000e-07 0.000 4.01050e-07 1.800 4.04000e-07 1.800
+ 4.04050e-07 0.000 4.05000e-07 0.000 4.05050e-07 1.800 4.06000e-07 1.800 4.06050e-07 0.000 4.07000e-07 0.000
+ 4.07050e-07 1.800 4.08000e-07 1.800 4.08050e-07 0.000 4.12000e-07 0.000 4.12050e-07 1.800 4.15000e-07 1.800
+ 4.15050e-07 0.000 4.21000e-07 0.000 4.21050e-07 1.800 4.22000e-07 1.800 4.22050e-07 0.000 4.24000e-07 0.000
+ 4.24050e-07 1.800 4.26000e-07 1.800 4.26050e-07 0.000 4.28000e-07 0.000 4.28050e-07 1.800 4.29000e-07 1.800
+ 4.29050e-07 0.000 4.31000e-07 0.000 4.31050e-07 1.800 4.32000e-07 1.800 4.32050e-07 0.000 4.33000e-07 0.000
+ 4.33050e-07 1.800 4.38000e-07 1.800 4.38050e-07 0.000 4.40000e-07 0.000 4.40050e-07 1.800 4.44000e-07 1.800
+ 4.44050e-07 0.000 4.45000e-07 0.000 4.45050e-07 1.800 4.46000e-07 1.800 4.46050e-07 0.000 4.48000e-07 0.000
+ 4.48050e-07 1.800 4.51000e-07 1.800 4.51050e-07 0.000 4.55000e-07 0.000 4.55050e-07 1.800 4.58000e-07 1.800
+ 4.58050e-07 0.000 4.60000e-07 0.000 4.60050e-07 1.800 4.61000e-07 1.800 4.61050e-07 0.000 4.62000e-07 0.000
+ 4.62050e-07 1.800 4.63000e-07 1.800 4.63050e-07 0.000 4.64000e-07 0.000 4.64050e-07 1.800 4.66000e-07 1.800
+ 4.66050e-07 0.000 4.69000e-07 0.000 4.69050e-07 1.800 4.73000e-07 1.800 4.73050e-07 0.000 4.76000e-07 0.000
+ 4.76050e-07 1.800 4.78000e-07 1.800 4.78050e-07 0.000 4.79000e-07 0.000 4.79050e-07 1.800 4.80000e-07 1.800
+ 4.80050e-07 0.000 4.81000e-07 0.000 4.81050e-07 1.800 4.82000e-07 1.800 4.82050e-07 0.000 4.83000e-07 0.000
+ 4.83050e-07 1.800 4.86000e-07 1.800 4.86050e-07 0.000 4.87000e-07 0.000 4.87050e-07 1.800 4.89000e-07 1.800
+ 4.89050e-07 0.000 4.90000e-07 0.000 4.90050e-07 1.800 4.91000e-07 1.800 4.91050e-07 0.000 4.95000e-07 0.000
+ 4.95050e-07 1.800 4.96000e-07 1.800 4.96050e-07 0.000 4.97000e-07 0.000 4.97050e-07 1.800 4.99000e-07 1.800
+ 4.99050e-07 0.000 5.00000e-07 0.000 5.00050e-07 1.800 5.03000e-07 1.800 5.03050e-07 0.000 5.05000e-07 0.000
+ 5.05050e-07 1.800 5.08000e-07 1.800 5.08050e-07 0.000 5.09000e-07 0.000 5.09050e-07 1.800 5.11000e-07 1.800
+ 5.11050e-07 0.000 5.12000e-07 0.000
+ )
Xd_c1 src_c1 c1 vdd gnd tb_inv
Vc2 src_c2 gnd PWL(
+ 0.00000e+00 1.800 2.00000e-09 1.800 2.05000e-09 0.000 4.00000e-09 0.000 4.05000e-09 1.800 6.00000e-09 1.800
+ 6.05000e-09 0.000 8.00000e-09 0.000 8.05000e-09 1.800 1.00000e-08 1.800 1.00500e-08 0.000 1.20000e-08 0.000
+ 1.20500e-08 1.800 1.40000e-08 1.800 1.40500e-08 0.000 1.60000e-08 0.000 1.60500e-08 1.800 1.80000e-08 1.800
+ 1.80500e-08 0.000 2.00000e-08 0.000 2.00500e-08 1.800 2.20000e-08 1.800 2.20500e-08 0.000 2.40000e-08 0.000
+ 2.40500e-08 1.800 2.60000e-08 1.800 2.60500e-08 0.000 2.80000e-08 0.000 2.80500e-08 1.800 3.00000e-08 1.800
+ 3.00500e-08 0.000 3.20000e-08 0.000 3.20500e-08 1.800 3.40000e-08 1.800 3.40500e-08 0.000 3.60000e-08 0.000
+ 3.60500e-08 1.800 3.80000e-08 1.800 3.80500e-08 0.000 4.00000e-08 0.000 4.00500e-08 1.800 4.20000e-08 1.800
+ 4.20500e-08 0.000 4.40000e-08 0.000 4.40500e-08 1.800 4.60000e-08 1.800 4.60500e-08 0.000 4.80000e-08 0.000
+ 4.80500e-08 1.800 5.00000e-08 1.800 5.00500e-08 0.000 5.20000e-08 0.000 5.20500e-08 1.800 5.40000e-08 1.800
+ 5.40500e-08 0.000 5.60000e-08 0.000 5.60500e-08 1.800 5.80000e-08 1.800 5.80500e-08 0.000 6.00000e-08 0.000
+ 6.00500e-08 1.800 6.20000e-08 1.800 6.20500e-08 0.000 6.40000e-08 0.000 6.40500e-08 1.800 6.60000e-08 1.800
+ 6.60500e-08 0.000 6.80000e-08 0.000 6.80500e-08 1.800 7.00000e-08 1.800 7.00500e-08 0.000 7.20000e-08 0.000
+ 7.20500e-08 1.800 7.40000e-08 1.800 7.40500e-08 0.000 7.60000e-08 0.000 7.60500e-08 1.800 7.80000e-08 1.800
+ 7.80500e-08 0.000 8.00000e-08 0.000 8.00500e-08 1.800 8.20000e-08 1.800 8.20500e-08 0.000 8.40000e-08 0.000
+ 8.40500e-08 1.800 8.60000e-08 1.800 8.60500e-08 0.000 8.80000e-08 0.000 8.80500e-08 1.800 9.00000e-08 1.800
+ 9.00500e-08 0.000 9.20000e-08 0.000 9.20500e-08 1.800 9.40000e-08 1.800 9.40500e-08 0.000 9.60000e-08 0.000
+ 9.60500e-08 1.800 9.80000e-08 1.800 9.80500e-08 0.000 1.00000e-07 0.000 1.00050e-07 1.800 1.02000e-07 1.800
+ 1.02050e-07 0.000 1.04000e-07 0.000 1.04050e-07 1.800 1.06000e-07 1.800 1.06050e-07 0.000 1.08000e-07 0.000
+ 1.08050e-07 1.800 1.10000e-07 1.800 1.10050e-07 0.000 1.12000e-07 0.000 1.12050e-07 1.800 1.14000e-07 1.800
+ 1.14050e-07 0.000 1.16000e-07 0.000 1.16050e-07 1.800 1.18000e-07 1.800 1.18050e-07 0.000 1.20000e-07 0.000
+ 1.20050e-07 1.800 1.22000e-07 1.800 1.22050e-07 0.000 1.24000e-07 0.000 1.24050e-07 1.800 1.26000e-07 1.800
+ 1.26050e-07 0.000 1.28000e-07 0.000 1.28050e-07 1.800 1.30000e-07 1.800 1.30050e-07 0.000 1.32000e-07 0.000
+ 1.32050e-07 1.800 1.34000e-07 1.800 1.34050e-07 0.000 1.36000e-07 0.000 1.36050e-07 1.800 1.38000e-07 1.800
+ 1.38050e-07 0.000 1.40000e-07 0.000 1.40050e-07 1.800 1.42000e-07 1.800 1.42050e-07 0.000 1.44000e-07 0.000
+ 1.44050e-07 1.800 1.46000e-07 1.800 1.46050e-07 0.000 1.48000e-07 0.000 1.48050e-07 1.800 1.50000e-07 1.800
+ 1.50050e-07 0.000 1.52000e-07 0.000 1.52050e-07 1.800 1.54000e-07 1.800 1.54050e-07 0.000 1.56000e-07 0.000
+ 1.56050e-07 1.800 1.58000e-07 1.800 1.58050e-07 0.000 1.60000e-07 0.000 1.60050e-07 1.800 1.62000e-07 1.800
+ 1.62050e-07 0.000 1.64000e-07 0.000 1.64050e-07 1.800 1.66000e-07 1.800 1.66050e-07 0.000 1.68000e-07 0.000
+ 1.68050e-07 1.800 1.70000e-07 1.800 1.70050e-07 0.000 1.72000e-07 0.000 1.72050e-07 1.800 1.74000e-07 1.800
+ 1.74050e-07 0.000 1.76000e-07 0.000 1.76050e-07 1.800 1.78000e-07 1.800 1.78050e-07 0.000 1.80000e-07 0.000
+ 1.80050e-07 1.800 1.82000e-07 1.800 1.82050e-07 0.000 1.84000e-07 0.000 1.84050e-07 1.800 1.86000e-07 1.800
+ 1.86050e-07 0.000 1.88000e-07 0.000 1.88050e-07 1.800 1.90000e-07 1.800 1.90050e-07 0.000 1.92000e-07 0.000
+ 1.92050e-07 1.800 1.94000e-07 1.800 1.94050e-07 0.000 1.96000e-07 0.000 1.96050e-07 1.800 1.98000e-07 1.800
+ 1.98050e-07 0.000 2.00000e-07 0.000 2.00050e-07 1.800 2.02000e-07 1.800 2.02050e-07 0.000 2.04000e-07 0.000
+ 2.04050e-07 1.800 2.06000e-07 1.800 2.06050e-07 0.000 2.08000e-07 0.000 2.08050e-07 1.800 2.10000e-07 1.800
+ 2.10050e-07 0.000 2.12000e-07 0.000 2.12050e-07 1.800 2.14000e-07 1.800 2.14050e-07 0.000 2.16000e-07 0.000
+ 2.16050e-07 1.800 2.18000e-07 1.800 2.18050e-07 0.000 2.20000e-07 0.000 2.20050e-07 1.800 2.22000e-07 1.800
+ 2.22050e-07 0.000 2.24000e-07 0.000 2.24050e-07 1.800 2.26000e-07 1.800 2.26050e-07 0.000 2.28000e-07 0.000
+ 2.28050e-07 1.800 2.30000e-07 1.800 2.30050e-07 0.000 2.32000e-07 0.000 2.32050e-07 1.800 2.34000e-07 1.800
+ 2.34050e-07 0.000 2.36000e-07 0.000 2.36050e-07 1.800 2.38000e-07 1.800 2.38050e-07 0.000 2.40000e-07 0.000
+ 2.40050e-07 1.800 2.42000e-07 1.800 2.42050e-07 0.000 2.44000e-07 0.000 2.44050e-07 1.800 2.46000e-07 1.800
+ 2.46050e-07 0.000 2.48000e-07 0.000 2.48050e-07 1.800 2.50000e-07 1.800 2.50050e-07 0.000 2.52000e-07 0.000
+ 2.52050e-07 1.800 2.54000e-07 1.800 2.54050e-07 0.000 2.56000e-07 0.000 2.56050e-07 1.800 2.57000e-07 1.800
+ 2.57050e-07 0.000 2.66000e-07 0.000 2.66050e-07 1.800 2.67000e-07 1.800 2.67050e-07 0.000 2.70000e-07 0.000
+ 2.70050e-07 1.800 2.73000e-07 1.800 2.73050e-07 0.000 2.74000e-07 0.000 2.74050e-07 1.800 2.84000e-07 1.800
+ 2.84050e-07 0.000 2.85000e-07 0.000 2.85050e-07 1.800 2.86000e-07 1.800 2.86050e-07 0.000 2.89000e-07 0.000
+ 2.89050e-07 1.800 2.91000e-07 1.800 2.91050e-07 0.000 2.92000e-07 0.000 2.92050e-07 1.800 2.93000e-07 1.800
+ 2.93050e-07 0.000 2.94000e-07 0.000 2.94050e-07 1.800 2.95000e-07 1.800 2.95050e-07 0.000 2.98000e-07 0.000
+ 2.98050e-07 1.800 3.01000e-07 1.800 3.01050e-07 0.000 3.02000e-07 0.000 3.02050e-07 1.800 3.05000e-07 1.800
+ 3.05050e-07 0.000 3.06000e-07 0.000 3.06050e-07 1.800 3.07000e-07 1.800 3.07050e-07 0.000 3.08000e-07 0.000
+ 3.08050e-07 1.800 3.09000e-07 1.800 3.09050e-07 0.000 3.12000e-07 0.000 3.12050e-07 1.800 3.13000e-07 1.800
+ 3.13050e-07 0.000 3.14000e-07 0.000 3.14050e-07 1.800 3.15000e-07 1.800 3.15050e-07 0.000 3.16000e-07 0.000
+ 3.16050e-07 1.800 3.17000e-07 1.800 3.17050e-07 0.000 3.22000e-07 0.000 3.22050e-07 1.800 3.23000e-07 1.800
+ 3.23050e-07 0.000 3.24000e-07 0.000 3.24050e-07 1.800 3.26000e-07 1.800 3.26050e-07 0.000 3.28000e-07 0.000
+ 3.28050e-07 1.800 3.29000e-07 1.800 3.29050e-07 0.000 3.31000e-07 0.000 3.31050e-07 1.800 3.38000e-07 1.800
+ 3.38050e-07 0.000 3.42000e-07 0.000 3.42050e-07 1.800 3.44000e-07 1.800 3.44050e-07 0.000 3.46000e-07 0.000
+ 3.46050e-07 1.800 3.47000e-07 1.800 3.47050e-07 0.000 3.48000e-07 0.000 3.48050e-07 1.800 3.52000e-07 1.800
+ 3.52050e-07 0.000 3.54000e-07 0.000 3.54050e-07 1.800 3.58000e-07 1.800 3.58050e-07 0.000 3.60000e-07 0.000
+ 3.60050e-07 1.800 3.61000e-07 1.800 3.61050e-07 0.000 3.63000e-07 0.000 3.63050e-07 1.800 3.64000e-07 1.800
+ 3.64050e-07 0.000 3.66000e-07 0.000 3.66050e-07 1.800 3.69000e-07 1.800 3.69050e-07 0.000 3.70000e-07 0.000
+ 3.70050e-07 1.800 3.73000e-07 1.800 3.73050e-07 0.000 3.74000e-07 0.000 3.74050e-07 1.800 3.76000e-07 1.800
+ 3.76050e-07 0.000 3.77000e-07 0.000 3.77050e-07 1.800 3.78000e-07 1.800 3.78050e-07 0.000 3.79000e-07 0.000
+ 3.79050e-07 1.800 3.80000e-07 1.800 3.80050e-07 0.000 3.82000e-07 0.000 3.82050e-07 1.800 3.83000e-07 1.800
+ 3.83050e-07 0.000 3.84000e-07 0.000 3.84050e-07 1.800 3.87000e-07 1.800 3.87050e-07 0.000 3.88000e-07 0.000
+ 3.88050e-07 1.800 3.89000e-07 1.800 3.89050e-07 0.000 3.90000e-07 0.000 3.90050e-07 1.800 3.91000e-07 1.800
+ 3.91050e-07 0.000 3.92000e-07 0.000 3.92050e-07 1.800 3.93000e-07 1.800 3.93050e-07 0.000 3.94000e-07 0.000
+ 3.94050e-07 1.800 3.95000e-07 1.800 3.95050e-07 0.000 4.00000e-07 0.000 4.00050e-07 1.800 4.01000e-07 1.800
+ 4.01050e-07 0.000 4.06000e-07 0.000 4.06050e-07 1.800 4.09000e-07 1.800 4.09050e-07 0.000 4.10000e-07 0.000
+ 4.10050e-07 1.800 4.13000e-07 1.800 4.13050e-07 0.000 4.15000e-07 0.000 4.15050e-07 1.800 4.16000e-07 1.800
+ 4.16050e-07 0.000 4.18000e-07 0.000 4.18050e-07 1.800 4.22000e-07 1.800 4.22050e-07 0.000 4.25000e-07 0.000
+ 4.25050e-07 1.800 4.26000e-07 1.800 4.26050e-07 0.000 4.27000e-07 0.000 4.27050e-07 1.800 4.28000e-07 1.800
+ 4.28050e-07 0.000 4.31000e-07 0.000 4.31050e-07 1.800 4.34000e-07 1.800 4.34050e-07 0.000 4.35000e-07 0.000
+ 4.35050e-07 1.800 4.36000e-07 1.800 4.36050e-07 0.000 4.37000e-07 0.000 4.37050e-07 1.800 4.38000e-07 1.800
+ 4.38050e-07 0.000 4.39000e-07 0.000 4.39050e-07 1.800 4.41000e-07 1.800 4.41050e-07 0.000 4.42000e-07 0.000
+ 4.42050e-07 1.800 4.44000e-07 1.800 4.44050e-07 0.000 4.45000e-07 0.000 4.45050e-07 1.800 4.47000e-07 1.800
+ 4.47050e-07 0.000 4.51000e-07 0.000 4.51050e-07 1.800 4.52000e-07 1.800 4.52050e-07 0.000 4.54000e-07 0.000
+ 4.54050e-07 1.800 4.57000e-07 1.800 4.57050e-07 0.000 4.58000e-07 0.000 4.58050e-07 1.800 4.59000e-07 1.800
+ 4.59050e-07 0.000 4.60000e-07 0.000 4.60050e-07 1.800 4.61000e-07 1.800 4.61050e-07 0.000 4.62000e-07 0.000
+ 4.62050e-07 1.800 4.63000e-07 1.800 4.63050e-07 0.000 4.65000e-07 0.000 4.65050e-07 1.800 4.67000e-07 1.800
+ 4.67050e-07 0.000 4.74000e-07 0.000 4.74050e-07 1.800 4.77000e-07 1.800 4.77050e-07 0.000 4.80000e-07 0.000
+ 4.80050e-07 1.800 4.82000e-07 1.800 4.82050e-07 0.000 4.85000e-07 0.000 4.85050e-07 1.800 4.87000e-07 1.800
+ 4.87050e-07 0.000 4.91000e-07 0.000 4.91050e-07 1.800 4.93000e-07 1.800 4.93050e-07 0.000 4.94000e-07 0.000
+ 4.94050e-07 1.800 4.99000e-07 1.800 4.99050e-07 0.000 5.00000e-07 0.000 5.00050e-07 1.800 5.01000e-07 1.800
+ 5.01050e-07 0.000 5.05000e-07 0.000 5.05050e-07 1.800 5.07000e-07 1.800 5.07050e-07 0.000 5.08000e-07 0.000
+ 5.08050e-07 1.800 5.12000e-07 1.800
+ )
Xd_c2 src_c2 c2 vdd gnd tb_inv
Vc3 src_c3 gnd PWL(
+ 0.00000e+00 1.800 1.00000e-09 1.800 1.05000e-09 0.000 2.00000e-09 0.000 2.05000e-09 1.800 3.00000e-09 1.800
+ 3.05000e-09 0.000 4.00000e-09 0.000 4.05000e-09 1.800 5.00000e-09 1.800 5.05000e-09 0.000 6.00000e-09 0.000
+ 6.05000e-09 1.800 7.00000e-09 1.800 7.05000e-09 0.000 8.00000e-09 0.000 8.05000e-09 1.800 9.00000e-09 1.800
+ 9.05000e-09 0.000 1.00000e-08 0.000 1.00500e-08 1.800 1.10000e-08 1.800 1.10500e-08 0.000 1.20000e-08 0.000
+ 1.20500e-08 1.800 1.30000e-08 1.800 1.30500e-08 0.000 1.40000e-08 0.000 1.40500e-08 1.800 1.50000e-08 1.800
+ 1.50500e-08 0.000 1.60000e-08 0.000 1.60500e-08 1.800 1.70000e-08 1.800 1.70500e-08 0.000 1.80000e-08 0.000
+ 1.80500e-08 1.800 1.90000e-08 1.800 1.90500e-08 0.000 2.00000e-08 0.000 2.00500e-08 1.800 2.10000e-08 1.800
+ 2.10500e-08 0.000 2.20000e-08 0.000 2.20500e-08 1.800 2.30000e-08 1.800 2.30500e-08 0.000 2.40000e-08 0.000
+ 2.40500e-08 1.800 2.50000e-08 1.800 2.50500e-08 0.000 2.60000e-08 0.000 2.60500e-08 1.800 2.70000e-08 1.800
+ 2.70500e-08 0.000 2.80000e-08 0.000 2.80500e-08 1.800 2.90000e-08 1.800 2.90500e-08 0.000 3.00000e-08 0.000
+ 3.00500e-08 1.800 3.10000e-08 1.800 3.10500e-08 0.000 3.20000e-08 0.000 3.20500e-08 1.800 3.30000e-08 1.800
+ 3.30500e-08 0.000 3.40000e-08 0.000 3.40500e-08 1.800 3.50000e-08 1.800 3.50500e-08 0.000 3.60000e-08 0.000
+ 3.60500e-08 1.800 3.70000e-08 1.800 3.70500e-08 0.000 3.80000e-08 0.000 3.80500e-08 1.800 3.90000e-08 1.800
+ 3.90500e-08 0.000 4.00000e-08 0.000 4.00500e-08 1.800 4.10000e-08 1.800 4.10500e-08 0.000 4.20000e-08 0.000
+ 4.20500e-08 1.800 4.30000e-08 1.800 4.30500e-08 0.000 4.40000e-08 0.000 4.40500e-08 1.800 4.50000e-08 1.800
+ 4.50500e-08 0.000 4.60000e-08 0.000 4.60500e-08 1.800 4.70000e-08 1.800 4.70500e-08 0.000 4.80000e-08 0.000
+ 4.80500e-08 1.800 4.90000e-08 1.800 4.90500e-08 0.000 5.00000e-08 0.000 5.00500e-08 1.800 5.10000e-08 1.800
+ 5.10500e-08 0.000 5.20000e-08 0.000 5.20500e-08 1.800 5.30000e-08 1.800 5.30500e-08 0.000 5.40000e-08 0.000
+ 5.40500e-08 1.800 5.50000e-08 1.800 5.50500e-08 0.000 5.60000e-08 0.000 5.60500e-08 1.800 5.70000e-08 1.800
+ 5.70500e-08 0.000 5.80000e-08 0.000 5.80500e-08 1.800 5.90000e-08 1.800 5.90500e-08 0.000 6.00000e-08 0.000
+ 6.00500e-08 1.800 6.10000e-08 1.800 6.10500e-08 0.000 6.20000e-08 0.000 6.20500e-08 1.800 6.30000e-08 1.800
+ 6.30500e-08 0.000 6.40000e-08 0.000 6.40500e-08 1.800 6.50000e-08 1.800 6.50500e-08 0.000 6.60000e-08 0.000
+ 6.60500e-08 1.800 6.70000e-08 1.800 6.70500e-08 0.000 6.80000e-08 0.000 6.80500e-08 1.800 6.90000e-08 1.800
+ 6.90500e-08 0.000 7.00000e-08 0.000 7.00500e-08 1.800 7.10000e-08 1.800 7.10500e-08 0.000 7.20000e-08 0.000
+ 7.20500e-08 1.800 7.30000e-08 1.800 7.30500e-08 0.000 7.40000e-08 0.000 7.40500e-08 1.800 7.50000e-08 1.800
+ 7.50500e-08 0.000 7.60000e-08 0.000 7.60500e-08 1.800 7.70000e-08 1.800 7.70500e-08 0.000 7.80000e-08 0.000
+ 7.80500e-08 1.800 7.90000e-08 1.800 7.90500e-08 0.000 8.00000e-08 0.000 8.00500e-08 1.800 8.10000e-08 1.800
+ 8.10500e-08 0.000 8.20000e-08 0.000 8.20500e-08 1.800 8.30000e-08 1.800 8.30500e-08 0.000 8.40000e-08 0.000
+ 8.40500e-08 1.800 8.50000e-08 1.800 8.50500e-08 0.000 8.60000e-08 0.000 8.60500e-08 1.800 8.70000e-08 1.800
+ 8.70500e-08 0.000 8.80000e-08 0.000 8.80500e-08 1.800 8.90000e-08 1.800 8.90500e-08 0.000 9.00000e-08 0.000
+ 9.00500e-08 1.800 9.10000e-08 1.800 9.10500e-08 0.000 9.20000e-08 0.000 9.20500e-08 1.800 9.30000e-08 1.800
+ 9.30500e-08 0.000 9.40000e-08 0.000 9.40500e-08 1.800 9.50000e-08 1.800 9.50500e-08 0.000 9.60000e-08 0.000
+ 9.60500e-08 1.800 9.70000e-08 1.800 9.70500e-08 0.000 9.80000e-08 0.000 9.80500e-08 1.800 9.90000e-08 1.800
+ 9.90500e-08 0.000 1.00000e-07 0.000 1.00050e-07 1.800 1.01000e-07 1.800 1.01050e-07 0.000 1.02000e-07 0.000
+ 1.02050e-07 1.800 1.03000e-07 1.800 1.03050e-07 0.000 1.04000e-07 0.000 1.04050e-07 1.800 1.05000e-07 1.800
+ 1.05050e-07 0.000 1.06000e-07 0.000 1.06050e-07 1.800 1.07000e-07 1.800 1.07050e-07 0.000 1.08000e-07 0.000
+ 1.08050e-07 1.800 1.09000e-07 1.800 1.09050e-07 0.000 1.10000e-07 0.000 1.10050e-07 1.800 1.11000e-07 1.800
+ 1.11050e-07 0.000 1.12000e-07 0.000 1.12050e-07 1.800 1.13000e-07 1.800 1.13050e-07 0.000 1.14000e-07 0.000
+ 1.14050e-07 1.800 1.15000e-07 1.800 1.15050e-07 0.000 1.16000e-07 0.000 1.16050e-07 1.800 1.17000e-07 1.800
+ 1.17050e-07 0.000 1.18000e-07 0.000 1.18050e-07 1.800 1.19000e-07 1.800 1.19050e-07 0.000 1.20000e-07 0.000
+ 1.20050e-07 1.800 1.21000e-07 1.800 1.21050e-07 0.000 1.22000e-07 0.000 1.22050e-07 1.800 1.23000e-07 1.800
+ 1.23050e-07 0.000 1.24000e-07 0.000 1.24050e-07 1.800 1.25000e-07 1.800 1.25050e-07 0.000 1.26000e-07 0.000
+ 1.26050e-07 1.800 1.27000e-07 1.800 1.27050e-07 0.000 1.28000e-07 0.000 1.28050e-07 1.800 1.29000e-07 1.800
+ 1.29050e-07 0.000 1.30000e-07 0.000 1.30050e-07 1.800 1.31000e-07 1.800 1.31050e-07 0.000 1.32000e-07 0.000
+ 1.32050e-07 1.800 1.33000e-07 1.800 1.33050e-07 0.000 1.34000e-07 0.000 1.34050e-07 1.800 1.35000e-07 1.800
+ 1.35050e-07 0.000 1.36000e-07 0.000 1.36050e-07 1.800 1.37000e-07 1.800 1.37050e-07 0.000 1.38000e-07 0.000
+ 1.38050e-07 1.800 1.39000e-07 1.800 1.39050e-07 0.000 1.40000e-07 0.000 1.40050e-07 1.800 1.41000e-07 1.800
+ 1.41050e-07 0.000 1.42000e-07 0.000 1.42050e-07 1.800 1.43000e-07 1.800 1.43050e-07 0.000 1.44000e-07 0.000
+ 1.44050e-07 1.800 1.45000e-07 1.800 1.45050e-07 0.000 1.46000e-07 0.000 1.46050e-07 1.800 1.47000e-07 1.800
+ 1.47050e-07 0.000 1.48000e-07 0.000 1.48050e-07 1.800 1.49000e-07 1.800 1.49050e-07 0.000 1.50000e-07 0.000
+ 1.50050e-07 1.800 1.51000e-07 1.800 1.51050e-07 0.000 1.52000e-07 0.000 1.52050e-07 1.800 1.53000e-07 1.800
+ 1.53050e-07 0.000 1.54000e-07 0.000 1.54050e-07 1.800 1.55000e-07 1.800 1.55050e-07 0.000 1.56000e-07 0.000
+ 1.56050e-07 1.800 1.57000e-07 1.800 1.57050e-07 0.000 1.58000e-07 0.000 1.58050e-07 1.800 1.59000e-07 1.800
+ 1.59050e-07 0.000 1.60000e-07 0.000 1.60050e-07 1.800 1.61000e-07 1.800 1.61050e-07 0.000 1.62000e-07 0.000
+ 1.62050e-07 1.800 1.63000e-07 1.800 1.63050e-07 0.000 1.64000e-07 0.000 1.64050e-07 1.800 1.65000e-07 1.800
+ 1.65050e-07 0.000 1.66000e-07 0.000 1.66050e-07 1.800 1.67000e-07 1.800 1.67050e-07 0.000 1.68000e-07 0.000
+ 1.68050e-07 1.800 1.69000e-07 1.800 1.69050e-07 0.000 1.70000e-07 0.000 1.70050e-07 1.800 1.71000e-07 1.800
+ 1.71050e-07 0.000 1.72000e-07 0.000 1.72050e-07 1.800 1.73000e-07 1.800 1.73050e-07 0.000 1.74000e-07 0.000
+ 1.74050e-07 1.800 1.75000e-07 1.800 1.75050e-07 0.000 1.76000e-07 0.000 1.76050e-07 1.800 1.77000e-07 1.800
+ 1.77050e-07 0.000 1.78000e-07 0.000 1.78050e-07 1.800 1.79000e-07 1.800 1.79050e-07 0.000 1.80000e-07 0.000
+ 1.80050e-07 1.800 1.81000e-07 1.800 1.81050e-07 0.000 1.82000e-07 0.000 1.82050e-07 1.800 1.83000e-07 1.800
+ 1.83050e-07 0.000 1.84000e-07 0.000 1.84050e-07 1.800 1.85000e-07 1.800 1.85050e-07 0.000 1.86000e-07 0.000
+ 1.86050e-07 1.800 1.87000e-07 1.800 1.87050e-07 0.000 1.88000e-07 0.000 1.88050e-07 1.800 1.89000e-07 1.800
+ 1.89050e-07 0.000 1.90000e-07 0.000 1.90050e-07 1.800 1.91000e-07 1.800 1.91050e-07 0.000 1.92000e-07 0.000
+ 1.92050e-07 1.800 1.93000e-07 1.800 1.93050e-07 0.000 1.94000e-07 0.000 1.94050e-07 1.800 1.95000e-07 1.800
+ 1.95050e-07 0.000 1.96000e-07 0.000 1.96050e-07 1.800 1.97000e-07 1.800 1.97050e-07 0.000 1.98000e-07 0.000
+ 1.98050e-07 1.800 1.99000e-07 1.800 1.99050e-07 0.000 2.00000e-07 0.000 2.00050e-07 1.800 2.01000e-07 1.800
+ 2.01050e-07 0.000 2.02000e-07 0.000 2.02050e-07 1.800 2.03000e-07 1.800 2.03050e-07 0.000 2.04000e-07 0.000
+ 2.04050e-07 1.800 2.05000e-07 1.800 2.05050e-07 0.000 2.06000e-07 0.000 2.06050e-07 1.800 2.07000e-07 1.800
+ 2.07050e-07 0.000 2.08000e-07 0.000 2.08050e-07 1.800 2.09000e-07 1.800 2.09050e-07 0.000 2.10000e-07 0.000
+ 2.10050e-07 1.800 2.11000e-07 1.800 2.11050e-07 0.000 2.12000e-07 0.000 2.12050e-07 1.800 2.13000e-07 1.800
+ 2.13050e-07 0.000 2.14000e-07 0.000 2.14050e-07 1.800 2.15000e-07 1.800 2.15050e-07 0.000 2.16000e-07 0.000
+ 2.16050e-07 1.800 2.17000e-07 1.800 2.17050e-07 0.000 2.18000e-07 0.000 2.18050e-07 1.800 2.19000e-07 1.800
+ 2.19050e-07 0.000 2.20000e-07 0.000 2.20050e-07 1.800 2.21000e-07 1.800 2.21050e-07 0.000 2.22000e-07 0.000
+ 2.22050e-07 1.800 2.23000e-07 1.800 2.23050e-07 0.000 2.24000e-07 0.000 2.24050e-07 1.800 2.25000e-07 1.800
+ 2.25050e-07 0.000 2.26000e-07 0.000 2.26050e-07 1.800 2.27000e-07 1.800 2.27050e-07 0.000 2.28000e-07 0.000
+ 2.28050e-07 1.800 2.29000e-07 1.800 2.29050e-07 0.000 2.30000e-07 0.000 2.30050e-07 1.800 2.31000e-07 1.800
+ 2.31050e-07 0.000 2.32000e-07 0.000 2.32050e-07 1.800 2.33000e-07 1.800 2.33050e-07 0.000 2.34000e-07 0.000
+ 2.34050e-07 1.800 2.35000e-07 1.800 2.35050e-07 0.000 2.36000e-07 0.000 2.36050e-07 1.800 2.37000e-07 1.800
+ 2.37050e-07 0.000 2.38000e-07 0.000 2.38050e-07 1.800 2.39000e-07 1.800 2.39050e-07 0.000 2.40000e-07 0.000
+ 2.40050e-07 1.800 2.41000e-07 1.800 2.41050e-07 0.000 2.42000e-07 0.000 2.42050e-07 1.800 2.43000e-07 1.800
+ 2.43050e-07 0.000 2.44000e-07 0.000 2.44050e-07 1.800 2.45000e-07 1.800 2.45050e-07 0.000 2.46000e-07 0.000
+ 2.46050e-07 1.800 2.47000e-07 1.800 2.47050e-07 0.000 2.48000e-07 0.000 2.48050e-07 1.800 2.49000e-07 1.800
+ 2.49050e-07 0.000 2.50000e-07 0.000 2.50050e-07 1.800 2.51000e-07 1.800 2.51050e-07 0.000 2.52000e-07 0.000
+ 2.52050e-07 1.800 2.53000e-07 1.800 2.53050e-07 0.000 2.54000e-07 0.000 2.54050e-07 1.800 2.55000e-07 1.800
+ 2.55050e-07 0.000 2.57000e-07 0.000 2.57050e-07 1.800 2.59000e-07 1.800 2.59050e-07 0.000 2.62000e-07 0.000
+ 2.62050e-07 1.800 2.64000e-07 1.800 2.64050e-07 0.000 2.66000e-07 0.000 2.66050e-07 1.800 2.67000e-07 1.800
+ 2.67050e-07 0.000 2.69000e-07 0.000 2.69050e-07 1.800 2.70000e-07 1.800 2.70050e-07 0.000 2.71000e-07 0.000
+ 2.71050e-07 1.800 2.72000e-07 1.800 2.72050e-07 0.000 2.73000e-07 0.000 2.73050e-07 1.800 2.74000e-07 1.800
+ 2.74050e-07 0.000 2.76000e-07 0.000 2.76050e-07 1.800 2.79000e-07 1.800 2.79050e-07 0.000 2.80000e-07 0.000
+ 2.80050e-07 1.800 2.81000e-07 1.800 2.81050e-07 0.000 2.82000e-07 0.000 2.82050e-07 1.800 2.83000e-07 1.800
+ 2.83050e-07 0.000 2.84000e-07 0.000 2.84050e-07 1.800 2.86000e-07 1.800 2.86050e-07 0.000 2.87000e-07 0.000
+ 2.87050e-07 1.800 2.90000e-07 1.800 2.90050e-07 0.000 2.91000e-07 0.000 2.91050e-07 1.800 2.92000e-07 1.800
+ 2.92050e-07 0.000 2.93000e-07 0.000 2.93050e-07 1.800 2.94000e-07 1.800 2.94050e-07 0.000 2.98000e-07 0.000
+ 2.98050e-07 1.800 2.99000e-07 1.800 2.99050e-07 0.000 3.00000e-07 0.000 3.00050e-07 1.800 3.01000e-07 1.800
+ 3.01050e-07 0.000 3.07000e-07 0.000 3.07050e-07 1.800 3.08000e-07 1.800 3.08050e-07 0.000 3.10000e-07 0.000
+ 3.10050e-07 1.800 3.11000e-07 1.800 3.11050e-07 0.000 3.13000e-07 0.000 3.13050e-07 1.800 3.16000e-07 1.800
+ 3.16050e-07 0.000 3.20000e-07 0.000 3.20050e-07 1.800 3.23000e-07 1.800 3.23050e-07 0.000 3.24000e-07 0.000
+ 3.24050e-07 1.800 3.25000e-07 1.800 3.25050e-07 0.000 3.28000e-07 0.000 3.28050e-07 1.800 3.29000e-07 1.800
+ 3.29050e-07 0.000 3.31000e-07 0.000 3.31050e-07 1.800 3.32000e-07 1.800 3.32050e-07 0.000 3.36000e-07 0.000
+ 3.36050e-07 1.800 3.40000e-07 1.800 3.40050e-07 0.000 3.42000e-07 0.000 3.42050e-07 1.800 3.43000e-07 1.800
+ 3.43050e-07 0.000 3.44000e-07 0.000 3.44050e-07 1.800 3.46000e-07 1.800 3.46050e-07 0.000 3.47000e-07 0.000
+ 3.47050e-07 1.800 3.50000e-07 1.800 3.50050e-07 0.000 3.53000e-07 0.000 3.53050e-07 1.800 3.57000e-07 1.800
+ 3.57050e-07 0.000 3.58000e-07 0.000 3.58050e-07 1.800 3.59000e-07 1.800 3.59050e-07 0.000 3.60000e-07 0.000
+ 3.60050e-07 1.800 3.61000e-07 1.800 3.61050e-07 0.000 3.62000e-07 0.000 3.62050e-07 1.800 3.64000e-07 1.800
+ 3.64050e-07 0.000 3.67000e-07 0.000 3.67050e-07 1.800 3.68000e-07 1.800 3.68050e-07 0.000 3.69000e-07 0.000
+ 3.69050e-07 1.800 3.71000e-07 1.800 3.71050e-07 0.000 3.72000e-07 0.000 3.72050e-07 1.800 3.73000e-07 1.800
+ 3.73050e-07 0.000 3.74000e-07 0.000 3.74050e-07 1.800 3.77000e-07 1.800 3.77050e-07 0.000 3.78000e-07 0.000
+ 3.78050e-07 1.800 3.81000e-07 1.800 3.81050e-07 0.000 3.83000e-07 0.000 3.83050e-07 1.800 3.84000e-07 1.800
+ 3.84050e-07 0.000 3.85000e-07 0.000 3.85050e-07 1.800 3.86000e-07 1.800 3.86050e-07 0.000 3.87000e-07 0.000
+ 3.87050e-07 1.800 3.88000e-07 1.800 3.88050e-07 0.000 3.89000e-07 0.000 3.89050e-07 1.800 3.93000e-07 1.800
+ 3.93050e-07 0.000 4.01000e-07 0.000 4.01050e-07 1.800 4.02000e-07 1.800 4.02050e-07 0.000 4.03000e-07 0.000
+ 4.03050e-07 1.800 4.05000e-07 1.800 4.05050e-07 0.000 4.06000e-07 0.000 4.06050e-07 1.800 4.08000e-07 1.800
+ 4.08050e-07 0.000 4.09000e-07 0.000 4.09050e-07 1.800 4.11000e-07 1.800 4.11050e-07 0.000 4.14000e-07 0.000
+ 4.14050e-07 1.800 4.17000e-07 1.800 4.17050e-07 0.000 4.18000e-07 0.000 4.18050e-07 1.800 4.19000e-07 1.800
+ 4.19050e-07 0.000 4.20000e-07 0.000 4.20050e-07 1.800 4.22000e-07 1.800 4.22050e-07 0.000 4.23000e-07 0.000
+ 4.23050e-07 1.800 4.28000e-07 1.800 4.28050e-07 0.000 4.30000e-07 0.000 4.30050e-07 1.800 4.32000e-07 1.800
+ 4.32050e-07 0.000 4.33000e-07 0.000 4.33050e-07 1.800 4.34000e-07 1.800 4.34050e-07 0.000 4.36000e-07 0.000
+ 4.36050e-07 1.800 4.39000e-07 1.800 4.39050e-07 0.000 4.40000e-07 0.000 4.40050e-07 1.800 4.41000e-07 1.800
+ 4.41050e-07 0.000 4.46000e-07 0.000 4.46050e-07 1.800 4.51000e-07 1.800 4.51050e-07 0.000 4.52000e-07 0.000
+ 4.52050e-07 1.800 4.54000e-07 1.800 4.54050e-07 0.000 4.56000e-07 0.000 4.56050e-07 1.800 4.57000e-07 1.800
+ 4.57050e-07 0.000 4.60000e-07 0.000 4.60050e-07 1.800 4.61000e-07 1.800 4.61050e-07 0.000 4.62000e-07 0.000
+ 4.62050e-07 1.800 4.63000e-07 1.800 4.63050e-07 0.000 4.66000e-07 0.000 4.66050e-07 1.800 4.67000e-07 1.800
+ 4.67050e-07 0.000 4.69000e-07 0.000 4.69050e-07 1.800 4.72000e-07 1.800 4.72050e-07 0.000 4.73000e-07 0.000
+ 4.73050e-07 1.800 4.74000e-07 1.800 4.74050e-07 0.000 4.77000e-07 0.000 4.77050e-07 1.800 4.78000e-07 1.800
+ 4.78050e-07 0.000 4.79000e-07 0.000 4.79050e-07 1.800 4.82000e-07 1.800 4.82050e-07 0.000 4.83000e-07 0.000
+ 4.83050e-07 1.800 4.87000e-07 1.800 4.87050e-07 0.000 4.89000e-07 0.000 4.89050e-07 1.800 4.90000e-07 1.800
+ 4.90050e-07 0.000 4.92000e-07 0.000 4.92050e-07 1.800 4.93000e-07 1.800 4.93050e-07 0.000 4.94000e-07 0.000
+ 4.94050e-07 1.800 4.96000e-07 1.800 4.96050e-07 0.000 4.99000e-07 0.000 4.99050e-07 1.800 5.01000e-07 1.800
+ 5.01050e-07 0.000 5.02000e-07 0.000 5.02050e-07 1.800 5.05000e-07 1.800 5.05050e-07 0.000 5.06000e-07 0.000
+ 5.06050e-07 1.800 5.07000e-07 1.800 5.07050e-07 0.000 5.09000e-07 0.000 5.09050e-07 1.800 5.10000e-07 1.800
+ 5.10050e-07 0.000 5.11000e-07 0.000 5.11050e-07 1.800 5.12000e-07 1.800
+ )
Xd_c3 src_c3 c3 vdd gnd tb_inv
Xl_s0 s0 lo_s0 vdd gnd tb_inv
Xl_s1 s1 lo_s1 vdd gnd tb_inv
Xl_s2 s2 lo_s2 vdd gnd tb_inv
Xl_s3 s3 lo_s3 vdd gnd tb_inv
X0 p0 p1 p2 p3 c0 c1 c2 c3 s0 s1 s2 s3 vdd gnd sum_xor_nand4_x1
.tran 200p 5.12000e-07
.control
set wr_singlescale
set wr_vecnames
run
set curplottitle=Bhargav-2025102061-1.3-sum_xor_nand4_x1-function
wrdata wave.txt v(p0) v(p1) v(p2) v(p3) v(c0) v(c1) v(c2) v(c3) v(s0) v(s1) v(s2) v(s3) i(VDD)
quit
.endc
.end
